* NGSPICE file created from clk_1MHz_mim.ext - technology: ihp-sg13g2

.subckt clk_1MHz_mim VDD VSS clk I1U
X0 ring_mrr_inv$1$1_0/ring_inv$1$1_2.Y.t0 clk_n.t2 a_6389_3773.t2 VSS.t36 sg13_lv_nmos ad=0.238p pd=2.08u as=0.238p ps=2.08u w=0.7u l=0.13u
X1 VDD.t9 ring_mrr_inv$1$1_0/ring_inv$1$1_1.A.t6 a_2194_3123.t9 VSS.t22 sg13_lv_nmos ad=55.85f pd=0.74u as=55.85f ps=0.74u w=0.155u l=0.5u
X2 ring_mrr_inv$1$1_0/ring_mirror_p$1$1_0.DRM.t2 I1U.t0 VDD.t21 VDD.t7 sg13_lv_pmos ad=95f pd=0.88u as=95f ps=0.88u w=0.5u l=3u
X3 VDD.t10 ring_mrr_inv$1$1_0/ring_inv$1$1_1.A.t6 a_2194_3123.t7 VSS.t23 sg13_lv_nmos ad=55.85f pd=0.74u as=55.85f ps=0.74u w=0.155u l=0.5u
X4 a_2394_4975.t4 ring_mrr_inv$1$1_0/ring_inv$1$1_2.Y.t2 ring_mrr_inv$1$1_0/ring_inv$1$1_1.A.t0 VDD.t6 sg13_lv_pmos ad=0.2375p pd=1.63u as=0.2375p ps=1.63u w=1.25u l=0.13u
X5 a_6389_3773.t1 ring_mrr_inv$1$1_0/ring_mirror_p$1$1_0.DRR.t0 VSS.t12 VSS.t13 sg13_lv_nmos ad=0.1425p pd=1.13u as=0.1425p ps=1.13u w=0.75u l=0.5u
X6 VDD.t21 I1U.t0 ring_mrr_inv$1$1_0/ring_mirror_p$1$1_0.DRM.t3 VDD.t7 sg13_lv_pmos ad=95f pd=0.88u as=0.17p ps=1.68u w=0.5u l=3u
X7 VDD.t28 VDD.t26 VDD.t27 VDD.t7 sg13_lv_pmos ad=0.5712p pd=4.04u as=0 ps=0 w=1.68u l=1u
X8 a_2394_4975.t5 ring_mrr_inv$1$1_0/ring_inv$1$1_2.Y.t2 ring_mrr_inv$1$1_0/ring_inv$1$1_1.A.t3 VDD.t6 sg13_lv_pmos ad=0.2375p pd=1.63u as=0.2375p ps=1.63u w=1.25u l=0.13u
X9 a_2194_3123.t11 ring_mrr_inv$1$1_0/ring_inv$1$1_2.Y.t2 ring_mrr_inv$1$1_0/ring_inv$1$1_1.A.t4 VSS.t7 sg13_lv_nmos ad=0.38p pd=2.38u as=0.38p ps=2.38u w=2u l=0.13u
X10 VDD.t13 ring_mrr_inv$1$1_0/ring_inv$1$1_1.A.t6 a_2194_3123.t4 VSS.t28 sg13_lv_nmos ad=0.10085p pd=1.34u as=55.85f ps=0.74u w=0.155u l=0.5u
X11 VSS.t12 ring_mrr_inv$1$1_0/ring_mirror_p$1$1_0.DRR.t0 ring_mrr_inv$1$1_0/ring_mirror_p$1$1_0.DRR.t1 VSS.t11 sg13_lv_nmos ad=0.1425p pd=1.13u as=0.1425p ps=1.13u w=0.75u l=0.5u
X12 a_2194_3123.t1 ring_mrr_inv$1$1_0/ring_inv$1$1_2.Y.t3 VSS.t6 VSS.t5 sg13_lv_nmos ad=55.85f pd=0.74u as=0.10085p ps=1.34u w=0.155u l=0.5u
X13 a_2194_3123.t3 ring_mrr_inv$1$1_0/ring_inv$1$1_1.A.t6 VDD.t2 VSS.t26 sg13_lv_nmos ad=55.85f pd=0.74u as=55.85f ps=0.74u w=0.155u l=0.5u
X14 VSS.t9 ring_mrr_inv$1$1_0/ring_mirror_p$1$1_0.DRR.t0 a_6389_3773.t1 VSS.t10 sg13_lv_nmos ad=0.1425p pd=1.13u as=0.1425p ps=1.13u w=0.75u l=0.5u
X15 a_2194_3123.t2 ring_mrr_inv$1$1_0/ring_inv$1$1_1.A.t6 VDD.t3 VSS.t27 sg13_lv_nmos ad=55.85f pd=0.74u as=55.85f ps=0.74u w=0.155u l=0.5u
X16 a_2394_4975.t1 ring_mrr_inv$1$1_0/ring_inv$1$1_1.A.t7 VSS.t30 VDD.t6 sg13_lv_pmos ad=95f pd=0.88u as=95f ps=0.88u w=0.5u l=1u
X17 VSS.t31 ring_mrr_inv$1$1_0/ring_inv$1$1_1.A.t7 a_2394_4975.t2 VDD.t6 sg13_lv_pmos ad=0.17p pd=1.68u as=95f ps=0.88u w=0.5u l=1u
X18 a_2194_3123.t12 ring_mrr_inv$1$1_0/ring_inv$1$1_2.Y.t2 ring_mrr_inv$1$1_0/ring_inv$1$1_1.A.t2 VSS.t4 sg13_lv_nmos ad=0.38p pd=2.38u as=0.38p ps=2.38u w=2u l=0.13u
X19 VDD.t18 I1U.t0 ring_mrr_inv$1$1_0/ring_mirror_p$1$1_0.DRM.t2 VDD.t7 sg13_lv_pmos ad=95f pd=0.88u as=95f ps=0.88u w=0.5u l=3u
X20 a_2194_3123.t8 ring_mrr_inv$1$1_0/ring_inv$1$1_1.A.t6 VDD.t12 VSS.t5 sg13_lv_nmos ad=55.85f pd=0.74u as=0.10085p ps=1.34u w=0.155u l=0.5u
X21 VDD.t11 ring_mrr_inv$1$1_0/ring_inv$1$1_1.A.t6 a_2194_3123.t5 VSS.t28 sg13_lv_nmos ad=0.10085p pd=1.34u as=55.85f ps=0.74u w=0.155u l=0.5u
X22 a_6389_3773.t0 ring_mrr_inv$1$1_0/ring_mirror_p$1$1_0.DRR.t0 VSS.t9 VSS.t8 sg13_lv_nmos ad=0.1425p pd=1.13u as=0.1425p ps=1.13u w=0.75u l=0.5u
X23 a_2194_3123.t9 ring_mrr_inv$1$1_0/ring_inv$1$1_1.A.t6 VDD.t10 VSS.t27 sg13_lv_nmos ad=55.85f pd=0.74u as=55.85f ps=0.74u w=0.155u l=0.5u
X24 a_2194_3123.t6 ring_mrr_inv$1$1_0/ring_inv$1$1_1.A.t6 VDD.t9 VSS.t26 sg13_lv_nmos ad=55.85f pd=0.74u as=55.85f ps=0.74u w=0.155u l=0.5u
X25 a_2394_4975.t2 ring_mrr_inv$1$1_0/ring_inv$1$1_1.A.t7 VSS.t29 VDD.t6 sg13_lv_pmos ad=95f pd=0.88u as=95f ps=0.88u w=0.5u l=1u
X26 clk.t0 clk_n.t3 VSS.t35 VSS.t34 sg13_lv_nmos ad=0.238p pd=2.08u as=0.238p ps=2.08u w=0.7u l=0.13u
X27 ring_mrr_inv$1$1_0/ring_inv$1$1_1.A.t5 ring_mrr_inv$1$1_0/ring_inv$1$1_2.Y.t2 a_2394_4975.t5 VDD.t6 sg13_lv_pmos ad=0.425p pd=3.18u as=0.2375p ps=1.63u w=1.25u l=0.13u
X28 clk_n.t1 ring_mrr_inv$1$1_0/ring_inv$1$1_1.A.t8 VDD.t8 VDD.t7 sg13_lv_pmos ad=0.3808p pd=2.92u as=0.3808p ps=2.92u w=1.12u l=0.13u
X29 VSS.t19 VSS.t17 a_6389_3773.t0 VSS.t18 sg13_lv_nmos ad=0.255p pd=2.18u as=0.1425p ps=1.13u w=0.75u l=0.5u
X30 ring_mrr_inv$1$1_0/ring_mirror_p$1$1_0.DRM.t1 I1U.t0 VDD.t17 VDD.t7 sg13_lv_pmos ad=95f pd=0.88u as=95f ps=0.88u w=0.5u l=3u
X31 a_2394_4975.t0 ring_mrr_inv$1$1_0/ring_inv$1$1_2.Y.t4 VDD.t14 VDD.t6 sg13_lv_pmos ad=95f pd=0.88u as=0.2p ps=1.8u w=0.5u l=0.5u
X32 VSS.t29 ring_mrr_inv$1$1_0/ring_inv$1$1_1.A.t7 a_2394_4975.t1 VDD.t6 sg13_lv_pmos ad=95f pd=0.88u as=95f ps=0.88u w=0.5u l=1u
X33 ring_mrr_inv$1$1_0/ring_inv$1$1_1.A.t1 ring_mrr_inv$1$1_0/ring_inv$1$1_2.Y.t2 a_2194_3123.t12 VSS.t3 sg13_lv_nmos ad=0.68p pd=4.68u as=0.38p ps=2.38u w=2u l=0.13u
X34 VDD.t5 ring_mrr_inv$1$1_0/ring_inv$1$1_1.A.t6 a_2194_3123.t1 VSS.t25 sg13_lv_nmos ad=55.85f pd=0.74u as=55.85f ps=0.74u w=0.155u l=0.5u
X35 ring_mrr_inv$1$1_0/ring_mirror_p$1$1_0.DRR.t3 I1U.t0 VDD.t18 VDD.t7 sg13_lv_pmos ad=0.17p pd=1.68u as=95f ps=0.88u w=0.5u l=3u
X36 ring_mrr_inv$1$1_0/ring_inv$1$1_2.Y.t1 clk_n.t2 ring_mrr_inv$1$1_0/ring_mirror_p$1$1_0.DRM.t4 VDD.t7 sg13_lv_pmos ad=0.3808p pd=2.92u as=0.3808p ps=2.92u w=1.12u l=0.13u
X37 VDD.t4 ring_mrr_inv$1$1_0/ring_inv$1$1_1.A.t6 a_2194_3123.t3 VSS.t24 sg13_lv_nmos ad=55.85f pd=0.74u as=55.85f ps=0.74u w=0.155u l=0.5u
X38 VDD.t17 I1U.t0 ring_mrr_inv$1$1_0/ring_mirror_p$1$1_0.DRR.t2 VDD.t7 sg13_lv_pmos ad=95f pd=0.88u as=0.17p ps=1.68u w=0.5u l=3u
X39 ring_mrr_inv$1$1_0/ring_inv$1$1_1.A.t3 ring_mrr_inv$1$1_0/ring_inv$1$1_2.Y.t2 a_2394_4975.t4 VDD.t6 sg13_lv_pmos ad=0.2375p pd=1.63u as=0.2375p ps=1.63u w=1.25u l=0.13u
X40 VSS.t30 ring_mrr_inv$1$1_0/ring_inv$1$1_1.A.t7 a_2394_4975.t0 VDD.t6 sg13_lv_pmos ad=95f pd=0.88u as=95f ps=0.88u w=0.5u l=1u
X41 VDD.t1 ring_mrr_inv$1$1_0/ring_inv$1$1_1.A.t6 a_2194_3123.t8 VSS.t25 sg13_lv_nmos ad=55.85f pd=0.74u as=55.85f ps=0.74u w=0.155u l=0.5u
X42 ring_mrr_inv$1$1_0/ring_inv$1$1_2.Y.t5 VSS.t2 cap_cmim l=43u w=42u
X43 ring_mrr_inv$1$1_0/ring_inv$1$1_1.A.t2 ring_mrr_inv$1$1_0/ring_inv$1$1_2.Y.t2 a_2194_3123.t11 VSS.t1 sg13_lv_nmos ad=0.38p pd=2.38u as=0.38p ps=2.38u w=2u l=0.13u
X44 VDD.t0 ring_mrr_inv$1$1_0/ring_inv$1$1_1.A.t6 a_2194_3123.t6 VSS.t24 sg13_lv_nmos ad=55.85f pd=0.74u as=55.85f ps=0.74u w=0.155u l=0.5u
X45 VDD.t25 VDD.t23 VDD.t24 VDD.t7 sg13_lv_pmos ad=0.5712p pd=4.04u as=0 ps=0 w=1.68u l=1u
X46 ring_mrr_inv$1$1_0/ring_mirror_p$1$1_0.DRR.t1 VSS.t14 VSS.t16 VSS.t15 sg13_lv_nmos ad=0.1425p pd=1.13u as=0.255p ps=2.18u w=0.75u l=0.5u
X47 VDD.t15 I1U.t0 ring_mrr_inv$1$1_0/ring_mirror_p$1$1_0.DRM.t1 VDD.t7 sg13_lv_pmos ad=95f pd=0.88u as=95f ps=0.88u w=0.5u l=3u
X48 ring_mrr_inv$1$1_0/ring_inv$1$1_1.A.t0 ring_mrr_inv$1$1_0/ring_inv$1$1_2.Y.t2 a_2394_4975.t3 VDD.t6 sg13_lv_pmos ad=0.2375p pd=1.63u as=0.425p ps=3.18u w=1.25u l=0.13u
X49 a_2194_3123.t0 ring_mrr_inv$1$1_0/ring_inv$1$1_1.A.t6 VDD.t5 VSS.t21 sg13_lv_nmos ad=55.85f pd=0.74u as=55.85f ps=0.74u w=0.155u l=0.5u
X50 a_2194_3123.t4 ring_mrr_inv$1$1_0/ring_inv$1$1_1.A.t6 VDD.t4 VSS.t20 sg13_lv_nmos ad=55.85f pd=0.74u as=55.85f ps=0.74u w=0.155u l=0.5u
X51 VDD.t3 ring_mrr_inv$1$1_0/ring_inv$1$1_1.A.t6 a_2194_3123.t0 VSS.t23 sg13_lv_nmos ad=55.85f pd=0.74u as=55.85f ps=0.74u w=0.155u l=0.5u
X52 VDD.t2 ring_mrr_inv$1$1_0/ring_inv$1$1_1.A.t6 a_2194_3123.t2 VSS.t22 sg13_lv_nmos ad=55.85f pd=0.74u as=55.85f ps=0.74u w=0.155u l=0.5u
X53 clk.t1 clk_n.t3 VDD.t29 VDD.t7 sg13_lv_pmos ad=0.3808p pd=2.92u as=0.3808p ps=2.92u w=1.12u l=0.13u
X54 ring_mrr_inv$1$1_0/ring_inv$1$1_1.A.t4 ring_mrr_inv$1$1_0/ring_inv$1$1_2.Y.t2 a_2194_3123.t10 VSS.t0 sg13_lv_nmos ad=0.38p pd=2.38u as=0.68p ps=4.68u w=2u l=0.13u
X55 clk_n.t0 ring_mrr_inv$1$1_0/ring_inv$1$1_1.A.t8 VSS.t33 VSS.t32 sg13_lv_nmos ad=0.238p pd=2.08u as=0.238p ps=2.08u w=0.7u l=0.13u
X56 ring_mrr_inv$1$1_0/ring_mirror_p$1$1_0.DRM.t0 I1U.t0 VDD.t15 VDD.t7 sg13_lv_pmos ad=0.17p pd=1.68u as=95f ps=0.88u w=0.5u l=3u
X57 a_2194_3123.t7 ring_mrr_inv$1$1_0/ring_inv$1$1_1.A.t6 VDD.t1 VSS.t21 sg13_lv_nmos ad=55.85f pd=0.74u as=55.85f ps=0.74u w=0.155u l=0.5u
X58 a_2194_3123.t5 ring_mrr_inv$1$1_0/ring_inv$1$1_1.A.t6 VDD.t0 VSS.t20 sg13_lv_nmos ad=55.85f pd=0.74u as=55.85f ps=0.74u w=0.155u l=0.5u
C0 ring_mrr_inv$1$1_0/ring_inv$1$1_2.Y ring_mrr_inv$1$1_0/ring_mirror_p$1$1_0.DRM 0.11692f
C1 ring_mrr_inv$1$1_0/ring_mirror_p$1$1_0.DRM clk_n 0.03433f
C2 ring_mrr_inv$1$1_0/ring_inv$1$1_1.A ring_mrr_inv$1$1_0/ring_mirror_p$1$1_0.DRR 0.02567f
C3 ring_mrr_inv$1$1_0/ring_inv$1$1_2.Y ring_mrr_inv$1$1_0/ring_mirror_p$1$1_0.DRR 0.23351f
C4 VDD ring_mrr_inv$1$1_0/ring_mirror_p$1$1_0.DRM 3.43456f
C5 ring_mrr_inv$1$1_0/ring_mirror_p$1$1_0.DRR clk_n 0.05f
C6 VDD ring_mrr_inv$1$1_0/ring_mirror_p$1$1_0.DRR 1.03131f
C7 I1U ring_mrr_inv$1$1_0/ring_mirror_p$1$1_0.DRM 0.73087f
C8 clk clk_n 0.09777f
C9 I1U ring_mrr_inv$1$1_0/ring_mirror_p$1$1_0.DRR 0.42265f
C10 VDD clk 0.26767f
C11 ring_mrr_inv$1$1_0/ring_inv$1$1_2.Y ring_mrr_inv$1$1_0/ring_inv$1$1_1.A 0.55439f
C12 ring_mrr_inv$1$1_0/ring_inv$1$1_1.A clk_n 0.09866f
C13 ring_mrr_inv$1$1_0/ring_inv$1$1_2.Y clk_n 0.65606f
C14 VDD ring_mrr_inv$1$1_0/ring_inv$1$1_1.A 2.77748f
C15 ring_mrr_inv$1$1_0/ring_mirror_p$1$1_0.DRM ring_mrr_inv$1$1_0/ring_mirror_p$1$1_0.DRR 0.17498f
C16 VDD ring_mrr_inv$1$1_0/ring_inv$1$1_2.Y 0.98461f
C17 VDD clk_n 0.62826f
C18 I1U ring_mrr_inv$1$1_0/ring_inv$1$1_1.A 0.07488f
C19 I1U ring_mrr_inv$1$1_0/ring_inv$1$1_2.Y 0.08899f
C20 I1U clk_n 0.01432f
C21 VDD I1U 5.14014f
R0 clk_n.n1 clk_n 9.74017
R1 clk_n clk_n.n0 9.42114
R2 clk_n clk_n.t0 8.99151
R3 clk_n.n3 clk_n.t1 6.14594
R4 clk_n.n0 clk_n.t3 3.76911
R5 clk_n.n1 clk_n.t2 3.73258
R6 clk_n.n3 clk_n.n2 1.84356
R7 clk_n clk_n.n3 0.268625
R8 clk_n.n2 clk_n.n1 0.0443394
R9 clk_n.n0 clk_n 0.0291
R10 clk_n.n2 clk_n 0.0236
R11 a_6389_3773.n0 a_6389_3773.t2 28.4162
R12 a_6389_3773.t1 a_6389_3773.n0 10.3813
R13 a_6389_3773.n0 a_6389_3773.t0 8.43168
R14 ring_mrr_inv$1$1_0/ring_inv$1$1_2.Y.n3 ring_mrr_inv$1$1_0/ring_inv$1$1_2.Y.n2 39.2857
R15 ring_mrr_inv$1$1_0/ring_inv$1$1_2.Y.n0 ring_mrr_inv$1$1_0/ring_inv$1$1_2.Y.t4 25.518
R16 ring_mrr_inv$1$1_0/ring_inv$1$1_2.Y.n1 ring_mrr_inv$1$1_0/ring_inv$1$1_2.Y.t3 25.2097
R17 ring_mrr_inv$1$1_0/ring_inv$1$1_2.Y.n3 ring_mrr_inv$1$1_0/ring_inv$1$1_2.Y.t0 8.75465
R18 ring_mrr_inv$1$1_0/ring_inv$1$1_2.Y.n0 ring_mrr_inv$1$1_0/ring_inv$1$1_2.Y.t2 6.61988
R19 ring_mrr_inv$1$1_0/ring_inv$1$1_2.Y ring_mrr_inv$1$1_0/ring_inv$1$1_2.Y.t1 6.52363
R20 ring_mrr_inv$1$1_0/ring_inv$1$1_2.Y.n2 ring_mrr_inv$1$1_0/ring_inv$1$1_2.Y.t5 4.13561
R21 ring_mrr_inv$1$1_0/ring_inv$1$1_2.Y.n2 ring_mrr_inv$1$1_0/ring_inv$1$1_2.Y 0.67922
R22 ring_mrr_inv$1$1_0/ring_inv$1$1_2.Y ring_mrr_inv$1$1_0/ring_inv$1$1_2.Y.n1 0.4025
R23 ring_mrr_inv$1$1_0/ring_inv$1$1_2.Y.n1 ring_mrr_inv$1$1_0/ring_inv$1$1_2.Y.n0 0.3565
R24 ring_mrr_inv$1$1_0/ring_inv$1$1_2.Y ring_mrr_inv$1$1_0/ring_inv$1$1_2.Y.n3 0.18989
R25 VSS.n146 VSS.n145 146679
R26 VSS.n145 VSS.n4 15083.7
R27 VSS.n145 VSS.n144 5405.09
R28 VSS.n147 VSS.n146 786.145
R29 VSS.n146 VSS.n3 279.793
R30 VSS.n28 VSS.n3 60.6031
R31 VSS.n71 VSS.n4 59.6207
R32 VSS.n144 VSS.t5 48.5989
R33 VSS.t28 VSS.n28 47.8862
R34 VSS.n21 VSS.n20 47.3392
R35 VSS.n15 VSS.n14 47.3392
R36 VSS.n12 VSS.n6 47.3392
R37 VSS.t23 VSS.n11 45.9261
R38 VSS.n18 VSS.t0 43.0999
R39 VSS.n46 VSS.n45 40.797
R40 VSS.n114 VSS.n43 40.797
R41 VSS.n115 VSS.n42 40.797
R42 VSS.n33 VSS.n32 40.2737
R43 VSS.n25 VSS.n7 40.2737
R44 VSS.n27 VSS.n26 40.2737
R45 VSS.n19 VSS.n9 40.2737
R46 VSS.t32 VSS.n2 38.1554
R47 VSS.t8 VSS.n55 37.883
R48 VSS.n111 VSS.t11 37.883
R49 VSS.t25 VSS.n142 36.5814
R50 VSS.t20 VSS.n29 36.5814
R51 VSS.n30 VSS.t20 36.5805
R52 VSS.n143 VSS.t25 36.5805
R53 VSS.n71 VSS.t34 35.5799
R54 VSS.n31 VSS.t24 35.3279
R55 VSS.n22 VSS.t3 35.3279
R56 VSS.t21 VSS.n141 34.6213
R57 VSS.n68 VSS.n64 33.5119
R58 VSS.n69 VSS.n63 33.5119
R59 VSS.n84 VSS.n82 33.5119
R60 VSS.n103 VSS.n55 33.5119
R61 VSS.n93 VSS.n53 33.5119
R62 VSS.n102 VSS.n85 33.5119
R63 VSS.n84 VSS.t18 32.0549
R64 VSS.t15 VSS.n45 32.0549
R65 VSS.n24 VSS.t4 28.9689
R66 VSS.n16 VSS.t7 28.2624
R67 VSS.n95 VSS.n89 26.2268
R68 VSS.n100 VSS.n92 26.2268
R69 VSS.n111 VSS.n109 26.2268
R70 VSS.n95 VSS.t36 25.4983
R71 VSS.t5 VSS.n143 25.2766
R72 VSS.t24 VSS.n30 25.2766
R73 VSS.n29 VSS.t28 25.2757
R74 VSS.n142 VSS.t21 25.2757
R75 VSS.n109 VSS.n92 23.3128
R76 VSS.n59 VSS.n58 20.1636
R77 VSS.n52 VSS.n51 20.1636
R78 VSS.n138 VSS.n137 19.8135
R79 VSS.n136 VSS.t30 19.1936
R80 VSS.n137 VSS.t31 18.8244
R81 VSS.n131 VSS.t6 18.1766
R82 VSS.t18 VSS.n83 17.4847
R83 VSS.n50 VSS.t15 17.4847
R84 VSS.n136 VSS.t29 17.2961
R85 VSS.n6 VSS.n5 17.0005
R86 VSS.n14 VSS.n5 17.0005
R87 VSS.n13 VSS.n5 17.0005
R88 VSS.n17 VSS.n5 17.0005
R89 VSS.n16 VSS.n5 17.0005
R90 VSS.n20 VSS.n5 17.0005
R91 VSS.n19 VSS.n5 17.0005
R92 VSS.n23 VSS.n5 17.0005
R93 VSS.n22 VSS.n5 17.0005
R94 VSS.n26 VSS.n5 17.0005
R95 VSS.n25 VSS.n5 17.0005
R96 VSS.n32 VSS.n5 17.0005
R97 VSS.n31 VSS.n5 17.0005
R98 VSS.n34 VSS.n12 17.0005
R99 VSS.n34 VSS.n15 17.0005
R100 VSS.n34 VSS.n11 17.0005
R101 VSS.n34 VSS.n18 17.0005
R102 VSS.n34 VSS.n10 17.0005
R103 VSS.n34 VSS.n21 17.0005
R104 VSS.n34 VSS.n9 17.0005
R105 VSS.n34 VSS.n24 17.0005
R106 VSS.n34 VSS.n8 17.0005
R107 VSS.n34 VSS.n27 17.0005
R108 VSS.n34 VSS.n7 17.0005
R109 VSS.n115 VSS.n36 17.0005
R110 VSS.n43 VSS.n36 17.0005
R111 VSS.n45 VSS.n36 17.0005
R112 VSS.n110 VSS.n36 17.0005
R113 VSS.n111 VSS.n36 17.0005
R114 VSS.n92 VSS.n36 17.0005
R115 VSS.n89 VSS.n36 17.0005
R116 VSS.n88 VSS.n36 17.0005
R117 VSS.n85 VSS.n36 17.0005
R118 VSS.n53 VSS.n36 17.0005
R119 VSS.n55 VSS.n36 17.0005
R120 VSS.n83 VSS.n36 17.0005
R121 VSS.n84 VSS.n36 17.0005
R122 VSS.n63 VSS.n36 17.0005
R123 VSS.n121 VSS.n62 17.0005
R124 VSS.n121 VSS.n63 17.0005
R125 VSS.n121 VSS.n61 17.0005
R126 VSS.n79 VSS.n67 17.0005
R127 VSS.n79 VSS.n69 17.0005
R128 VSS.n79 VSS.n66 17.0005
R129 VSS.n79 VSS.n64 17.0005
R130 VSS.n121 VSS.n55 17.0005
R131 VSS.n121 VSS.n57 17.0005
R132 VSS.n121 VSS.n84 17.0005
R133 VSS.n121 VSS.n91 17.0005
R134 VSS.n121 VSS.n92 17.0005
R135 VSS.n121 VSS.n90 17.0005
R136 VSS.n121 VSS.n89 17.0005
R137 VSS.n121 VSS.n87 17.0005
R138 VSS.n121 VSS.n88 17.0005
R139 VSS.n121 VSS.n86 17.0005
R140 VSS.n121 VSS.n85 17.0005
R141 VSS.n121 VSS.n54 17.0005
R142 VSS.n121 VSS.n53 17.0005
R143 VSS.n106 VSS.n99 17.0005
R144 VSS.n106 VSS.n100 17.0005
R145 VSS.n106 VSS.n98 17.0005
R146 VSS.n106 VSS.n95 17.0005
R147 VSS.n106 VSS.n101 17.0005
R148 VSS.n106 VSS.n102 17.0005
R149 VSS.n106 VSS.n94 17.0005
R150 VSS.n106 VSS.n93 17.0005
R151 VSS.n121 VSS.n45 17.0005
R152 VSS.n121 VSS.n50 17.0005
R153 VSS.n121 VSS.n111 17.0005
R154 VSS.n121 VSS.n113 17.0005
R155 VSS.n121 VSS.n115 17.0005
R156 VSS.n121 VSS.n44 17.0005
R157 VSS.n121 VSS.n43 17.0005
R158 VSS.n118 VSS.n1 17.0005
R159 VSS.n117 VSS.n1 17.0005
R160 VSS.n42 VSS.n1 17.0005
R161 VSS.n112 VSS.n1 17.0005
R162 VSS.n114 VSS.n1 17.0005
R163 VSS.n126 VSS.n125 17.0005
R164 VSS.n125 VSS.n40 17.0005
R165 VSS.n123 VSS.t32 16.7562
R166 VSS.n70 VSS.n64 16.0277
R167 VSS.n69 VSS.n68 16.0277
R168 VSS.n82 VSS.n63 16.0277
R169 VSS.n103 VSS.n53 16.0277
R170 VSS.n102 VSS.n88 16.0277
R171 VSS.n37 VSS.t14 15.2858
R172 VSS.n72 VSS.t17 15.2171
R173 VSS.n100 VSS.t13 14.5707
R174 VSS.t1 VSS.n19 12.7184
R175 VSS.n147 VSS.n2 12.6585
R176 VSS.n57 VSS.t8 11.6566
R177 VSS.t11 VSS.n110 11.6566
R178 VSS.n58 VSS.n57 10.082
R179 VSS.n51 VSS.n50 10.082
R180 VSS.n83 VSS.n59 10.082
R181 VSS.n110 VSS.n52 10.082
R182 VSS.t22 VSS.n23 9.89216
R183 VSS.t7 VSS.t27 9.89216
R184 VSS.t34 VSS.n70 9.47112
R185 VSS.t36 VSS.n88 9.47112
R186 VSS.n96 VSS.t9 9.40902
R187 VSS.t27 VSS.n10 9.18561
R188 VSS.n96 VSS.t12 9.13058
R189 VSS.n65 VSS.t35 9.00182
R190 VSS.n0 VSS.t33 9.00182
R191 VSS.n72 VSS.t19 8.83496
R192 VSS.n37 VSS.t16 8.75933
R193 VSS.t10 VSS.n85 8.74261
R194 VSS.t13 VSS.n89 8.74261
R195 VSS.n46 VSS.n43 8.74261
R196 VSS.n115 VSS.n114 8.74261
R197 VSS.n123 VSS.n42 8.74261
R198 VSS.n68 VSS.n60 8.501
R199 VSS.n124 VSS.n123 8.501
R200 VSS.n134 VSS.n133 8.48864
R201 VSS.n121 VSS.n120 8.48407
R202 VSS.n135 VSS.n134 8.46995
R203 VSS.n116 VSS.n41 8.46995
R204 VSS.n127 VSS.n36 8.46995
R205 VSS.n33 VSS.n31 7.77252
R206 VSS.n32 VSS.n7 7.77252
R207 VSS.n26 VSS.n8 7.77252
R208 VSS.n24 VSS.n22 7.77252
R209 VSS.n23 VSS.n9 7.77252
R210 VSS.n93 VSS.t10 7.28559
R211 VSS.n27 VSS.t26 6.35943
R212 VSS.n148 VSS.n147 5.66978
R213 VSS.n123 VSS.n39 5.66778
R214 VSS.n123 VSS.n122 5.66767
R215 VSS.t3 VSS.n8 4.94633
R216 VSS.n21 VSS.t1 4.94633
R217 VSS.n105 VSS.n104 4.33235
R218 VSS.n48 VSS.n47 4.33235
R219 VSS.n81 VSS.n80 4.32914
R220 VSS.n108 VSS.n107 4.32914
R221 VSS.n78 VSS.n4 4.25205
R222 VSS.n82 VSS.n81 4.25182
R223 VSS.n109 VSS.n108 4.25182
R224 VSS.n47 VSS.n46 4.25112
R225 VSS.n105 VSS.n103 4.25112
R226 VSS.t0 VSS.n17 4.23978
R227 VSS.n73 VSS.t2 3.61297
R228 VSS VSS.n148 3.51637
R229 VSS.n51 VSS.n36 3.46048
R230 VSS.n58 VSS.n36 3.46048
R231 VSS.n79 VSS.n71 3.46048
R232 VSS.n121 VSS.n59 3.46048
R233 VSS.n121 VSS.n52 3.46048
R234 VSS.n130 VSS.n3 3.40096
R235 VSS.n121 VSS.n56 3.3562
R236 VSS.n121 VSS.n49 3.3562
R237 VSS.n78 VSS.n77 2.97386
R238 VSS.n76 VSS.n36 2.72233
R239 VSS.n138 VSS.n34 2.28134
R240 VSS.n129 VSS 2.162
R241 VSS.n141 VSS.n140 2.13698
R242 VSS.n34 VSS.n33 2.1255
R243 VSS.n70 VSS.n36 2.1255
R244 VSS.n36 VSS.n35 1.97377
R245 VSS.n139 VSS.n135 1.65053
R246 VSS.n140 VSS.n139 1.53172
R247 VSS.t26 VSS.n25 1.41359
R248 VSS.t4 VSS.t22 1.41359
R249 VSS.n13 VSS.t23 1.41359
R250 VSS.n74 VSS.n36 1.07554
R251 VSS.n132 VSS 1.07323
R252 VSS.n133 VSS.n132 1.05155
R253 VSS VSS.n128 0.897
R254 VSS VSS.n131 0.884415
R255 VSS.n74 VSS.n73 0.770357
R256 VSS.n143 VSS.n5 0.7637
R257 VSS.n142 VSS.n5 0.7637
R258 VSS.n30 VSS.n5 0.7637
R259 VSS.n29 VSS.n5 0.7637
R260 VSS.n28 VSS.n5 0.7637
R261 VSS.n2 VSS.n1 0.73551
R262 VSS.n75 VSS.n74 0.730246
R263 VSS.n131 VSS.n5 0.724964
R264 VSS.n20 VSS.n10 0.707047
R265 VSS.n18 VSS.n16 0.707047
R266 VSS.n17 VSS.n11 0.707047
R267 VSS.n15 VSS.n13 0.707047
R268 VSS.n14 VSS.n12 0.707047
R269 VSS.n141 VSS.n6 0.707047
R270 VSS.n132 VSS.n5 0.54303
R271 VSS.n128 VSS.n35 0.47569
R272 VSS.n73 VSS.n35 0.473848
R273 VSS.n76 VSS.n75 0.331476
R274 VSS.n139 VSS.n138 0.329349
R275 VSS.n137 VSS.n136 0.318749
R276 VSS.n75 VSS.n72 0.279167
R277 VSS.n38 VSS.n37 0.273109
R278 VSS.n77 VSS.n76 0.265103
R279 VSS.n120 VSS.n116 0.222121
R280 VSS.n116 VSS.n40 0.198772
R281 VSS.n135 VSS.n129 0.195106
R282 VSS.n127 VSS.n126 0.187772
R283 VSS.n49 VSS.n48 0.161665
R284 VSS.n104 VSS.n56 0.153331
R285 VSS.n80 VSS.n56 0.152721
R286 VSS.n107 VSS.n49 0.144387
R287 VSS.n97 VSS.n96 0.113216
R288 VSS.n40 VSS.n38 0.112333
R289 VSS.n128 VSS.n127 0.0667723
R290 VSS.n119 VSS.n118 0.0484699
R291 VSS.n112 VSS.n44 0.0468158
R292 VSS.n117 VSS.n113 0.0468158
R293 VSS.n144 VSS.n5 0.0411474
R294 VSS.n98 VSS.n87 0.0401992
R295 VSS.n67 VSS.n62 0.0385451
R296 VSS.n94 VSS.n54 0.0385451
R297 VSS.n101 VSS.n86 0.0385451
R298 VSS.n120 VSS.n119 0.0348491
R299 VSS.n99 VSS.n91 0.0302744
R300 VSS.n99 VSS.n90 0.0269662
R301 VSS.n107 VSS.n91 0.0269662
R302 VSS.n97 VSS 0.0261391
R303 VSS.n133 VSS.n129 0.025714
R304 VSS.n77 VSS.n66 0.0186955
R305 VSS.n67 VSS.n61 0.0186955
R306 VSS.n80 VSS.n62 0.0186955
R307 VSS.n104 VSS.n54 0.0186955
R308 VSS.n94 VSS.n86 0.0186955
R309 VSS.n101 VSS.n87 0.0186955
R310 VSS.n66 VSS.n65 0.0137331
R311 VSS.n65 VSS 0.0137331
R312 VSS.n118 VSS.n0 0.0137331
R313 VSS VSS.n0 0.0137331
R314 VSS.n126 VSS.n38 0.0133333
R315 VSS VSS.n61 0.0120789
R316 VSS.n48 VSS.n44 0.0104248
R317 VSS.n113 VSS.n112 0.0104248
R318 VSS.n119 VSS.n117 0.0104248
R319 VSS.n140 VSS.n34 0.00480891
R320 VSS VSS.n90 0.00380827
R321 VSS.n81 VSS.n79 0.00193169
R322 VSS.n108 VSS.n106 0.00193169
R323 VSS.n148 VSS.n1 0.00188998
R324 VSS.n79 VSS.n78 0.001822
R325 VSS.n130 VSS.n5 0.0018
R326 VSS.n106 VSS.n105 0.00174993
R327 VSS.n47 VSS.n1 0.00174993
R328 VSS.n125 VSS.n39 0.00166667
R329 VSS.n39 VSS.n36 0.00133332
R330 VSS.n98 VSS.n97 0.00132707
R331 VSS.n134 VSS.n130 0.00119999
R332 VSS.n122 VSS.n41 0.001
R333 VSS.n124 VSS.n41 0.001
R334 VSS.n60 VSS.n36 0.001
R335 VSS.n121 VSS.n60 0.001
R336 VSS.n122 VSS.n121 0.001
R337 VSS.n125 VSS.n124 0.001
R338 ring_mrr_inv$1$1_0/ring_inv$1$1_1.A.n5 ring_mrr_inv$1$1_0/ring_inv$1$1_1.A.t6 25.59
R339 ring_mrr_inv$1$1_0/ring_inv$1$1_1.A.n5 ring_mrr_inv$1$1_0/ring_inv$1$1_1.A.t7 25.1081
R340 ring_mrr_inv$1$1_0/ring_inv$1$1_1.A.n6 ring_mrr_inv$1$1_0/ring_inv$1$1_1.A.n5 9.0005
R341 ring_mrr_inv$1$1_0/ring_inv$1$1_1.A.n2 ring_mrr_inv$1$1_0/ring_inv$1$1_1.A.t0 6.77352
R342 ring_mrr_inv$1$1_0/ring_inv$1$1_1.A.n3 ring_mrr_inv$1$1_0/ring_inv$1$1_1.A.t5 6.07327
R343 ring_mrr_inv$1$1_0/ring_inv$1$1_1.A.n2 ring_mrr_inv$1$1_0/ring_inv$1$1_1.A.t3 6.07327
R344 ring_mrr_inv$1$1_0/ring_inv$1$1_1.A.n0 ring_mrr_inv$1$1_0/ring_inv$1$1_1.A.t4 4.10783
R345 ring_mrr_inv$1$1_0/ring_inv$1$1_1.A ring_mrr_inv$1$1_0/ring_inv$1$1_1.A.t8 3.79952
R346 ring_mrr_inv$1$1_0/ring_inv$1$1_1.A.n0 ring_mrr_inv$1$1_0/ring_inv$1$1_1.A.t2 3.40658
R347 ring_mrr_inv$1$1_0/ring_inv$1$1_1.A.n1 ring_mrr_inv$1$1_0/ring_inv$1$1_1.A.t1 3.40592
R348 ring_mrr_inv$1$1_0/ring_inv$1$1_1.A.n6 ring_mrr_inv$1$1_0/ring_inv$1$1_1.A.n4 0.872826
R349 ring_mrr_inv$1$1_0/ring_inv$1$1_1.A.n1 ring_mrr_inv$1$1_0/ring_inv$1$1_1.A.n0 0.70175
R350 ring_mrr_inv$1$1_0/ring_inv$1$1_1.A.n3 ring_mrr_inv$1$1_0/ring_inv$1$1_1.A.n2 0.70175
R351 ring_mrr_inv$1$1_0/ring_inv$1$1_1.A.n4 ring_mrr_inv$1$1_0/ring_inv$1$1_1.A.n3 0.138
R352 ring_mrr_inv$1$1_0/ring_inv$1$1_1.A.n4 ring_mrr_inv$1$1_0/ring_inv$1$1_1.A.n1 0.120812
R353 ring_mrr_inv$1$1_0/ring_inv$1$1_1.A ring_mrr_inv$1$1_0/ring_inv$1$1_1.A.n6 0.120733
R354 a_2194_3123.n5 a_2194_3123.n4 18.7002
R355 a_2194_3123.n0 a_2194_3123.t4 17.2274
R356 a_2194_3123.n1 a_2194_3123.t3 17.2274
R357 a_2194_3123.n2 a_2194_3123.t2 17.2274
R358 a_2194_3123.n6 a_2194_3123.t0 17.2274
R359 a_2194_3123.t1 a_2194_3123.n7 17.2274
R360 a_2194_3123.n7 a_2194_3123.t8 17.2239
R361 a_2194_3123.n0 a_2194_3123.t5 17.2239
R362 a_2194_3123.n1 a_2194_3123.t6 17.2239
R363 a_2194_3123.n2 a_2194_3123.t9 17.2239
R364 a_2194_3123.n6 a_2194_3123.t7 17.2239
R365 a_2194_3123.n3 a_2194_3123.t12 4.10735
R366 a_2194_3123.n4 a_2194_3123.t10 3.64026
R367 a_2194_3123.n3 a_2194_3123.t11 3.4061
R368 a_2194_3123.n1 a_2194_3123.n0 1.293
R369 a_2194_3123.n2 a_2194_3123.n1 1.293
R370 a_2194_3123.n7 a_2194_3123.n6 1.293
R371 a_2194_3123.n5 a_2194_3123.n2 0.942702
R372 a_2194_3123.n4 a_2194_3123.n3 0.413313
R373 a_2194_3123.n6 a_2194_3123.n5 0.303327
R374 VDD.n89 VDD.n88 20.1019
R375 VDD.n79 VDD.t12 18.5233
R376 VDD.n85 VDD.t5 18.5199
R377 VDD.n95 VDD.t14 17.7293
R378 VDD.n34 VDD.t15 17.3339
R379 VDD.n33 VDD.t21 17.3339
R380 VDD.n82 VDD.t0 17.2308
R381 VDD.n81 VDD.t9 17.2308
R382 VDD.n80 VDD.t10 17.2308
R383 VDD.n79 VDD.t1 17.2308
R384 VDD.n85 VDD.t3 17.2274
R385 VDD.n86 VDD.t2 17.2274
R386 VDD.n87 VDD.t4 17.2274
R387 VDD.n32 VDD.t17 17.0005
R388 VDD.n35 VDD.t18 17.0005
R389 VDD.n45 VDD.n44 17.0005
R390 VDD.n44 VDD.n23 17.0005
R391 VDD.n44 VDD.n27 17.0005
R392 VDD.n44 VDD.n22 17.0005
R393 VDD.n44 VDD.n43 17.0005
R394 VDD.n46 VDD.n5 17.0005
R395 VDD.n21 VDD.n5 17.0005
R396 VDD.n25 VDD.n5 17.0005
R397 VDD.n42 VDD.n5 17.0005
R398 VDD.n61 VDD.n57 17.0005
R399 VDD.n61 VDD.n54 17.0005
R400 VDD.n61 VDD.n60 17.0005
R401 VDD.n61 VDD.n51 17.0005
R402 VDD.n56 VDD.n5 17.0005
R403 VDD.n55 VDD.n5 17.0005
R404 VDD.n53 VDD.n5 17.0005
R405 VDD.n59 VDD.n5 17.0005
R406 VDD.n58 VDD.n5 17.0005
R407 VDD.n50 VDD.n5 17.0005
R408 VDD.n65 VDD.n64 17.0005
R409 VDD.n64 VDD.n10 17.0005
R410 VDD.n64 VDD.n8 17.0005
R411 VDD.n64 VDD.n13 17.0005
R412 VDD.n64 VDD.n7 17.0005
R413 VDD.n65 VDD.n5 17.0005
R414 VDD.n12 VDD.n5 17.0005
R415 VDD.n11 VDD.n5 17.0005
R416 VDD.n14 VDD.n5 17.0005
R417 VDD.n83 VDD.t11 17.0005
R418 VDD.n84 VDD.t13 17.0005
R419 VDD.n24 VDD.n5 8.49381
R420 VDD.n30 VDD.n5 8.49381
R421 VDD.n61 VDD.n52 8.49065
R422 VDD.n73 VDD.n1 8.46995
R423 VDD.n77 VDD.n76 8.46995
R424 VDD.n90 VDD.n1 8.46995
R425 VDD.n26 VDD.t29 6.41406
R426 VDD.n9 VDD.t8 6.41406
R427 VDD.t6 VDD.n74 5.66778
R428 VDD.n75 VDD.t6 5.66767
R429 VDD.n48 VDD.n5 5.65199
R430 VDD.n19 VDD.n5 5.65139
R431 VDD.n28 VDD.t23 4.902
R432 VDD.n70 VDD.t26 4.902
R433 VDD.n28 VDD.t24 4.34604
R434 VDD.n29 VDD.t25 3.88159
R435 VDD.n69 VDD.t27 3.88159
R436 VDD.n93 VDD.n2 3.62449
R437 VDD.n34 VDD.n33 3.54145
R438 VDD.n71 VDD.t28 3.29663
R439 VDD.n91 VDD.n3 2.99025
R440 VDD.n62 VDD.n20 2.98952
R441 VDD.n47 VDD.n17 2.98932
R442 VDD.n49 VDD.n16 2.98803
R443 VDD.n63 VDD.n15 2.98803
R444 VDD.t7 VDD.n16 2.83541
R445 VDD.n63 VDD.t7 2.83541
R446 VDD.t6 VDD.n2 2.83459
R447 VDD.n66 VDD.n6 2.72207
R448 VDD.n41 VDD.n18 2.71856
R449 VDD.n78 VDD.n1 2.29895
R450 VDD.t7 VDD.n18 2.12693
R451 VDD.n96 VDD.n1 1.9709
R452 VDD.t7 VDD.n17 1.70109
R453 VDD.n83 VDD.n82 1.52331
R454 VDD.t7 VDD.n62 1.41756
R455 VDD.t7 VDD.n6 1.41739
R456 VDD.n87 VDD.n86 1.293
R457 VDD.n86 VDD.n85 1.293
R458 VDD.n82 VDD.n81 1.293
R459 VDD.n81 VDD.n80 1.293
R460 VDD.n80 VDD.n79 1.293
R461 VDD.n67 VDD.n5 1.20075
R462 VDD.n40 VDD.n5 1.20074
R463 VDD.n88 VDD.n84 1.15925
R464 VDD VDD.n4 1.12941
R465 VDD VDD.n0 1.1092
R466 VDD.n38 VDD.n37 1.07532
R467 VDD.n68 VDD.n4 1.06929
R468 VDD.n92 VDD.n1 1.06386
R469 VDD.n71 VDD.n70 1.01356
R470 VDD.n95 VDD.n94 1.0125
R471 VDD.n39 VDD.n38 1.0074
R472 VDD.n94 VDD.n93 0.987864
R473 VDD.n36 VDD 0.932702
R474 VDD.n72 VDD.n0 0.919539
R475 VDD.n37 VDD.n36 0.913186
R476 VDD.n92 VDD.n91 0.822735
R477 VDD.n93 VDD.n92 0.774826
R478 VDD.n67 VDD.n66 0.713895
R479 VDD.n41 VDD.n40 0.675013
R480 VDD.n68 VDD.n67 0.645389
R481 VDD.n40 VDD.n39 0.644087
R482 VDD.n36 VDD.n5 0.63971
R483 VDD.n1 VDD.n0 0.593319
R484 VDD.n32 VDD.n31 0.574563
R485 VDD.n84 VDD.n83 0.560813
R486 VDD.n94 VDD.n1 0.555511
R487 VDD.n38 VDD.n5 0.550303
R488 VDD.n37 VDD.n35 0.540188
R489 VDD.n78 VDD.n77 0.506521
R490 VDD.n5 VDD.n4 0.458918
R491 VDD.n96 VDD.n95 0.457259
R492 VDD.n70 VDD.n69 0.451625
R493 VDD.n29 VDD.n28 0.451279
R494 VDD VDD.n96 0.437714
R495 VDD.n69 VDD.n68 0.437167
R496 VDD.n89 VDD.n78 0.436825
R497 VDD.n39 VDD.n29 0.417167
R498 VDD VDD.n71 0.397764
R499 VDD.n33 VDD.n32 0.333938
R500 VDD.n35 VDD.n34 0.333938
R501 VDD.n88 VDD.n87 0.30675
R502 VDD.n77 VDD.n73 0.265045
R503 VDD.n91 VDD.n90 0.240939
R504 VDD.t6 VDD.n3 0.236971
R505 VDD.t7 VDD.n5 0.157907
R506 VDD.n73 VDD.n72 0.156606
R507 VDD.n90 VDD.n89 0.108939
R508 VDD.n48 VDD.n47 0.0668385
R509 VDD.n72 VDD 0.0608922
R510 VDD.n19 VDD.n15 0.0553696
R511 VDD.n20 VDD.n19 0.0494694
R512 VDD.n49 VDD.n48 0.0380121
R513 VDD.n53 VDD.n52 0.0327055
R514 VDD.n50 VDD.n49 0.0275769
R515 VDD.n58 VDD.n51 0.0275769
R516 VDD.n60 VDD.n59 0.0275769
R517 VDD.n23 VDD.n21 0.0258846
R518 VDD.n46 VDD.n45 0.0258846
R519 VDD.n24 VDD.n22 0.0246801
R520 VDD.n59 VDD.n52 0.0233978
R521 VDD.n42 VDD.n22 0.0199615
R522 VDD.n27 VDD.n24 0.0187571
R523 VDD.n57 VDD.n55 0.0182692
R524 VDD.n56 VDD.n20 0.0182692
R525 VDD.n26 VDD 0.0178462
R526 VDD.n9 VDD 0.0178462
R527 VDD.n14 VDD.n7 0.0165769
R528 VDD.n13 VDD.n11 0.0165769
R529 VDD.n12 VDD.n8 0.0165769
R530 VDD.n31 VDD.n30 0.0153725
R531 VDD.n30 VDD.n10 0.0153725
R532 VDD.n15 VDD.n14 0.0131923
R533 VDD.n11 VDD.n7 0.0131923
R534 VDD.n13 VDD.n12 0.0131923
R535 VDD.n31 VDD.n8 0.0131923
R536 VDD.n55 VDD.n54 0.0115
R537 VDD.n57 VDD.n56 0.0115
R538 VDD.n54 VDD 0.0110769
R539 VDD.n65 VDD 0.0110769
R540 VDD.n43 VDD.n42 0.00980769
R541 VDD.n43 VDD.n41 0.00938462
R542 VDD.n66 VDD.n65 0.00938462
R543 VDD VDD.n25 0.00769231
R544 VDD VDD.n53 0.00769231
R545 VDD.n25 VDD.n23 0.00388462
R546 VDD.n45 VDD.n21 0.00388462
R547 VDD.n47 VDD.n46 0.00388462
R548 VDD.n44 VDD.n18 0.00263103
R549 VDD.n61 VDD.n16 0.00248252
R550 VDD.n64 VDD.n63 0.00248252
R551 VDD.n2 VDD.n1 0.00229873
R552 VDD.n51 VDD.n50 0.00219231
R553 VDD.n60 VDD.n58 0.00219231
R554 VDD.n44 VDD.n17 0.00218892
R555 VDD.n62 VDD.n61 0.00199064
R556 VDD.n64 VDD.n6 0.00192672
R557 VDD.n76 VDD.n74 0.00166667
R558 VDD.n27 VDD.n26 0.00134615
R559 VDD.n10 VDD.n9 0.00134615
R560 VDD.n74 VDD.n1 0.00133332
R561 VDD.n3 VDD.n1 0.00116502
R562 VDD.n76 VDD.n75 0.001
R563 VDD.n75 VDD.n1 0.001
R564 I1U.n0 I1U.t0 25.0785
R565 I1U.n0 I1U 5.35559
R566 I1U I1U.n0 0.0239667
R567 ring_mrr_inv$1$1_0/ring_mirror_p$1$1_0.DRM.n1 ring_mrr_inv$1$1_0/ring_mirror_p$1$1_0.DRM.t0 22.2208
R568 ring_mrr_inv$1$1_0/ring_mirror_p$1$1_0.DRM.n0 ring_mrr_inv$1$1_0/ring_mirror_p$1$1_0.DRM.t3 22.1553
R569 ring_mrr_inv$1$1_0/ring_mirror_p$1$1_0.DRM.n0 ring_mrr_inv$1$1_0/ring_mirror_p$1$1_0.DRM.t2 17.029
R570 ring_mrr_inv$1$1_0/ring_mirror_p$1$1_0.DRM.n1 ring_mrr_inv$1$1_0/ring_mirror_p$1$1_0.DRM.t1 17.0005
R571 ring_mrr_inv$1$1_0/ring_mirror_p$1$1_0.DRM ring_mrr_inv$1$1_0/ring_mirror_p$1$1_0.DRM.t4 15.483
R572 ring_mrr_inv$1$1_0/ring_mirror_p$1$1_0.DRM.n2 ring_mrr_inv$1$1_0/ring_mirror_p$1$1_0.DRM.n0 9.36767
R573 ring_mrr_inv$1$1_0/ring_mirror_p$1$1_0.DRM.n2 ring_mrr_inv$1$1_0/ring_mirror_p$1$1_0.DRM.n1 9.01757
R574 ring_mrr_inv$1$1_0/ring_mirror_p$1$1_0.DRM.n3 ring_mrr_inv$1$1_0/ring_mirror_p$1$1_0.DRM.n2 0.547845
R575 ring_mrr_inv$1$1_0/ring_mirror_p$1$1_0.DRM ring_mrr_inv$1$1_0/ring_mirror_p$1$1_0.DRM.n3 0.0995
R576 ring_mrr_inv$1$1_0/ring_mirror_p$1$1_0.DRM.n3 ring_mrr_inv$1$1_0/ring_mirror_p$1$1_0.DRM 0.0506266
R577 a_2394_4975.n3 a_2394_4975.t2 19.1936
R578 a_2394_4975.n2 a_2394_4975.n1 18.7515
R579 a_2394_4975.n2 a_2394_4975.t0 18.2143
R580 a_2394_4975.t1 a_2394_4975.n3 17.2961
R581 a_2394_4975.n0 a_2394_4975.t5 6.77495
R582 a_2394_4975.n1 a_2394_4975.t3 6.07724
R583 a_2394_4975.n0 a_2394_4975.t4 6.0737
R584 a_2394_4975.n3 a_2394_4975.n2 0.9255
R585 a_2394_4975.n1 a_2394_4975.n0 0.653317
R586 ring_mrr_inv$1$1_0/ring_mirror_p$1$1_0.DRR.n0 ring_mrr_inv$1$1_0/ring_mirror_p$1$1_0.DRR.t3 48.067
R587 ring_mrr_inv$1$1_0/ring_mirror_p$1$1_0.DRR.n0 ring_mrr_inv$1$1_0/ring_mirror_p$1$1_0.DRR.t2 26.0005
R588 ring_mrr_inv$1$1_0/ring_mirror_p$1$1_0.DRR.n1 ring_mrr_inv$1$1_0/ring_mirror_p$1$1_0.DRR.t0 15.638
R589 ring_mrr_inv$1$1_0/ring_mirror_p$1$1_0.DRR ring_mrr_inv$1$1_0/ring_mirror_p$1$1_0.DRR.n1 13.6719
R590 ring_mrr_inv$1$1_0/ring_mirror_p$1$1_0.DRR.n1 ring_mrr_inv$1$1_0/ring_mirror_p$1$1_0.DRR.t1 8.42998
R591 ring_mrr_inv$1$1_0/ring_mirror_p$1$1_0.DRR ring_mrr_inv$1$1_0/ring_mirror_p$1$1_0.DRR.n0 0.627045
R592 clk.n0 clk.t0 8.99151
R593 clk.n0 clk.t1 6.225
R594 clk.n0 clk 0.477167
R595 clk clk.n0 0.0207299
C22 clk VSS 0.44315f
C23 I1U VSS 2.53046f
C24 VDD VSS 7.78335f
C25 clk_n VSS 1.34124f $ **FLOATING
C26 ring_mrr_inv$1$1_0/ring_mirror_p$1$1_0.DRR VSS 3.37905f $ **FLOATING
C27 ring_mrr_inv$1$1_0/ring_mirror_p$1$1_0.DRM VSS 0.54825f $ **FLOATING
C28 ring_mrr_inv$1$1_0/ring_inv$1$1_1.A VSS 5.66215f $ **FLOATING
C29 ring_mrr_inv$1$1_0/ring_inv$1$1_2.Y VSS 92.9011f $ **FLOATING
C30 ring_mrr_inv$1$1_0/ring_mirror_p$1$1_0.DRM.t4 VSS 0.34911f $ **FLOATING
C31 ring_mrr_inv$1$1_0/ring_mirror_p$1$1_0.DRM.t3 VSS 0.22015f $ **FLOATING
C32 ring_mrr_inv$1$1_0/ring_mirror_p$1$1_0.DRM.t2 VSS 0.12995f $ **FLOATING
C33 ring_mrr_inv$1$1_0/ring_mirror_p$1$1_0.DRM.n0 VSS 0.77841f $ **FLOATING
C34 ring_mrr_inv$1$1_0/ring_mirror_p$1$1_0.DRM.t0 VSS 0.2224f $ **FLOATING
C35 ring_mrr_inv$1$1_0/ring_mirror_p$1$1_0.DRM.t1 VSS 0.12997f $ **FLOATING
C36 ring_mrr_inv$1$1_0/ring_mirror_p$1$1_0.DRM.n1 VSS 0.7969f $ **FLOATING
C37 ring_mrr_inv$1$1_0/ring_mirror_p$1$1_0.DRM.n2 VSS 0.34963f $ **FLOATING
C38 ring_mrr_inv$1$1_0/ring_mirror_p$1$1_0.DRM.n3 VSS 0.13116f $ **FLOATING
C39 I1U.t0 VSS 3.97002f $ **FLOATING
C40 I1U.n0 VSS 0.66078f $ **FLOATING
C41 VDD.n0 VSS 0.03726f $ **FLOATING
C42 VDD.n1 VSS 0.39831f $ **FLOATING
C43 VDD.n2 VSS 0.01074f $ **FLOATING
C44 VDD.n3 VSS 0.01073f $ **FLOATING
C45 VDD.t28 VSS 0.02708f $ **FLOATING
C46 VDD.t26 VSS 0.08869f $ **FLOATING
C47 VDD.t27 VSS 0.02865f $ **FLOATING
C48 VDD.n4 VSS 0.04513f $ **FLOATING
C49 VDD.n5 VSS 0.53184f $ **FLOATING
C50 VDD.n7 VSS 0.01048f $ **FLOATING
C51 VDD.n8 VSS 0.01048f $ **FLOATING
C52 VDD.t8 VSS 0.01924f $ **FLOATING
C53 VDD.n9 VSS 0.01932f $ **FLOATING
C54 VDD.n10 VSS 0.01078f $ **FLOATING
C55 VDD.n11 VSS 0.01048f $ **FLOATING
C56 VDD.n12 VSS 0.01048f $ **FLOATING
C57 VDD.n13 VSS 0.01048f $ **FLOATING
C58 VDD.n14 VSS 0.01048f $ **FLOATING
C59 VDD.n15 VSS 0.04833f $ **FLOATING
C60 VDD.n19 VSS 0.01511f $ **FLOATING
C61 VDD.n20 VSS 0.04918f $ **FLOATING
C62 VDD.n21 VSS 0.01048f $ **FLOATING
C63 VDD.n22 VSS 0.019f $ **FLOATING
C64 VDD.n23 VSS 0.01048f $ **FLOATING
C65 VDD.t29 VSS 0.01924f $ **FLOATING
C66 VDD.n26 VSS 0.01932f $ **FLOATING
C67 VDD.n27 VSS 0.01108f $ **FLOATING
C68 VDD.t25 VSS 0.02865f $ **FLOATING
C69 VDD.t23 VSS 0.08869f $ **FLOATING
C70 VDD.t24 VSS 0.03037f $ **FLOATING
C71 VDD.n28 VSS 0.01887f $ **FLOATING
C72 VDD.n29 VSS 0.0178f $ **FLOATING
C73 VDD.n31 VSS 0.01826f $ **FLOATING
C74 VDD.n33 VSS 0.04178f $ **FLOATING
C75 VDD.n34 VSS 0.04178f $ **FLOATING
C76 VDD.n36 VSS 0.03108f $ **FLOATING
C77 VDD.n37 VSS 0.06047f $ **FLOATING
C78 VDD.n38 VSS 0.04043f $ **FLOATING
C79 VDD.n39 VSS 0.0516f $ **FLOATING
C80 VDD.n40 VSS 0.01941f $ **FLOATING
C81 VDD.n41 VSS 0.05447f $ **FLOATING
C82 VDD.n42 VSS 0.01048f $ **FLOATING
C83 VDD.n44 VSS 0.0812f $ **FLOATING
C84 VDD.n45 VSS 0.01048f $ **FLOATING
C85 VDD.n46 VSS 0.01048f $ **FLOATING
C86 VDD.n47 VSS 0.04668f $ **FLOATING
C87 VDD.n48 VSS 0.01488f $ **FLOATING
C88 VDD.n49 VSS 0.05105f $ **FLOATING
C89 VDD.n50 VSS 0.01048f $ **FLOATING
C90 VDD.n51 VSS 0.01048f $ **FLOATING
C91 VDD.n53 VSS 0.0192f $ **FLOATING
C92 VDD.n55 VSS 0.01048f $ **FLOATING
C93 VDD.n56 VSS 0.01048f $ **FLOATING
C94 VDD.n57 VSS 0.01048f $ **FLOATING
C95 VDD.n58 VSS 0.01048f $ **FLOATING
C96 VDD.n59 VSS 0.02503f $ **FLOATING
C97 VDD.n60 VSS 0.01048f $ **FLOATING
C98 VDD.n61 VSS 0.0812f $ **FLOATING
C99 VDD.t7 VSS 5.09105f $ **FLOATING
C100 VDD.n64 VSS 0.0812f $ **FLOATING
C101 VDD.n66 VSS 0.05498f $ **FLOATING
C102 VDD.n67 VSS 0.02046f $ **FLOATING
C103 VDD.n68 VSS 0.05415f $ **FLOATING
C104 VDD.n69 VSS 0.01791f $ **FLOATING
C105 VDD.n71 VSS 0.02483f $ **FLOATING
C106 VDD.n72 VSS 0.04051f $ **FLOATING
C107 VDD.t6 VSS 2.46185f $ **FLOATING
C108 VDD.n77 VSS 0.01803f $ **FLOATING
C109 VDD.n78 VSS 0.01538f $ **FLOATING
C110 VDD.n79 VSS 0.02828f $ **FLOATING
C111 VDD.n80 VSS 0.01779f $ **FLOATING
C112 VDD.n81 VSS 0.01779f $ **FLOATING
C113 VDD.n82 VSS 0.01915f $ **FLOATING
C114 VDD.n83 VSS 0.012f $ **FLOATING
C115 VDD.n85 VSS 0.02842f $ **FLOATING
C116 VDD.n86 VSS 0.01787f $ **FLOATING
C117 VDD.n87 VSS 0.01251f $ **FLOATING
C118 VDD.n88 VSS 0.05849f $ **FLOATING
C119 VDD.n89 VSS 0.0628f $ **FLOATING
C120 VDD.n91 VSS 0.05409f $ **FLOATING
C121 VDD.n92 VSS 0.02509f $ **FLOATING
C122 VDD.n93 VSS 0.07746f $ **FLOATING
C123 VDD.n94 VSS 0.0392f $ **FLOATING
C124 VDD.n95 VSS 0.05185f $ **FLOATING
C125 VDD.n96 VSS 0.01138f $ **FLOATING
C126 ring_mrr_inv$1$1_0/ring_inv$1$1_1.A.t8 VSS 0.09913f $ **FLOATING
C127 ring_mrr_inv$1$1_0/ring_inv$1$1_1.A.t1 VSS 0.0937f $ **FLOATING
C128 ring_mrr_inv$1$1_0/ring_inv$1$1_1.A.t2 VSS 0.10391f $ **FLOATING
C129 ring_mrr_inv$1$1_0/ring_inv$1$1_1.A.t4 VSS 0.11239f $ **FLOATING
C130 ring_mrr_inv$1$1_0/ring_inv$1$1_1.A.n0 VSS 0.09968f $ **FLOATING
C131 ring_mrr_inv$1$1_0/ring_inv$1$1_1.A.n1 VSS 0.05148f $ **FLOATING
C132 ring_mrr_inv$1$1_0/ring_inv$1$1_1.A.t5 VSS 0.05598f $ **FLOATING
C133 ring_mrr_inv$1$1_0/ring_inv$1$1_1.A.t3 VSS 0.06237f $ **FLOATING
C134 ring_mrr_inv$1$1_0/ring_inv$1$1_1.A.t0 VSS 0.06646f $ **FLOATING
C135 ring_mrr_inv$1$1_0/ring_inv$1$1_1.A.n2 VSS 0.08376f $ **FLOATING
C136 ring_mrr_inv$1$1_0/ring_inv$1$1_1.A.n3 VSS 0.04158f $ **FLOATING
C137 ring_mrr_inv$1$1_0/ring_inv$1$1_1.A.n4 VSS 0.10182f $ **FLOATING
C138 ring_mrr_inv$1$1_0/ring_inv$1$1_1.A.t7 VSS 0.54829f $ **FLOATING
C139 ring_mrr_inv$1$1_0/ring_inv$1$1_1.A.t6 VSS 0.55279f $ **FLOATING
C140 ring_mrr_inv$1$1_0/ring_inv$1$1_1.A.n5 VSS 0.3495f $ **FLOATING
C141 ring_mrr_inv$1$1_0/ring_inv$1$1_1.A.n6 VSS 0.10649f $ **FLOATING
.ends
