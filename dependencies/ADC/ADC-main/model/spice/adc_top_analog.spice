* NGSPICE file created from adc_top_analog.ext - technology: ihp-sg13g2

.subckt adc_top_analog VSS VDD VBIAS RAMP_EN RAMP_REF RAMP_RESET SEL_CAL VCAL SEL_MEAS
+ VMEAS CMP_OUTPUT VRAMP
X0 VDD.t14 VBIAS.t8 ota_lv_gmid_comparator_0.ota_slow_gmid_common_0/ota_slow_gmid_pairs_0.tail.t0 VDD.t1 sg13_lv_pmos ad=0.19p pd=1.38u as=0.34p ps=2.68u w=1u l=0.5u
X1 VRAMP.t9 RAMP_RESET.t0 VSS.t154 VSS.t158 sg13_lv_nmos ad=0.627p pd=3.68u as=0.627p ps=3.68u w=3.3u l=0.13u
X2 ramp_generator_0.ramp_generator_input_select_0.v_cmp.t4 VMEAS.t0 SEL_MEAS.t4 VSS.t107 sg13_lv_nmos ad=0.19p pd=1.38u as=0.19p ps=1.38u w=1u l=0.13u
X3 VCAL.t5 SEL_CAL.t0 ramp_generator_0.ramp_generator_input_select_0.v_cmp.t17 VSS.t132 sg13_lv_nmos ad=0.19p pd=1.38u as=0.19p ps=1.38u w=1u l=0.13u
X4 VSS.t138 RAMP_RESET.t0 VRAMP.t13 VSS.t157 sg13_lv_nmos ad=0.627p pd=3.68u as=0.627p ps=3.68u w=3.3u l=0.13u
X5 ota_lv_gmid_comparator_0.ota_slow_gmid_ctrl_buff_1.y.t0 ota_lv_gmid_comparator_0.ota_slow_gmid_ctrl_buff_1.ota_slow_gmid_ctrl_inv_0.x.t2 VSS.t162 VSS.t161 sg13_lv_nmos ad=0.68p pd=4.68u as=0.68p ps=4.68u w=2u l=0.13u
X6 ota_lv_gmid_comparator_0.ota_slow_gmid_ctrl_buff_1.y.t1 ota_lv_gmid_comparator_0.ota_slow_gmid_ctrl_buff_1.ota_slow_gmid_ctrl_inv_0.x.t2 VDD.t233 VDD.t88 sg13_lv_pmos ad=0.68p pd=4.68u as=0.68p ps=4.68u w=2u l=0.13u
X7 ramp_generator_0.ramp_generator_nmos_mirror_0.pmos_ref.t9 RAMP_EN.t0 VDD.t161 VDD.t40 sg13_lv_pmos ad=0.19p pd=1.38u as=0.19p ps=1.38u w=1u l=0.13u
X8 a_n2237_2812.t0 VDD.t21 VSS.t61 rhigh l=2.5u w=0.5u
X9 ramp_generator_0.ramp_generator_nmos_mirror_0.pmos_ref.t8 RAMP_EN.t0 VDD.t159 VDD.t133 sg13_lv_pmos ad=0.19p pd=1.38u as=0.19p ps=1.38u w=1u l=0.13u
X10 ota_lv_gmid_comparator_0.ota_slow_gmid_mirror_0.vref.t1 VRAMP.t14 ota_lv_gmid_comparator_0.ota_slow_gmid_common_0/ota_slow_gmid_pairs_0.tail.t3 VDD.t32 sg13_lv_pmos ad=0.85p pd=5.68u as=0.475p ps=2.88u w=2.5u l=5u
X11 a_n2237_2812.t1 VDD.t22 VSS.t62 rhigh l=2.5u w=0.5u
X12 VRAMP.t8 RAMP_RESET.t1 VSS.t151 VSS.t156 sg13_lv_nmos ad=0.627p pd=3.68u as=0.627p ps=3.68u w=3.3u l=0.13u
X13 VDD.t91 ota_lv_gmid_comparator_0.ota_slow_gmid_ctrl_buff_1.y.t2 VBIAS.t7 VDD.t88 sg13_lv_pmos ad=0.27075p pd=1.805u as=0.4845p ps=3.53u w=1.425u l=0.13u
X14 VBIAS.t5 ota_lv_gmid_comparator_0.ota_slow_gmid_ctrl_buff_1.y.t2 VDD.t101 VDD.t88 sg13_lv_pmos ad=0.27075p pd=1.805u as=0.27075p ps=1.805u w=1.425u l=0.13u
X15 VCAL.t3 SEL_CAL.t0 ramp_generator_0.ramp_generator_input_select_0.v_cmp.t20 VSS.t131 sg13_lv_nmos ad=0.19p pd=1.38u as=0.19p ps=1.38u w=1u l=0.13u
X16 VDD.t229 VDD.t198 VDD.t228 VDD.t1 sg13_lv_pmos ad=0.34p pd=2.68u as=0 ps=0 w=1u l=0.5u
X17 ota_lv_gmid_comparator_0.ota_slow_gmid_mirror_0.vout1.t7 ota_lv_gmid_comparator_0.ota_slow_gmid_ctrl_buff_1.y.t3 VDD.t111 VDD.t28 sg13_lv_pmos ad=0.27075p pd=1.805u as=0.27075p ps=1.805u w=1.425u l=0.13u
X18 a_n786_n1161.t2 ota_lv_gmid_comparator_0.ota_slow_gmid_ctrl_buff_0.x.t6 VDD.t74 VSS.t75 sg13_lv_nmos ad=55.85f pd=0.74u as=55.85f ps=0.74u w=0.155u l=0.5u
X19 VDD.t77 ota_lv_gmid_comparator_0.ota_slow_gmid_ctrl_buff_0.x.t6 a_n786_n1161.t1 VSS.t76 sg13_lv_nmos ad=0.10085p pd=1.34u as=55.85f ps=0.74u w=0.155u l=0.5u
X20 SEL_MEAS.t4 VMEAS.t0 ramp_generator_0.ramp_generator_input_select_0.v_cmp.t9 VSS.t106 sg13_lv_nmos ad=0.19p pd=1.38u as=0.19p ps=1.38u w=1u l=0.13u
X21 VDD.t196 VDD.t195 VDD.t196 VDD.t28 sg13_lv_pmos ad=0.475p pd=2.88u as=0 ps=0 w=2.5u l=2u
X22 a_n786_n1161.t8 ota_lv_gmid_comparator_0.ota_slow_gmid_ctrl_buff_0.x.t6 VDD.t75 VSS.t82 sg13_lv_nmos ad=55.85f pd=0.74u as=0.10085p ps=1.34u w=0.155u l=0.5u
X23 VDD.t35 VDD.t36 VSS.t72 rhigh l=3u w=0.5u
X24 ramp_generator_0.ramp_generator_nmos_mirror_0.pmos_ref.t15 RAMP_EN.t0 VDD.t142 VDD.t169 sg13_lv_pmos ad=0.19p pd=1.38u as=0.19p ps=1.38u w=1u l=0.13u
X25 SEL_MEAS.t2 VMEAS.t0 ramp_generator_0.ramp_generator_input_select_0.v_cmp.t8 VSS.t105 sg13_lv_nmos ad=0.19p pd=1.38u as=0.19p ps=1.38u w=1u l=0.13u
X26 VDD.t132 RAMP_EN.t0 ramp_generator_0.ramp_generator_nmos_mirror_0.pmos_ref.t19 VDD.t168 sg13_lv_pmos ad=0.19p pd=1.38u as=0.19p ps=1.38u w=1u l=0.13u
X27 VDD.t70 ramp_generator_0.ramp_generator_nmos_mirror_0.pmos_ref.t22 ramp_generator_0.ramp_generator_nmos_mirror_0.pmos_ref.t52 VDD.t42 sg13_lv_pmos ad=0.1005p pd=1.34u as=0.1005p ps=1.34u w=0.15u l=10u
X28 a_n786_n1161.t9 ota_lv_gmid_comparator_0.ota_slow_gmid_ctrl_buff_0.x.t6 VDD.t72 VSS.t73 sg13_lv_nmos ad=55.85f pd=0.74u as=55.85f ps=0.74u w=0.155u l=0.5u
X29 ramp_generator_0.ramp_generator_nmos_mirror_0.pmos_ref.t6 RAMP_EN.t0 VDD.t145 VDD.t167 sg13_lv_pmos ad=0.19p pd=1.38u as=0.19p ps=1.38u w=1u l=0.13u
X30 VDD.t9 a_n7165_947# VDD.t8 VDD.t7 sg13_lv_pmos ad=0.1005p pd=1.34u as=0 ps=0 w=0.15u l=5u
X31 ota_lv_gmid_comparator_0.ota_slow_gmid_ctrl_buff_0.ota_slow_gmid_ctrl_inv_0.x.t0 ota_lv_gmid_comparator_0.ota_slow_gmid_ctrl_buff_0.x.t7 VSS.t65 VSS.t64 sg13_lv_nmos ad=0.68p pd=4.68u as=0.68p ps=4.68u w=2u l=0.13u
X32 ramp_generator_0.ramp_generator_nmos_mirror_0.pmos_ref.t51 ramp_generator_0.ramp_generator_nmos_mirror_0.pmos_ref.t22 VDD.t69 VDD.t40 sg13_lv_pmos ad=0.1005p pd=1.34u as=0.1005p ps=1.34u w=0.15u l=10u
X33 ramp_generator_0.ramp_generator_nmos_mirror_0.pmos_ref.t50 ramp_generator_0.ramp_generator_nmos_mirror_0.pmos_ref.t22 VDD.t68 VDD.t10 sg13_lv_pmos ad=0.1005p pd=1.34u as=0.1005p ps=1.34u w=0.15u l=10u
X34 VDD.t83 a_n7165_1683# VDD.t82 VDD.t7 sg13_lv_pmos ad=0.1005p pd=1.34u as=0 ps=0 w=0.15u l=5u
X35 ramp_generator_0.ramp_generator_nmos_mirror_0.pmos_ref.t49 ramp_generator_0.ramp_generator_nmos_mirror_0.pmos_ref.t22 VDD.t67 VDD.t10 sg13_lv_pmos ad=0.1005p pd=1.34u as=0.1005p ps=1.34u w=0.15u l=10u
X36 RAMP_REF.t7 RAMP_REF.t3 VSS.t71 VSS.t109 sg13_lv_nmos ad=0.102p pd=1.28u as=57f ps=0.68u w=0.3u l=10u
X37 ramp_generator_0.ramp_generator_nmos_mirror_0.pmos_ref.t48 ramp_generator_0.ramp_generator_nmos_mirror_0.pmos_ref.t22 VDD.t66 VDD.t10 sg13_lv_pmos ad=0.1005p pd=1.34u as=0.1005p ps=1.34u w=0.15u l=10u
X38 VDD.t34 a_n17365_947# VDD.t33 VDD.t10 sg13_lv_pmos ad=0.1005p pd=1.34u as=0 ps=0 w=0.15u l=5u
X39 VDD.t114 ota_lv_gmid_comparator_0.ota_slow_gmid_ctrl_buff_1.y.t3 ota_lv_gmid_comparator_0.ota_slow_gmid_mirror_0.vout1.t7 VDD.t28 sg13_lv_pmos ad=0.27075p pd=1.805u as=0.27075p ps=1.805u w=1.425u l=0.13u
X40 VDD.t101 ota_lv_gmid_comparator_0.ota_slow_gmid_ctrl_buff_1.y.t2 VBIAS.t4 VDD.t88 sg13_lv_pmos ad=0.27075p pd=1.805u as=0.27075p ps=1.805u w=1.425u l=0.13u
X41 ota_lv_gmid_comparator_0.ota_slow_gmid_mirror_0.vout1.t5 ota_lv_gmid_comparator_0.ota_slow_gmid_ctrl_buff_1.y.t3 VDD.t115 VDD.t28 sg13_lv_pmos ad=0.27075p pd=1.805u as=0.4845p ps=3.53u w=1.425u l=0.13u
X42 VCAL.t4 SEL_CAL.t0 ramp_generator_0.ramp_generator_input_select_0.v_cmp.t16 VSS.t130 sg13_lv_nmos ad=0.19p pd=1.38u as=0.34p ps=2.68u w=1u l=0.13u
X43 ota_lv_gmid_comparator_0.ota_slow_gmid_mirror_0.vout1.t6 ota_lv_gmid_comparator_0.ota_slow_gmid_ctrl_buff_1.y.t3 VDD.t114 VDD.t28 sg13_lv_pmos ad=0.4845p pd=3.53u as=0.27075p ps=1.805u w=1.425u l=0.13u
X44 VBIAS.t4 ota_lv_gmid_comparator_0.ota_slow_gmid_ctrl_buff_1.y.t2 VDD.t92 VDD.t88 sg13_lv_pmos ad=0.27075p pd=1.805u as=0.27075p ps=1.805u w=1.425u l=0.13u
X45 VDD.t112 ota_lv_gmid_comparator_0.ota_slow_gmid_ctrl_buff_1.y.t3 ota_lv_gmid_comparator_0.ota_slow_gmid_mirror_0.vout1.t5 VDD.t28 sg13_lv_pmos ad=0.27075p pd=1.805u as=0.27075p ps=1.805u w=1.425u l=0.13u
X46 ota_lv_gmid_comparator_0.ota_slow_gmid_common_0/ota_slow_gmid_pairs_0.tail.t1 VBIAS.t8 VDD.t16 VDD.t1 sg13_lv_pmos ad=0.34p pd=2.68u as=0.19p ps=1.38u w=1u l=0.5u
X47 ramp_generator_0.ramp_generator_nmos_mirror_0.pmos_ref.t4 RAMP_EN.t0 VDD.t154 VDD.t126 sg13_lv_pmos ad=0.19p pd=1.38u as=0.19p ps=1.38u w=1u l=0.13u
X48 VDD.t125 RAMP_EN.t0 ramp_generator_0.ramp_generator_nmos_mirror_0.pmos_ref.t18 VDD.t165 sg13_lv_pmos ad=0.19p pd=1.38u as=0.19p ps=1.38u w=1u l=0.13u
X49 VDD.t74 ota_lv_gmid_comparator_0.ota_slow_gmid_ctrl_buff_0.x.t6 a_n786_n1161.t7 VSS.t78 sg13_lv_nmos ad=55.85f pd=0.74u as=55.85f ps=0.74u w=0.155u l=0.5u
X50 ota_lv_gmid_comparator_0.ota_slow_gmid_common_0/ota_slow_gmid_pairs_0.tail.t3 ramp_generator_0.ramp_generator_input_select_0.v_cmp.t21 ota_lv_gmid_comparator_0.ota_slow_gmid_mirror_0.vota.t1 VDD.t27 sg13_lv_pmos ad=0.475p pd=2.88u as=0.85p ps=5.68u w=2.5u l=5u
X51 VDD.t71 ota_lv_gmid_comparator_0.ota_slow_gmid_ctrl_buff_0.x.t6 a_n786_n1161.t9 VSS.t74 sg13_lv_nmos ad=55.85f pd=0.74u as=55.85f ps=0.74u w=0.155u l=0.5u
X52 SEL_MEAS.t1 VMEAS.t0 ramp_generator_0.ramp_generator_input_select_0.v_cmp.t6 VSS.t104 sg13_lv_nmos ad=0.19p pd=1.38u as=0.19p ps=1.38u w=1u l=0.13u
X53 VDD.t224 VDD.t206 VDD.t205 VDD.t88 sg13_lv_pmos ad=0.85p pd=5.68u as=0 ps=0 w=2.5u l=2u
X54 SEL_MEAS.t7 VMEAS.t0 ramp_generator_0.ramp_generator_input_select_0.v_cmp.t5 VSS.t103 sg13_lv_nmos ad=0.19p pd=1.38u as=0.19p ps=1.38u w=1u l=0.13u
X55 ramp_generator_0.ramp_generator_input_select_0.v_cmp.t18 SEL_CAL.t0 VCAL.t9 VSS.t129 sg13_lv_nmos ad=0.19p pd=1.38u as=0.19p ps=1.38u w=1u l=0.13u
X56 ramp_generator_0.ramp_generator_nmos_mirror_0.pmos_ref.t47 ramp_generator_0.ramp_generator_nmos_mirror_0.pmos_ref.t22 VDD.t65 VDD.t40 sg13_lv_pmos ad=0.1005p pd=1.34u as=0.1005p ps=1.34u w=0.15u l=10u
X57 VDD.t207 VDD.t204 VDD.t207 VDD.t88 sg13_lv_pmos ad=0.475p pd=2.88u as=0 ps=0 w=2.5u l=2u
X58 ota_lv_gmid_comparator_0.ota_slow_gmid_mirror_0.vout1.t4 ota_lv_gmid_comparator_0.ota_slow_gmid_ctrl_buff_1.y.t3 VDD.t112 VDD.t28 sg13_lv_pmos ad=0.27075p pd=1.805u as=0.27075p ps=1.805u w=1.425u l=0.13u
X59 ramp_generator_0.ramp_generator_input_select_0.v_cmp.t13 SEL_CAL.t0 VCAL.t8 VSS.t128 sg13_lv_nmos ad=0.19p pd=1.38u as=0.19p ps=1.38u w=1u l=0.13u
X60 a_n786_n1161.t10 ota_lv_gmid_comparator_0.ota_slow_gmid_mirror_0.vout1.t14 ota_lv_gmid_comparator_0.ota_slow_gmid_ctrl_buff_0.x.t1 VSS.t60 sg13_lv_nmos ad=0.38p pd=2.38u as=0.38p ps=2.38u w=2u l=0.13u
X61 VDD.t73 ota_lv_gmid_comparator_0.ota_slow_gmid_ctrl_buff_0.x.t6 a_n786_n1161.t5 VSS.t77 sg13_lv_nmos ad=55.85f pd=0.74u as=55.85f ps=0.74u w=0.155u l=0.5u
X62 VDD.t5 VDD.t6 VSS.t3 rhigh l=3u w=0.5u
X63 a_n586_691.t4 ota_lv_gmid_comparator_0.ota_slow_gmid_mirror_0.vout1.t14 ota_lv_gmid_comparator_0.ota_slow_gmid_ctrl_buff_0.x.t4 VDD.t1 sg13_lv_pmos ad=0.2375p pd=1.63u as=0.2375p ps=1.63u w=1.25u l=0.13u
X64 VDD.t140 RAMP_EN.t0 ramp_generator_0.ramp_generator_nmos_mirror_0.pmos_ref.t17 VDD.t164 sg13_lv_pmos ad=0.19p pd=1.38u as=0.19p ps=1.38u w=1u l=0.13u
X65 ramp_generator_0.ramp_generator_nmos_mirror_0.pmos_ref.t1 RAMP_EN.t0 VDD.t150 VDD.t163 sg13_lv_pmos ad=0.19p pd=1.38u as=0.19p ps=1.38u w=1u l=0.13u
X66 VDD.t162 RAMP_EN.t0 ramp_generator_0.ramp_generator_nmos_mirror_0.pmos_ref.t11 VDD.t138 sg13_lv_pmos ad=0.34p pd=2.68u as=0.19p ps=1.38u w=1u l=0.13u
X67 VSS.t142 RAMP_RESET.t1 VRAMP.t11 VSS.t155 sg13_lv_nmos ad=0.627p pd=3.68u as=0.627p ps=3.68u w=3.3u l=0.13u
X68 VDD.t64 ramp_generator_0.ramp_generator_nmos_mirror_0.pmos_ref.t22 ramp_generator_0.ramp_generator_nmos_mirror_0.pmos_ref.t46 VDD.t42 sg13_lv_pmos ad=0.1005p pd=1.34u as=0.1005p ps=1.34u w=0.15u l=10u
X69 VDD.t63 ramp_generator_0.ramp_generator_nmos_mirror_0.pmos_ref.t22 ramp_generator_0.ramp_generator_nmos_mirror_0.pmos_ref.t45 VDD.t7 sg13_lv_pmos ad=0.1005p pd=1.34u as=0.1005p ps=1.34u w=0.15u l=10u
X70 VDD.t111 ota_lv_gmid_comparator_0.ota_slow_gmid_ctrl_buff_1.y.t3 ota_lv_gmid_comparator_0.ota_slow_gmid_mirror_0.vout1.t4 VDD.t28 sg13_lv_pmos ad=0.27075p pd=1.805u as=0.27075p ps=1.805u w=1.425u l=0.13u
X71 VSS.t154 RAMP_RESET.t0 VRAMP.t10 VSS.t153 sg13_lv_nmos ad=0.627p pd=3.68u as=0.627p ps=3.68u w=3.3u l=0.13u
X72 VRAMP.t13 RAMP_RESET.t0 VSS.t147 VSS.t152 sg13_lv_nmos ad=0.627p pd=3.68u as=0.627p ps=3.68u w=3.3u l=0.13u
X73 VDD.t161 RAMP_EN.t0 ramp_generator_0.ramp_generator_nmos_mirror_0.pmos_ref.t10 VDD.t160 sg13_lv_pmos ad=0.19p pd=1.38u as=0.19p ps=1.38u w=1u l=0.13u
X74 VDD.t159 RAMP_EN.t0 ramp_generator_0.ramp_generator_nmos_mirror_0.pmos_ref.t16 VDD.t158 sg13_lv_pmos ad=0.19p pd=1.38u as=0.19p ps=1.38u w=1u l=0.13u
X75 VDD.t62 ramp_generator_0.ramp_generator_nmos_mirror_0.pmos_ref.t22 ramp_generator_0.ramp_generator_nmos_mirror_0.pmos_ref.t44 VDD.t7 sg13_lv_pmos ad=0.1005p pd=1.34u as=0.1005p ps=1.34u w=0.15u l=10u
X76 VSS.t55 VSS.t16 VSS.t54 VSS.t17 sg13_lv_nmos ad=0.102p pd=1.28u as=0 ps=0 w=0.3u l=10u
X77 VSS.t84 ota_lv_gmid_comparator_0.ota_slow_gmid_mirror_0.vota.t4 ota_lv_gmid_comparator_0.ota_slow_gmid_mirror_0.vout1.t11 VSS.t85 sg13_lv_nmos ad=95f pd=0.88u as=0.17p ps=1.68u w=0.5u l=10u
X78 VDD.t93 ota_lv_gmid_comparator_0.ota_slow_gmid_ctrl_buff_1.y.t2 VBIAS.t1 VDD.t88 sg13_lv_pmos ad=0.27075p pd=1.805u as=0.27075p ps=1.805u w=1.425u l=0.13u
X79 VSS.t1 ota_lv_gmid_comparator_0.ota_slow_gmid_ctrl_buff_0.x.t8 a_n586_691.t1 VDD.t4 sg13_lv_pmos ad=95f pd=0.88u as=95f ps=0.88u w=0.5u l=1u
X80 VSS.t151 RAMP_RESET.t1 VRAMP.t12 VSS.t150 sg13_lv_nmos ad=0.627p pd=3.68u as=1.122p ps=7.28u w=3.3u l=0.13u
X81 VSS.t52 VSS.t4 VSS.t51 VSS.t5 sg13_lv_nmos ad=0.102p pd=1.28u as=0 ps=0 w=0.3u l=10u
X82 VSS.t71 RAMP_REF.t0 RAMP_REF.t6 VSS.t67 sg13_lv_nmos ad=57f pd=0.68u as=0.102p ps=1.28u w=0.3u l=10u
X83 ota_lv_gmid_comparator_0.ota_slow_gmid_mirror_0.vout1.t10 ota_lv_gmid_comparator_0.ota_slow_gmid_mirror_0.vota.t4 VSS.t84 VSS.t83 sg13_lv_nmos ad=0.17p pd=1.68u as=95f ps=0.88u w=0.5u l=10u
X84 SEL_MEAS.t6 VMEAS.t0 ramp_generator_0.ramp_generator_input_select_0.v_cmp.t10 VSS.t102 sg13_lv_nmos ad=0.19p pd=1.38u as=0.19p ps=1.38u w=1u l=0.13u
X85 ramp_generator_0.ramp_generator_input_select_0.v_cmp.t17 SEL_CAL.t0 VCAL.t7 VSS.t127 sg13_lv_nmos ad=0.19p pd=1.38u as=0.19p ps=1.38u w=1u l=0.13u
X86 VDD.t23 VDD.t24 VSS.t63 rhigh l=3u w=0.5u
X87 ramp_generator_0.ramp_generator_nmos_mirror_0.pmos_ref.t19 RAMP_EN.t0 VDD.t147 VDD.t146 sg13_lv_pmos ad=0.19p pd=1.38u as=0.19p ps=1.38u w=1u l=0.13u
X88 VDD.t231 a_n17365_1131# VDD.t230 VDD.t10 sg13_lv_pmos ad=0.1005p pd=1.34u as=0 ps=0 w=0.15u l=5u
X89 ramp_generator_0.ramp_generator_nmos_mirror_0.pmos_ref.t43 ramp_generator_0.ramp_generator_nmos_mirror_0.pmos_ref.t22 VDD.t61 VDD.t10 sg13_lv_pmos ad=0.1005p pd=1.34u as=0.1005p ps=1.34u w=0.15u l=10u
X90 CMP_OUTPUT.t0 ota_lv_gmid_comparator_0.ota_slow_gmid_ctrl_buff_0.ota_slow_gmid_ctrl_inv_0.x.t2 VSS.t160 VSS.t159 sg13_lv_nmos ad=0.68p pd=4.68u as=0.68p ps=4.68u w=2u l=0.13u
X91 VDD.t85 a_n17365_1499# VDD.t84 VDD.t10 sg13_lv_pmos ad=0.1005p pd=1.34u as=0 ps=0 w=0.15u l=5u
X92 VSS.t169 VRAMP.t1 cap_cmim l=40u w=40u
X93 VDD.t12 a_n17365_1867# VDD.t11 VDD.t10 sg13_lv_pmos ad=0.1005p pd=1.34u as=0 ps=0 w=0.15u l=5u
X94 RAMP_REF.t5 RAMP_REF.t3 VSS.t69 VSS.t109 sg13_lv_nmos ad=0.102p pd=1.28u as=57f ps=0.68u w=0.3u l=10u
X95 VDD.t137 RAMP_EN.t0 ramp_generator_0.ramp_generator_nmos_mirror_0.pmos_ref.t14 VDD.t144 sg13_lv_pmos ad=0.19p pd=1.38u as=0.19p ps=1.38u w=1u l=0.13u
X96 VSS.t49 VSS.t4 VSS.t48 VSS.t5 sg13_lv_nmos ad=0.102p pd=1.28u as=0 ps=0 w=0.3u l=10u
X97 a_n786_n1161.t4 ota_lv_gmid_comparator_0.ota_slow_gmid_ctrl_buff_0.x.t6 VDD.t81 VSS.t81 sg13_lv_nmos ad=55.85f pd=0.74u as=55.85f ps=0.74u w=0.155u l=0.5u
X98 a_n786_n1161.t12 ota_lv_gmid_comparator_0.ota_slow_gmid_mirror_0.vout1.t14 ota_lv_gmid_comparator_0.ota_slow_gmid_ctrl_buff_0.x.t2 VSS.t59 sg13_lv_nmos ad=0.38p pd=2.38u as=0.38p ps=2.38u w=2u l=0.13u
X99 RAMP_REF.t4 RAMP_REF.t3 VSS.t70 VSS.t109 sg13_lv_nmos ad=0.102p pd=1.28u as=57f ps=0.68u w=0.3u l=10u
X100 VDD.t219 VDD.t192 VDD.t218 VDD.t1 sg13_lv_pmos ad=0.34p pd=2.68u as=0 ps=0 w=1u l=0.5u
X101 VBIAS.t1 ota_lv_gmid_comparator_0.ota_slow_gmid_ctrl_buff_1.y.t2 VDD.t96 VDD.t88 sg13_lv_pmos ad=0.27075p pd=1.805u as=0.27075p ps=1.805u w=1.425u l=0.13u
X102 VDD.t97 ota_lv_gmid_comparator_0.ota_slow_gmid_ctrl_buff_1.y.t2 VBIAS.t2 VDD.t88 sg13_lv_pmos ad=0.4845p pd=3.53u as=0.27075p ps=1.805u w=1.425u l=0.13u
X103 VSS.t70 RAMP_REF.t0 RAMP_REF.t2 VSS.t67 sg13_lv_nmos ad=57f pd=0.68u as=0.102p ps=1.28u w=0.3u l=10u
X104 ramp_generator_0.ramp_generator_input_select_0.v_cmp.t10 VMEAS.t0 SEL_MEAS.t5 VSS.t101 sg13_lv_nmos ad=0.19p pd=1.38u as=0.19p ps=1.38u w=1u l=0.13u
X105 ramp_generator_0.ramp_generator_input_select_0.v_cmp.t20 SEL_CAL.t0 VCAL.t6 VSS.t126 sg13_lv_nmos ad=0.19p pd=1.38u as=0.19p ps=1.38u w=1u l=0.13u
X106 ramp_generator_0.ramp_generator_input_select_0.v_cmp.t9 VMEAS.t0 SEL_MEAS.t3 VSS.t100 sg13_lv_nmos ad=0.19p pd=1.38u as=0.19p ps=1.38u w=1u l=0.13u
X107 ramp_generator_0.ramp_generator_input_select_0.v_cmp.t8 VMEAS.t0 SEL_MEAS.t9 VSS.t99 sg13_lv_nmos ad=0.19p pd=1.38u as=0.19p ps=1.38u w=1u l=0.13u
X108 ramp_generator_0.ramp_generator_nmos_mirror_0.pmos_ref.t5 RAMP_EN.t0 VDD.t121 VDD.t42 sg13_lv_pmos ad=0.19p pd=1.38u as=0.19p ps=1.38u w=1u l=0.13u
X109 ramp_generator_0.ramp_generator_nmos_mirror_0.pmos_ref.t42 ramp_generator_0.ramp_generator_nmos_mirror_0.pmos_ref.t22 VDD.t60 VDD.t40 sg13_lv_pmos ad=0.1005p pd=1.34u as=0.1005p ps=1.34u w=0.15u l=10u
X110 VCAL.t0 SEL_CAL.t0 ramp_generator_0.ramp_generator_input_select_0.v_cmp.t12 VSS.t125 sg13_lv_nmos ad=0.19p pd=1.38u as=0.19p ps=1.38u w=1u l=0.13u
X111 VDD.t154 RAMP_EN.t0 ramp_generator_0.ramp_generator_nmos_mirror_0.pmos_ref.t13 VDD.t153 sg13_lv_pmos ad=0.19p pd=1.38u as=0.19p ps=1.38u w=1u l=0.13u
X112 ramp_generator_0.ramp_generator_nmos_mirror_0.pmos_ref.t18 RAMP_EN.t0 VDD.t127 VDD.t152 sg13_lv_pmos ad=0.19p pd=1.38u as=0.19p ps=1.38u w=1u l=0.13u
X113 VDD.t26 a_n7165_1315# VDD.t25 VDD.t7 sg13_lv_pmos ad=0.1005p pd=1.34u as=0 ps=0 w=0.15u l=5u
X114 VSS.t167 ota_lv_gmid_comparator_0.ota_slow_gmid_mirror_0.vref.t2 ota_lv_gmid_comparator_0.ota_slow_gmid_mirror_0.vref.t4 VSS.t85 sg13_lv_nmos ad=95f pd=0.88u as=0.17p ps=1.68u w=0.5u l=10u
X115 VDD.t16 VBIAS.t8 ota_lv_gmid_comparator_0.ota_slow_gmid_common_0/ota_slow_gmid_tail_0.ibiasn.t1 VDD.t1 sg13_lv_pmos ad=0.19p pd=1.38u as=0.34p ps=2.68u w=1u l=0.5u
X116 VDD.t72 ota_lv_gmid_comparator_0.ota_slow_gmid_ctrl_buff_0.x.t6 a_n786_n1161.t8 VSS.t80 sg13_lv_nmos ad=55.85f pd=0.74u as=55.85f ps=0.74u w=0.155u l=0.5u
X117 VDD.t216 VDD.t195 VDD.t210 VDD.t28 sg13_lv_pmos ad=0.85p pd=5.68u as=0 ps=0 w=2.5u l=2u
X118 VDD.t96 ota_lv_gmid_comparator_0.ota_slow_gmid_ctrl_buff_1.y.t2 VBIAS.t3 VDD.t88 sg13_lv_pmos ad=0.27075p pd=1.805u as=0.4845p ps=3.53u w=1.425u l=0.13u
X119 VDD.t59 ramp_generator_0.ramp_generator_nmos_mirror_0.pmos_ref.t22 ramp_generator_0.ramp_generator_nmos_mirror_0.pmos_ref.t41 VDD.t42 sg13_lv_pmos ad=0.1005p pd=1.34u as=0.1005p ps=1.34u w=0.15u l=10u
X120 VBIAS.t2 ota_lv_gmid_comparator_0.ota_slow_gmid_ctrl_buff_1.y.t2 VDD.t94 VDD.t88 sg13_lv_pmos ad=0.27075p pd=1.805u as=0.27075p ps=1.805u w=1.425u l=0.13u
X121 ota_lv_gmid_comparator_0.ota_slow_gmid_mirror_0.vota.t3 ota_lv_gmid_comparator_0.ota_slow_gmid_mirror_0.vref.t2 VSS.t167 VSS.t83 sg13_lv_nmos ad=0.17p pd=1.68u as=95f ps=0.88u w=0.5u l=10u
X122 VSS.t165 ota_lv_gmid_comparator_0.ota_slow_gmid_mirror_0.vref.t2 ota_lv_gmid_comparator_0.ota_slow_gmid_mirror_0.vota.t2 VSS.t85 sg13_lv_nmos ad=95f pd=0.88u as=0.17p ps=1.68u w=0.5u l=10u
X123 VDD.t87 a_n7165_763# VDD.t86 VDD.t7 sg13_lv_pmos ad=0.1005p pd=1.34u as=0 ps=0 w=0.15u l=5u
X124 VDD.t213 VDD.t198 VDD.t212 VDD.t1 sg13_lv_pmos ad=0.34p pd=2.68u as=0 ps=0 w=1u l=0.5u
X125 ramp_generator_0.ramp_generator_nmos_mirror_0.pmos_ref.t17 RAMP_EN.t0 VDD.t141 VDD.t151 sg13_lv_pmos ad=0.19p pd=1.38u as=0.19p ps=1.38u w=1u l=0.13u
X126 ramp_generator_0.ramp_generator_nmos_mirror_0.pmos_ref.t40 ramp_generator_0.ramp_generator_nmos_mirror_0.pmos_ref.t22 VDD.t58 VDD.t10 sg13_lv_pmos ad=0.1005p pd=1.34u as=0.1005p ps=1.34u w=0.15u l=10u
X127 ota_lv_gmid_comparator_0.ota_slow_gmid_mirror_0.vref.t3 ota_lv_gmid_comparator_0.ota_slow_gmid_mirror_0.vref.t2 VSS.t165 VSS.t83 sg13_lv_nmos ad=0.17p pd=1.68u as=95f ps=0.88u w=0.5u l=10u
X128 VDD.t150 RAMP_EN.t0 ramp_generator_0.ramp_generator_nmos_mirror_0.pmos_ref.t12 VDD.t139 sg13_lv_pmos ad=0.19p pd=1.38u as=0.19p ps=1.38u w=1u l=0.13u
X129 VDD.t187 a_n17365_763# VDD.t186 VDD.t10 sg13_lv_pmos ad=0.1005p pd=1.34u as=0 ps=0 w=0.15u l=5u
X130 ramp_generator_0.ramp_generator_input_select_0.v_cmp.t7 VMEAS.t0 SEL_MEAS.t2 VSS.t98 sg13_lv_nmos ad=0.34p pd=2.68u as=0.19p ps=1.38u w=1u l=0.13u
X131 VRAMP.t11 RAMP_RESET.t1 VSS.t144 VSS.t149 sg13_lv_nmos ad=0.627p pd=3.68u as=0.627p ps=3.68u w=3.3u l=0.13u
X132 VDD.t94 ota_lv_gmid_comparator_0.ota_slow_gmid_ctrl_buff_1.y.t2 VBIAS.t0 VDD.t88 sg13_lv_pmos ad=0.27075p pd=1.805u as=0.27075p ps=1.805u w=1.425u l=0.13u
X133 VDD.t30 VDD.t31 VSS.t66 rhigh l=3u w=0.5u
X134 a_n786_n1161.t7 ota_lv_gmid_comparator_0.ota_slow_gmid_ctrl_buff_0.x.t6 VDD.t73 VSS.t81 sg13_lv_nmos ad=55.85f pd=0.74u as=55.85f ps=0.74u w=0.155u l=0.5u
X135 ramp_generator_0.ramp_generator_input_select_0.v_cmp.t6 VMEAS.t0 SEL_MEAS.t0 VSS.t97 sg13_lv_nmos ad=0.19p pd=1.38u as=0.19p ps=1.38u w=1u l=0.13u
X136 VBIAS.t0 ota_lv_gmid_comparator_0.ota_slow_gmid_ctrl_buff_1.y.t2 VDD.t93 VDD.t88 sg13_lv_pmos ad=0.27075p pd=1.805u as=0.27075p ps=1.805u w=1.425u l=0.13u
X137 VRAMP.t10 RAMP_RESET.t0 VSS.t140 VSS.t148 sg13_lv_nmos ad=0.627p pd=3.68u as=0.627p ps=3.68u w=3.3u l=0.13u
X138 ramp_generator_0.ramp_generator_input_select_0.v_cmp.t5 VMEAS.t0 SEL_MEAS.t8 VSS.t96 sg13_lv_nmos ad=0.19p pd=1.38u as=0.19p ps=1.38u w=1u l=0.13u
X139 VCAL.t9 SEL_CAL.t0 ramp_generator_0.ramp_generator_input_select_0.v_cmp.t15 VSS.t124 sg13_lv_nmos ad=0.19p pd=1.38u as=0.19p ps=1.38u w=1u l=0.13u
X140 ota_lv_gmid_comparator_0.ota_slow_gmid_ctrl_buff_0.x.t1 ota_lv_gmid_comparator_0.ota_slow_gmid_mirror_0.vout1.t14 a_n786_n1161.t12 VSS.t58 sg13_lv_nmos ad=0.38p pd=2.38u as=0.38p ps=2.38u w=2u l=0.13u
X141 VSS.t147 RAMP_RESET.t0 VRAMP.t9 VSS.t146 sg13_lv_nmos ad=0.627p pd=3.68u as=0.627p ps=3.68u w=3.3u l=0.13u
X142 VDD.t79 ota_lv_gmid_comparator_0.ota_slow_gmid_ctrl_buff_0.x.t6 a_n786_n1161.t6 VSS.t80 sg13_lv_nmos ad=55.85f pd=0.74u as=55.85f ps=0.74u w=0.155u l=0.5u
X143 VCAL.t8 SEL_CAL.t0 ramp_generator_0.ramp_generator_input_select_0.v_cmp.t19 VSS.t123 sg13_lv_nmos ad=0.19p pd=1.38u as=0.19p ps=1.38u w=1u l=0.13u
X144 VSS.t2 ota_lv_gmid_comparator_0.ota_slow_gmid_ctrl_buff_0.x.t8 a_n586_691.t0 VDD.t3 sg13_lv_pmos ad=0.17p pd=1.68u as=95f ps=0.88u w=0.5u l=1u
X145 a_n786_n1161.t5 ota_lv_gmid_comparator_0.ota_slow_gmid_ctrl_buff_0.x.t6 VDD.t71 VSS.t79 sg13_lv_nmos ad=55.85f pd=0.74u as=55.85f ps=0.74u w=0.155u l=0.5u
X146 ramp_generator_0.ramp_generator_nmos_mirror_0.pmos_ref.t16 RAMP_EN.t0 VDD.t135 VDD.t149 sg13_lv_pmos ad=0.19p pd=1.38u as=0.19p ps=1.38u w=1u l=0.13u
X147 VDD.t57 ramp_generator_0.ramp_generator_nmos_mirror_0.pmos_ref.t22 VRAMP.t3 VDD.t42 sg13_lv_pmos ad=0.1005p pd=1.34u as=0.1005p ps=1.34u w=0.15u l=10u
X148 ota_lv_gmid_comparator_0.ota_slow_gmid_mirror_0.vota.t0 ramp_generator_0.ramp_generator_input_select_0.v_cmp.t22 ota_lv_gmid_comparator_0.ota_slow_gmid_common_0/ota_slow_gmid_pairs_0.tail.t2 VDD.t32 sg13_lv_pmos ad=0.85p pd=5.68u as=0.475p ps=2.88u w=2.5u l=5u
X149 ramp_generator_0.ramp_generator_nmos_mirror_0.pmos_ref.t0 RAMP_EN.t0 VDD.t134 VDD.t148 sg13_lv_pmos ad=0.19p pd=1.38u as=0.19p ps=1.38u w=1u l=0.13u
X150 ramp_generator_0.ramp_generator_nmos_mirror_0.pmos_ref.t39 ramp_generator_0.ramp_generator_nmos_mirror_0.pmos_ref.t22 VDD.t56 VDD.t40 sg13_lv_pmos ad=0.1005p pd=1.34u as=0.1005p ps=1.34u w=0.15u l=10u
X151 VSS.t69 RAMP_REF.t0 ramp_generator_0.ramp_generator_nmos_mirror_0.pmos_ref.t20 VSS.t67 sg13_lv_nmos ad=57f pd=0.68u as=0.102p ps=1.28u w=0.3u l=10u
X152 a_n786_n1161.t3 ota_lv_gmid_comparator_0.ota_slow_gmid_ctrl_buff_0.x.t6 VDD.t80 VSS.t79 sg13_lv_nmos ad=55.85f pd=0.74u as=55.85f ps=0.74u w=0.155u l=0.5u
X153 VSS.t136 RAMP_RESET.t1 VRAMP.t8 VSS.t145 sg13_lv_nmos ad=0.627p pd=3.68u as=0.627p ps=3.68u w=3.3u l=0.13u
X154 VSS.t163 ota_lv_gmid_comparator_0.ota_slow_gmid_mirror_0.vota.t5 ota_lv_gmid_comparator_0.ota_slow_gmid_mirror_0.vout1.t13 VSS.t85 sg13_lv_nmos ad=95f pd=0.88u as=0.17p ps=1.68u w=0.5u l=10u
X155 SEL_MEAS.t8 VMEAS.t0 ramp_generator_0.ramp_generator_input_select_0.v_cmp.t2 VSS.t95 sg13_lv_nmos ad=0.19p pd=1.38u as=0.19p ps=1.38u w=1u l=0.13u
X156 ota_lv_gmid_comparator_0.ota_slow_gmid_ctrl_buff_0.x.t3 ota_lv_gmid_comparator_0.ota_slow_gmid_mirror_0.vout1.t14 a_n586_691.t5 VDD.t1 sg13_lv_pmos ad=0.2375p pd=1.63u as=0.425p ps=3.18u w=1.25u l=0.13u
X157 VDD.t210 VDD.t195 VDD.t210 VDD.t28 sg13_lv_pmos ad=0.475p pd=2.88u as=0 ps=0 w=2.5u l=2u
X158 SEL_MEAS.t5 VMEAS.t0 ramp_generator_0.ramp_generator_input_select_0.v_cmp.t1 VSS.t94 sg13_lv_nmos ad=0.19p pd=1.38u as=0.19p ps=1.38u w=1u l=0.13u
X159 VDD.t147 RAMP_EN.t0 ramp_generator_0.ramp_generator_nmos_mirror_0.pmos_ref.t15 VDD.t146 sg13_lv_pmos ad=0.19p pd=1.38u as=0.19p ps=1.38u w=1u l=0.13u
X160 ramp_generator_0.ramp_generator_input_select_0.v_cmp.t14 SEL_CAL.t0 VCAL.t1 VSS.t122 sg13_lv_nmos ad=0.19p pd=1.38u as=0.19p ps=1.38u w=1u l=0.13u
X161 VDD.t55 ramp_generator_0.ramp_generator_nmos_mirror_0.pmos_ref.t22 ramp_generator_0.ramp_generator_nmos_mirror_0.pmos_ref.t38 VDD.t7 sg13_lv_pmos ad=0.1005p pd=1.34u as=0.1005p ps=1.34u w=0.15u l=10u
X162 VSS.t46 VSS.t4 VSS.t45 VSS.t5 sg13_lv_nmos ad=0.102p pd=1.28u as=0 ps=0 w=0.3u l=10u
X163 ota_lv_gmid_comparator_0.ota_slow_gmid_mirror_0.vout1.t12 ota_lv_gmid_comparator_0.ota_slow_gmid_mirror_0.vota.t5 VSS.t163 VSS.t83 sg13_lv_nmos ad=0.17p pd=1.68u as=95f ps=0.88u w=0.5u l=10u
X164 VDD.t145 RAMP_EN.t0 ramp_generator_0.ramp_generator_nmos_mirror_0.pmos_ref.t7 VDD.t131 sg13_lv_pmos ad=0.19p pd=1.38u as=0.19p ps=1.38u w=1u l=0.13u
X165 ota_lv_gmid_comparator_0.ota_slow_gmid_common_0/ota_slow_gmid_tail_0.ibiasn.t0 VBIAS.t8 VDD.t13 VDD.t1 sg13_lv_pmos ad=0.34p pd=2.68u as=0.19p ps=1.38u w=1u l=0.5u
X166 ramp_generator_0.ramp_generator_nmos_mirror_0.pmos_ref.t14 RAMP_EN.t0 VDD.t130 VDD.t144 sg13_lv_pmos ad=0.19p pd=1.38u as=0.19p ps=1.38u w=1u l=0.13u
X167 ota_lv_gmid_comparator_0.ota_slow_gmid_ctrl_buff_0.x.t5 ota_lv_gmid_comparator_0.ota_slow_gmid_mirror_0.vout1.t14 a_n586_691.t4 VDD.t1 sg13_lv_pmos ad=0.425p pd=3.18u as=0.2375p ps=1.63u w=1.25u l=0.13u
X168 ota_lv_gmid_comparator_0.ota_slow_gmid_ctrl_buff_0.x.t2 ota_lv_gmid_comparator_0.ota_slow_gmid_mirror_0.vout1.t14 a_n786_n1161.t11 VSS.t57 sg13_lv_nmos ad=0.38p pd=2.38u as=0.68p ps=4.68u w=2u l=0.13u
X169 VDD.t54 ramp_generator_0.ramp_generator_nmos_mirror_0.pmos_ref.t22 ramp_generator_0.ramp_generator_nmos_mirror_0.pmos_ref.t37 VDD.t7 sg13_lv_pmos ad=0.1005p pd=1.34u as=0.1005p ps=1.34u w=0.15u l=10u
X170 VDD.t53 ramp_generator_0.ramp_generator_nmos_mirror_0.pmos_ref.t22 ramp_generator_0.ramp_generator_nmos_mirror_0.pmos_ref.t36 VDD.t7 sg13_lv_pmos ad=0.1005p pd=1.34u as=0.1005p ps=1.34u w=0.15u l=10u
X171 VCAL.t7 SEL_CAL.t0 ramp_generator_0.ramp_generator_input_select_0.v_cmp.t14 VSS.t121 sg13_lv_nmos ad=0.19p pd=1.38u as=0.19p ps=1.38u w=1u l=0.13u
X172 ramp_generator_0.ramp_generator_nmos_mirror_0.pmos_ref.t13 RAMP_EN.t0 VDD.t128 VDD.t143 sg13_lv_pmos ad=0.19p pd=1.38u as=0.19p ps=1.38u w=1u l=0.13u
X173 VDD.t52 ramp_generator_0.ramp_generator_nmos_mirror_0.pmos_ref.t22 ramp_generator_0.ramp_generator_nmos_mirror_0.pmos_ref.t35 VDD.t7 sg13_lv_pmos ad=0.1005p pd=1.34u as=0.1005p ps=1.34u w=0.15u l=10u
X174 ota_lv_gmid_comparator_0.ota_slow_gmid_ctrl_buff_0.ota_slow_gmid_ctrl_inv_0.x.t1 ota_lv_gmid_comparator_0.ota_slow_gmid_ctrl_buff_0.x.t7 VDD.t29 VDD.t28 sg13_lv_pmos ad=0.68p pd=4.68u as=0.68p ps=4.68u w=2u l=0.13u
X175 VDD.t174 a_n2196_3318# VDD.t173 VDD.t172 sg13_lv_pmos ad=1.02p pd=6.68u as=0 ps=0 w=3u l=3u
X176 ota_lv_gmid_comparator_0.ota_slow_gmid_common_0/ota_slow_gmid_pairs_0.tail.t2 VRAMP.t15 ota_lv_gmid_comparator_0.ota_slow_gmid_mirror_0.vref.t0 VDD.t27 sg13_lv_pmos ad=0.475p pd=2.88u as=0.85p ps=5.68u w=2.5u l=5u
X177 VDD.t142 RAMP_EN.t0 ramp_generator_0.ramp_generator_nmos_mirror_0.pmos_ref.t3 VDD.t124 sg13_lv_pmos ad=0.19p pd=1.38u as=0.19p ps=1.38u w=1u l=0.13u
X178 VSS.t43 VSS.t16 VSS.t42 VSS.t17 sg13_lv_nmos ad=0.102p pd=1.28u as=0 ps=0 w=0.3u l=10u
X179 VSS.t170 VRAMP.t0 cap_cmim l=40u w=40u
X180 VSS.t40 VSS.t12 VSS.t39 VSS.t13 sg13_lv_nmos ad=0.17p pd=1.68u as=0 ps=0 w=0.5u l=2u
X181 VSS.t37 VSS.t8 VSS.t36 VSS.t9 sg13_lv_nmos ad=0.17p pd=1.68u as=0 ps=0 w=0.5u l=2u
X182 VDD.t76 ota_lv_gmid_comparator_0.ota_slow_gmid_ctrl_buff_0.x.t6 a_n786_n1161.t4 VSS.t78 sg13_lv_nmos ad=55.85f pd=0.74u as=55.85f ps=0.74u w=0.155u l=0.5u
X183 ota_lv_gmid_comparator_0.ota_slow_gmid_ctrl_buff_1.ota_slow_gmid_ctrl_inv_0.x.t1 RAMP_EN.t1 VDD.t89 VDD.t88 sg13_lv_pmos ad=0.68p pd=4.68u as=0.68p ps=4.68u w=2u l=0.13u
X184 VDD.t208 VDD.t206 VDD.t207 VDD.t88 sg13_lv_pmos ad=0.85p pd=5.68u as=0 ps=0 w=2.5u l=2u
X185 VCAL.t6 SEL_CAL.t0 ramp_generator_0.ramp_generator_input_select_0.v_cmp.t11 VSS.t120 sg13_lv_nmos ad=0.19p pd=1.38u as=0.19p ps=1.38u w=1u l=0.13u
X186 VDD.t176 a_n17365_1683# VDD.t175 VDD.t10 sg13_lv_pmos ad=0.1005p pd=1.34u as=0 ps=0 w=0.15u l=5u
X187 VDD.t81 ota_lv_gmid_comparator_0.ota_slow_gmid_ctrl_buff_0.x.t6 a_n786_n1161.t3 VSS.t77 sg13_lv_nmos ad=55.85f pd=0.74u as=55.85f ps=0.74u w=0.155u l=0.5u
X188 SEL_MEAS.t3 VMEAS.t0 ramp_generator_0.ramp_generator_input_select_0.v_cmp.t0 VSS.t93 sg13_lv_nmos ad=0.19p pd=1.38u as=0.19p ps=1.38u w=1u l=0.13u
X189 VDD.t205 VDD.t204 VDD.t205 VDD.t88 sg13_lv_pmos ad=0.475p pd=2.88u as=0 ps=0 w=2.5u l=2u
X190 SEL_MEAS.t9 VMEAS.t0 ramp_generator_0.ramp_generator_input_select_0.v_cmp.t4 VSS.t92 sg13_lv_nmos ad=0.19p pd=1.38u as=0.19p ps=1.38u w=1u l=0.13u
X191 ramp_generator_0.ramp_generator_input_select_0.v_cmp.t12 SEL_CAL.t0 VCAL.t5 VSS.t119 sg13_lv_nmos ad=0.19p pd=1.38u as=0.19p ps=1.38u w=1u l=0.13u
X192 ota_lv_gmid_comparator_0.ota_slow_gmid_mirror_0.vout1.t3 ota_lv_gmid_comparator_0.ota_slow_gmid_ctrl_buff_1.y.t3 VDD.t104 VDD.t28 sg13_lv_pmos ad=0.27075p pd=1.805u as=0.27075p ps=1.805u w=1.425u l=0.13u
X193 VDD.t141 RAMP_EN.t0 ramp_generator_0.ramp_generator_nmos_mirror_0.pmos_ref.t2 VDD.t122 sg13_lv_pmos ad=0.19p pd=1.38u as=0.19p ps=1.38u w=1u l=0.13u
X194 ramp_generator_0.ramp_generator_nmos_mirror_0.pmos_ref.t12 RAMP_EN.t0 VDD.t140 VDD.t139 sg13_lv_pmos ad=0.19p pd=1.38u as=0.19p ps=1.38u w=1u l=0.13u
X195 a_n586_691.t2 ota_lv_gmid_comparator_0.ota_slow_gmid_mirror_0.vout1.t15 VDD.t20 VDD.t19 sg13_lv_pmos ad=95f pd=0.88u as=0.2p ps=1.8u w=0.5u l=0.5u
X196 VSS.t144 RAMP_RESET.t1 VRAMP.t4 VSS.t143 sg13_lv_nmos ad=0.627p pd=3.68u as=0.627p ps=3.68u w=3.3u l=0.13u
X197 VRAMP.t7 RAMP_RESET.t1 VSS.t142 VSS.t141 sg13_lv_nmos ad=1.122p pd=7.28u as=0.627p ps=3.68u w=3.3u l=0.13u
X198 ramp_generator_0.ramp_generator_nmos_mirror_0.pmos_ref.t21 RAMP_REF.t3 VSS.t68 VSS.t109 sg13_lv_nmos ad=0.102p pd=1.28u as=57f ps=0.68u w=0.3u l=10u
X199 VDD.t78 ota_lv_gmid_comparator_0.ota_slow_gmid_ctrl_buff_0.x.t6 a_n786_n1161.t2 VSS.t76 sg13_lv_nmos ad=0.10085p pd=1.34u as=55.85f ps=0.74u w=0.155u l=0.5u
X200 ramp_generator_0.ramp_generator_nmos_mirror_0.pmos_ref.t11 RAMP_EN.t0 VDD.t119 VDD.t138 sg13_lv_pmos ad=0.19p pd=1.38u as=0.19p ps=1.38u w=1u l=0.13u
X201 ramp_generator_0.ramp_generator_nmos_mirror_0.pmos_ref.t34 ramp_generator_0.ramp_generator_nmos_mirror_0.pmos_ref.t22 VDD.t51 VDD.t10 sg13_lv_pmos ad=0.1005p pd=1.34u as=0.1005p ps=1.34u w=0.15u l=10u
X202 VRAMP.t2 ramp_generator_0.ramp_generator_nmos_mirror_0.pmos_ref.t22 VDD.t50 VDD.t40 sg13_lv_pmos ad=0.1005p pd=1.34u as=0.1005p ps=1.34u w=0.15u l=10u
X203 VDD.t237 a_n7165_1131# VDD.t236 VDD.t7 sg13_lv_pmos ad=0.1005p pd=1.34u as=0 ps=0 w=0.15u l=5u
X204 a_n786_n1161.t1 ota_lv_gmid_comparator_0.ota_slow_gmid_ctrl_buff_0.x.t6 VDD.t76 VSS.t75 sg13_lv_nmos ad=55.85f pd=0.74u as=55.85f ps=0.74u w=0.155u l=0.5u
X205 ota_lv_gmid_comparator_0.ota_slow_gmid_mirror_0.vout1.t9 VBIAS.t8 VDD.t14 VDD.t1 sg13_lv_pmos ad=0.34p pd=2.68u as=0.19p ps=1.38u w=1u l=0.5u
X206 ramp_generator_0.ramp_generator_nmos_mirror_0.pmos_ref.t33 ramp_generator_0.ramp_generator_nmos_mirror_0.pmos_ref.t22 VDD.t49 VDD.t40 sg13_lv_pmos ad=0.1005p pd=1.34u as=0.1005p ps=1.34u w=0.15u l=10u
X207 VDD.t191 a_n7165_1499# VDD.t190 VDD.t7 sg13_lv_pmos ad=0.1005p pd=1.34u as=0 ps=0 w=0.15u l=5u
X208 ramp_generator_0.ramp_generator_nmos_mirror_0.pmos_ref.t32 ramp_generator_0.ramp_generator_nmos_mirror_0.pmos_ref.t22 VDD.t48 VDD.t10 sg13_lv_pmos ad=0.1005p pd=1.34u as=0.1005p ps=1.34u w=0.15u l=10u
X209 VSS.t140 RAMP_RESET.t0 VRAMP.t6 VSS.t139 sg13_lv_nmos ad=0.627p pd=3.68u as=1.122p ps=7.28u w=3.3u l=0.13u
X210 ota_lv_gmid_comparator_0.ota_slow_gmid_mirror_0.vout1.t1 ota_lv_gmid_comparator_0.ota_slow_gmid_ctrl_buff_1.y.t3 VDD.t109 VDD.t28 sg13_lv_pmos ad=0.27075p pd=1.805u as=0.4845p ps=3.53u w=1.425u l=0.13u
X211 VDD.t107 ota_lv_gmid_comparator_0.ota_slow_gmid_ctrl_buff_1.y.t3 ota_lv_gmid_comparator_0.ota_slow_gmid_mirror_0.vout1.t3 VDD.t28 sg13_lv_pmos ad=0.27075p pd=1.805u as=0.27075p ps=1.805u w=1.425u l=0.13u
X212 ramp_generator_0.ramp_generator_nmos_mirror_0.pmos_ref.t31 ramp_generator_0.ramp_generator_nmos_mirror_0.pmos_ref.t22 VDD.t47 VDD.t40 sg13_lv_pmos ad=0.1005p pd=1.34u as=0.1005p ps=1.34u w=0.15u l=10u
X213 VDD.t189 a_n7165_1867# VDD.t188 VDD.t7 sg13_lv_pmos ad=0.1005p pd=1.34u as=0 ps=0 w=0.15u l=5u
X214 ota_lv_gmid_comparator_0.ota_slow_gmid_mirror_0.vout1.t2 ota_lv_gmid_comparator_0.ota_slow_gmid_ctrl_buff_1.y.t3 VDD.t107 VDD.t28 sg13_lv_pmos ad=0.4845p pd=3.53u as=0.27075p ps=1.805u w=1.425u l=0.13u
X215 VDD.t185 a_1595_3318# VDD.t184 VDD.t183 sg13_lv_pmos ad=1.02p pd=6.68u as=0 ps=0 w=3u l=3u
X216 ramp_generator_0.ramp_generator_nmos_mirror_0.pmos_ref.t10 RAMP_EN.t0 VDD.t137 VDD.t136 sg13_lv_pmos ad=0.19p pd=1.38u as=0.19p ps=1.38u w=1u l=0.13u
X217 VDD.t135 RAMP_EN.t0 ramp_generator_0.ramp_generator_nmos_mirror_0.pmos_ref.t9 VDD.t40 sg13_lv_pmos ad=0.19p pd=1.38u as=0.19p ps=1.38u w=1u l=0.13u
X218 VRAMP.t5 RAMP_RESET.t0 VSS.t138 VSS.t137 sg13_lv_nmos ad=1.122p pd=7.28u as=0.627p ps=3.68u w=3.3u l=0.13u
X219 VDD.t105 ota_lv_gmid_comparator_0.ota_slow_gmid_ctrl_buff_1.y.t3 ota_lv_gmid_comparator_0.ota_slow_gmid_mirror_0.vout1.t1 VDD.t28 sg13_lv_pmos ad=0.27075p pd=1.805u as=0.27075p ps=1.805u w=1.425u l=0.13u
X220 ota_lv_gmid_comparator_0.ota_slow_gmid_ctrl_buff_0.x.t0 ota_lv_gmid_comparator_0.ota_slow_gmid_mirror_0.vout1.t14 a_n786_n1161.t10 VSS.t56 sg13_lv_nmos ad=0.68p pd=4.68u as=0.38p ps=2.38u w=2u l=0.13u
X221 VSS.t0 ota_lv_gmid_comparator_0.ota_slow_gmid_ctrl_buff_0.x.t8 a_n586_691.t2 VDD.t2 sg13_lv_pmos ad=95f pd=0.88u as=95f ps=0.88u w=0.5u l=1u
X222 VDD.t134 RAMP_EN.t0 ramp_generator_0.ramp_generator_nmos_mirror_0.pmos_ref.t8 VDD.t133 sg13_lv_pmos ad=0.19p pd=1.38u as=0.19p ps=1.38u w=1u l=0.13u
X223 VSS.t34 VSS.t12 VSS.t33 VSS.t13 sg13_lv_nmos ad=0.17p pd=1.68u as=0 ps=0 w=0.5u l=2u
X224 VSS.t31 VSS.t8 VSS.t30 VSS.t9 sg13_lv_nmos ad=0.17p pd=1.68u as=0 ps=0 w=0.5u l=2u
X225 SEL_MEAS.t0 VMEAS.t0 ramp_generator_0.ramp_generator_input_select_0.v_cmp.t3 VSS.t91 sg13_lv_nmos ad=0.19p pd=1.38u as=0.19p ps=1.38u w=1u l=0.13u
X226 CMP_OUTPUT.t1 ota_lv_gmid_comparator_0.ota_slow_gmid_ctrl_buff_0.ota_slow_gmid_ctrl_inv_0.x.t2 VDD.t232 VDD.t28 sg13_lv_pmos ad=0.68p pd=4.68u as=0.68p ps=4.68u w=2u l=0.13u
X227 ramp_generator_0.ramp_generator_input_select_0.v_cmp.t15 SEL_CAL.t0 VCAL.t4 VSS.t118 sg13_lv_nmos ad=0.19p pd=1.38u as=0.19p ps=1.38u w=1u l=0.13u
X228 VDD.t203 VDD.t192 VDD.t202 VDD.t1 sg13_lv_pmos ad=0.34p pd=2.68u as=0 ps=0 w=1u l=0.5u
X229 ramp_generator_0.ramp_generator_input_select_0.v_cmp.t19 SEL_CAL.t0 VCAL.t2 VSS.t117 sg13_lv_nmos ad=0.19p pd=1.38u as=0.19p ps=1.38u w=1u l=0.13u
X230 VSS.t28 VSS.t12 VSS.t27 VSS.t13 sg13_lv_nmos ad=0.17p pd=1.68u as=0 ps=0 w=0.5u l=2u
X231 VSS.t25 VSS.t8 VSS.t24 VSS.t9 sg13_lv_nmos ad=0.17p pd=1.68u as=0 ps=0 w=0.5u l=2u
X232 ota_lv_gmid_comparator_0.ota_slow_gmid_mirror_0.vout1.t0 ota_lv_gmid_comparator_0.ota_slow_gmid_ctrl_buff_1.y.t3 VDD.t105 VDD.t28 sg13_lv_pmos ad=0.27075p pd=1.805u as=0.27075p ps=1.805u w=1.425u l=0.13u
X233 VDD.t45 ramp_generator_0.ramp_generator_nmos_mirror_0.pmos_ref.t22 ramp_generator_0.ramp_generator_nmos_mirror_0.pmos_ref.t30 VDD.t42 sg13_lv_pmos ad=0.1005p pd=1.34u as=0.1005p ps=1.34u w=0.15u l=10u
X234 a_n786_n1161.t6 ota_lv_gmid_comparator_0.ota_slow_gmid_mirror_0.vout1.t16 VSS.t108 VSS.t82 sg13_lv_nmos ad=55.85f pd=0.74u as=0.10085p ps=1.34u w=0.155u l=0.5u
X235 ramp_generator_0.ramp_generator_nmos_mirror_0.pmos_ref.t7 RAMP_EN.t0 VDD.t132 VDD.t131 sg13_lv_pmos ad=0.19p pd=1.38u as=0.19p ps=1.38u w=1u l=0.13u
X236 VDD.t130 RAMP_EN.t0 ramp_generator_0.ramp_generator_nmos_mirror_0.pmos_ref.t6 VDD.t129 sg13_lv_pmos ad=0.19p pd=1.38u as=0.19p ps=1.38u w=1u l=0.13u
X237 VDD.t182 a_n7165_579# VDD.t181 VDD.t7 sg13_lv_pmos ad=0.1005p pd=1.34u as=0 ps=0 w=0.15u l=5u
X238 a_n586_691.t1 ota_lv_gmid_comparator_0.ota_slow_gmid_ctrl_buff_0.x.t8 VSS.t0 VDD.t1 sg13_lv_pmos ad=95f pd=0.88u as=95f ps=0.88u w=0.5u l=1u
X239 ota_lv_gmid_comparator_0.ota_slow_gmid_ctrl_buff_1.ota_slow_gmid_ctrl_inv_0.x.t0 RAMP_EN.t1 VSS.t87 VSS.t86 sg13_lv_nmos ad=0.68p pd=4.68u as=0.68p ps=4.68u w=2u l=0.13u
X240 VDD.t13 VBIAS.t8 ota_lv_gmid_comparator_0.ota_slow_gmid_mirror_0.vout1.t8 VDD.t1 sg13_lv_pmos ad=0.19p pd=1.38u as=0.34p ps=2.68u w=1u l=0.5u
X241 VSS.t22 VSS.t16 VSS.t21 VSS.t17 sg13_lv_nmos ad=0.102p pd=1.28u as=0 ps=0 w=0.3u l=10u
X242 ramp_generator_0.ramp_generator_input_select_0.v_cmp.t3 SEL_CAL.t0 VCAL.t3 VSS.t116 sg13_lv_nmos ad=0.19p pd=1.38u as=0.19p ps=1.38u w=1u l=0.13u
X243 VDD.t80 ota_lv_gmid_comparator_0.ota_slow_gmid_ctrl_buff_0.x.t6 a_n786_n1161.t0 VSS.t74 sg13_lv_nmos ad=55.85f pd=0.74u as=55.85f ps=0.74u w=0.155u l=0.5u
X244 ramp_generator_0.ramp_generator_input_select_0.v_cmp.t2 VMEAS.t0 SEL_MEAS.t1 VSS.t90 sg13_lv_nmos ad=0.19p pd=1.38u as=0.19p ps=1.38u w=1u l=0.13u
X245 VDD.t46 ramp_generator_0.ramp_generator_nmos_mirror_0.pmos_ref.t22 ramp_generator_0.ramp_generator_nmos_mirror_0.pmos_ref.t29 VDD.t42 sg13_lv_pmos ad=0.1005p pd=1.34u as=0.1005p ps=1.34u w=0.15u l=10u
X246 VDD.t235 a_n17365_579# VDD.t234 VDD.t10 sg13_lv_pmos ad=0.1005p pd=1.34u as=0 ps=0 w=0.15u l=5u
X247 ramp_generator_0.ramp_generator_input_select_0.v_cmp.t1 VMEAS.t0 SEL_MEAS.t7 VSS.t89 sg13_lv_nmos ad=0.19p pd=1.38u as=0.19p ps=1.38u w=1u l=0.13u
X248 VDD.t44 ramp_generator_0.ramp_generator_nmos_mirror_0.pmos_ref.t22 ramp_generator_0.ramp_generator_nmos_mirror_0.pmos_ref.t28 VDD.t42 sg13_lv_pmos ad=0.1005p pd=1.34u as=0.1005p ps=1.34u w=0.15u l=10u
X249 a_n586_691.t0 ota_lv_gmid_comparator_0.ota_slow_gmid_ctrl_buff_0.x.t8 VSS.t1 VDD.t0 sg13_lv_pmos ad=95f pd=0.88u as=95f ps=0.88u w=0.5u l=1u
X250 VCAL.t2 SEL_CAL.t0 ramp_generator_0.ramp_generator_input_select_0.v_cmp.t18 VSS.t115 sg13_lv_nmos ad=0.19p pd=1.38u as=0.19p ps=1.38u w=1u l=0.13u
X251 VDD.t104 ota_lv_gmid_comparator_0.ota_slow_gmid_ctrl_buff_1.y.t3 ota_lv_gmid_comparator_0.ota_slow_gmid_mirror_0.vout1.t0 VDD.t28 sg13_lv_pmos ad=0.27075p pd=1.805u as=0.27075p ps=1.805u w=1.425u l=0.13u
X252 VDD.t128 RAMP_EN.t0 ramp_generator_0.ramp_generator_nmos_mirror_0.pmos_ref.t5 VDD.t42 sg13_lv_pmos ad=0.19p pd=1.38u as=0.19p ps=1.38u w=1u l=0.13u
X253 VDD.t43 ramp_generator_0.ramp_generator_nmos_mirror_0.pmos_ref.t22 ramp_generator_0.ramp_generator_nmos_mirror_0.pmos_ref.t27 VDD.t42 sg13_lv_pmos ad=0.1005p pd=1.34u as=0.1005p ps=1.34u w=0.15u l=10u
X254 a_n586_691.t3 ota_lv_gmid_comparator_0.ota_slow_gmid_mirror_0.vout1.t14 ota_lv_gmid_comparator_0.ota_slow_gmid_ctrl_buff_0.x.t3 VDD.t1 sg13_lv_pmos ad=0.2375p pd=1.63u as=0.2375p ps=1.63u w=1.25u l=0.13u
X255 ota_lv_gmid_comparator_0.ota_slow_gmid_ctrl_buff_0.x.t4 ota_lv_gmid_comparator_0.ota_slow_gmid_mirror_0.vout1.t14 a_n586_691.t3 VDD.t1 sg13_lv_pmos ad=0.2375p pd=1.63u as=0.2375p ps=1.63u w=1.25u l=0.13u
X256 VCAL.t1 SEL_CAL.t0 ramp_generator_0.ramp_generator_input_select_0.v_cmp.t13 VSS.t114 sg13_lv_nmos ad=0.19p pd=1.38u as=0.19p ps=1.38u w=1u l=0.13u
X257 VSS.t19 VSS.t16 VSS.t18 VSS.t17 sg13_lv_nmos ad=0.102p pd=1.28u as=0 ps=0 w=0.3u l=10u
X258 VDD.t200 VDD.t198 VDD.t199 VDD.t1 sg13_lv_pmos ad=0.34p pd=2.68u as=0 ps=0 w=1u l=0.5u
X259 VDD.t127 RAMP_EN.t0 ramp_generator_0.ramp_generator_nmos_mirror_0.pmos_ref.t4 VDD.t126 sg13_lv_pmos ad=0.19p pd=1.38u as=0.19p ps=1.38u w=1u l=0.13u
X260 VDD.t180 a_2150_2812.t1 VSS.t134 rhigh l=2.5u w=0.5u
X261 ramp_generator_0.ramp_generator_nmos_mirror_0.pmos_ref.t3 RAMP_EN.t0 VDD.t125 VDD.t124 sg13_lv_pmos ad=0.19p pd=1.38u as=0.19p ps=1.38u w=1u l=0.13u
X262 VDD.t197 VDD.t195 VDD.t196 VDD.t28 sg13_lv_pmos ad=0.85p pd=5.68u as=0 ps=0 w=2.5u l=2u
X263 VSS.t68 RAMP_REF.t0 RAMP_REF.t1 VSS.t67 sg13_lv_nmos ad=57f pd=0.68u as=0.102p ps=1.28u w=0.3u l=10u
X264 a_n786_n1161.t0 ota_lv_gmid_comparator_0.ota_slow_gmid_ctrl_buff_0.x.t6 VDD.t79 VSS.t73 sg13_lv_nmos ad=55.85f pd=0.74u as=55.85f ps=0.74u w=0.155u l=0.5u
X265 VDD.t179 a_2150_2812.t0 VSS.t133 rhigh l=2.5u w=0.5u
X266 VDD.t92 ota_lv_gmid_comparator_0.ota_slow_gmid_ctrl_buff_1.y.t2 VBIAS.t6 VDD.t88 sg13_lv_pmos ad=0.27075p pd=1.805u as=0.27075p ps=1.805u w=1.425u l=0.13u
X267 ramp_generator_0.ramp_generator_nmos_mirror_0.pmos_ref.t26 ramp_generator_0.ramp_generator_nmos_mirror_0.pmos_ref.t22 VDD.t41 VDD.t40 sg13_lv_pmos ad=0.1005p pd=1.34u as=0.1005p ps=1.34u w=0.15u l=10u
X268 VSS.t15 VSS.t12 VSS.t14 VSS.t13 sg13_lv_nmos ad=0.17p pd=1.68u as=0 ps=0 w=0.5u l=2u
X269 ramp_generator_0.ramp_generator_nmos_mirror_0.pmos_ref.t2 RAMP_EN.t0 VDD.t123 VDD.t122 sg13_lv_pmos ad=0.19p pd=1.38u as=0.34p ps=2.68u w=1u l=0.13u
X270 VSS.t11 VSS.t8 VSS.t10 VSS.t9 sg13_lv_nmos ad=0.17p pd=1.68u as=0 ps=0 w=0.5u l=2u
X271 VRAMP.t4 RAMP_RESET.t1 VSS.t136 VSS.t135 sg13_lv_nmos ad=0.627p pd=3.68u as=0.627p ps=3.68u w=3.3u l=0.13u
X272 VSS.t7 VSS.t4 VSS.t6 VSS.t5 sg13_lv_nmos ad=0.102p pd=1.28u as=0 ps=0 w=0.3u l=10u
X273 VDD.t194 VDD.t192 VDD.t193 VDD.t1 sg13_lv_pmos ad=0.34p pd=2.68u as=0 ps=0 w=1u l=0.5u
X274 VDD.t121 RAMP_EN.t0 ramp_generator_0.ramp_generator_nmos_mirror_0.pmos_ref.t1 VDD.t120 sg13_lv_pmos ad=0.19p pd=1.38u as=0.19p ps=1.38u w=1u l=0.13u
X275 VDD.t119 RAMP_EN.t0 ramp_generator_0.ramp_generator_nmos_mirror_0.pmos_ref.t0 VDD.t118 sg13_lv_pmos ad=0.19p pd=1.38u as=0.19p ps=1.38u w=1u l=0.13u
X276 VDD.t178 a_n17365_1315# VDD.t177 VDD.t10 sg13_lv_pmos ad=0.1005p pd=1.34u as=0 ps=0 w=0.15u l=5u
X277 ramp_generator_0.ramp_generator_nmos_mirror_0.pmos_ref.t25 ramp_generator_0.ramp_generator_nmos_mirror_0.pmos_ref.t22 VDD.t39 VDD.t10 sg13_lv_pmos ad=0.1005p pd=1.34u as=0.1005p ps=1.34u w=0.15u l=10u
X278 VDD.t38 ramp_generator_0.ramp_generator_nmos_mirror_0.pmos_ref.t22 ramp_generator_0.ramp_generator_nmos_mirror_0.pmos_ref.t24 VDD.t7 sg13_lv_pmos ad=0.1005p pd=1.34u as=0.1005p ps=1.34u w=0.15u l=10u
X279 VDD.t37 ramp_generator_0.ramp_generator_nmos_mirror_0.pmos_ref.t22 ramp_generator_0.ramp_generator_nmos_mirror_0.pmos_ref.t23 VDD.t7 sg13_lv_pmos ad=0.1005p pd=1.34u as=0.1005p ps=1.34u w=0.15u l=10u
X280 ramp_generator_0.ramp_generator_input_select_0.v_cmp.t11 SEL_CAL.t0 VCAL.t0 VSS.t113 sg13_lv_nmos ad=0.19p pd=1.38u as=0.19p ps=1.38u w=1u l=0.13u
X281 VBIAS.t6 ota_lv_gmid_comparator_0.ota_slow_gmid_ctrl_buff_1.y.t2 VDD.t91 VDD.t88 sg13_lv_pmos ad=0.27075p pd=1.805u as=0.27075p ps=1.805u w=1.425u l=0.13u
X282 VDD.t90 ota_lv_gmid_comparator_0.ota_slow_gmid_ctrl_buff_1.y.t2 VBIAS.t5 VDD.t88 sg13_lv_pmos ad=0.4845p pd=3.53u as=0.27075p ps=1.805u w=1.425u l=0.13u
X283 ramp_generator_0.ramp_generator_input_select_0.v_cmp.t0 VMEAS.t0 SEL_MEAS.t6 VSS.t88 sg13_lv_nmos ad=0.19p pd=1.38u as=0.19p ps=1.38u w=1u l=0.13u
C0 ota_lv_gmid_comparator_0.ota_slow_gmid_mirror_0.vota ota_lv_gmid_comparator_0.ota_slow_gmid_ctrl_buff_0.x 0.04676f
C1 ota_lv_gmid_comparator_0.ota_slow_gmid_ctrl_buff_0.x ramp_generator_0.ramp_generator_input_select_0.v_cmp 0.02079f
C2 ota_lv_gmid_comparator_0.ota_slow_gmid_ctrl_buff_0.x ota_lv_gmid_comparator_0.ota_slow_gmid_ctrl_buff_0.ota_slow_gmid_ctrl_inv_0.x 0.06925f
C3 ota_lv_gmid_comparator_0.ota_slow_gmid_mirror_0.vout1 a_1595_3318# 0.10845f
C4 VDD a_1251_3470# 0.12401f
C5 VRAMP ramp_generator_0.ramp_generator_nmos_mirror_0.pmos_ref 5.66879f
C6 VDD a_1650_2812# 0.19516f
C7 VBIAS ota_lv_gmid_comparator_0.ota_slow_gmid_ctrl_buff_1.y 0.44744f
C8 VDD a_971_3470# 0.13092f
C9 VDD CMP_OUTPUT 0.38093f
C10 RAMP_EN ota_lv_gmid_comparator_0.ota_slow_gmid_mirror_0.vota 0.06945f
C11 VDD a_n17365_763# 0.7207f
C12 VRAMP SEL_MEAS 0.61381f
C13 RAMP_EN ramp_generator_0.ramp_generator_input_select_0.v_cmp 1.39477f
C14 VDD RAMP_REF 0.89081f
C15 VBIAS ota_lv_gmid_comparator_0.ota_slow_gmid_common_0/ota_slow_gmid_tail_0.ibiasn 0.0909f
C16 a_1595_3318# a_1650_3092# 0.04855f
C17 VRAMP RAMP_RESET 1.71281f
C18 RAMP_EN ota_lv_gmid_comparator_0.ota_slow_gmid_ctrl_buff_1.ota_slow_gmid_ctrl_inv_0.x 0.06339f
C19 a_n17365_947# a_n17365_763# 0.15028f
C20 VDD a_n17365_1499# 0.7207f
C21 a_n7165_1683# a_n7165_1499# 0.15028f
C22 SEL_MEAS ramp_generator_0.ramp_generator_input_select_0.v_cmp 3.11428f
C23 SEL_CAL SEL_MEAS 0.01048f
C24 RAMP_REF VMEAS 0.04892f
C25 ota_lv_gmid_comparator_0.ota_slow_gmid_ctrl_buff_1.y ota_lv_gmid_comparator_0.ota_slow_gmid_ctrl_buff_0.x 0.0786f
C26 VDD a_n17365_947# 0.7207f
C27 ota_lv_gmid_comparator_0.ota_slow_gmid_mirror_0.vout1 ota_lv_gmid_comparator_0.ota_slow_gmid_common_0/ota_slow_gmid_pairs_0.tail 0.09425f
C28 VRAMP ota_lv_gmid_comparator_0.ota_slow_gmid_common_0/ota_slow_gmid_pairs_0.tail 0.22789f
C29 RAMP_RESET ramp_generator_0.ramp_generator_input_select_0.v_cmp 2.45251f
C30 RAMP_RESET SEL_CAL 0.57567f
C31 VDD VBIAS 6.03062f
C32 VRAMP ota_lv_gmid_comparator_0.ota_slow_gmid_mirror_0.vout1 0.07138f
C33 VDD a_n1072_3470# 0.14322f
C34 a_n7165_1131# a_n7165_947# 0.15028f
C35 VDD a_n17365_1683# 0.7207f
C36 ota_lv_gmid_comparator_0.ota_slow_gmid_mirror_0.vota ota_lv_gmid_comparator_0.ota_slow_gmid_common_0/ota_slow_gmid_pairs_0.tail 0.07368f
C37 VDD a_n2196_3318# 1.59204f
C38 a_n17365_1683# a_n17365_1499# 0.15028f
C39 ota_lv_gmid_comparator_0.ota_slow_gmid_common_0/ota_slow_gmid_pairs_0.tail ramp_generator_0.ramp_generator_input_select_0.v_cmp 0.2743f
C40 VDD a_n2151_3092# 0.04843f
C41 RAMP_RESET a_n17365_579# 0.01076f
C42 VDD a_n17365_1131# 0.7207f
C43 ota_lv_gmid_comparator_0.ota_slow_gmid_mirror_0.vota ota_lv_gmid_comparator_0.ota_slow_gmid_mirror_0.vout1 4.01324f
C44 VRAMP ota_lv_gmid_comparator_0.ota_slow_gmid_mirror_0.vota 1.10093f
C45 VDD a_n7165_579# 0.83068f
C46 VDD ota_lv_gmid_comparator_0.ota_slow_gmid_ctrl_buff_0.x 2.94511f
C47 VRAMP ramp_generator_0.ramp_generator_input_select_0.v_cmp 6.51379f
C48 a_n7165_1315# a_n7165_1499# 0.15028f
C49 ota_lv_gmid_comparator_0.ota_slow_gmid_ctrl_buff_0.ota_slow_gmid_ctrl_inv_0.x ota_lv_gmid_comparator_0.ota_slow_gmid_mirror_0.vout1 0.02822f
C50 VRAMP SEL_CAL 0.33766f
C51 VBIAS a_n1072_3470# 0.01744f
C52 ota_lv_gmid_comparator_0.ota_slow_gmid_mirror_0.vref ota_lv_gmid_comparator_0.ota_slow_gmid_common_0/ota_slow_gmid_pairs_0.tail 0.04038f
C53 VBIAS a_n2196_3318# 0.11249f
C54 VDD RAMP_EN 5.614f
C55 a_n17365_1131# a_n17365_947# 0.15028f
C56 VRAMP a_n7165_1867# 0.01028f
C57 VDD a_n17365_1867# 0.83068f
C58 RAMP_REF ramp_generator_0.ramp_generator_nmos_mirror_0.pmos_ref 3.2109f
C59 ota_lv_gmid_comparator_0.ota_slow_gmid_mirror_0.vref ota_lv_gmid_comparator_0.ota_slow_gmid_mirror_0.vout1 5.20161f
C60 VRAMP ota_lv_gmid_comparator_0.ota_slow_gmid_mirror_0.vref 0.62886f
C61 a_n7165_1867# a_n7165_1683# 0.15028f
C62 ota_lv_gmid_comparator_0.ota_slow_gmid_mirror_0.vota ramp_generator_0.ramp_generator_input_select_0.v_cmp 0.54935f
C63 VCAL SEL_MEAS 4.24985f
C64 SEL_CAL ramp_generator_0.ramp_generator_input_select_0.v_cmp 0.2789f
C65 VDD a_1595_3318# 1.6017f
C66 VDD ramp_generator_0.ramp_generator_nmos_mirror_0.pmos_ref 47.0723f
C67 VDD a_n17365_1315# 0.7207f
C68 ota_lv_gmid_comparator_0.ota_slow_gmid_mirror_0.vota ota_lv_gmid_comparator_0.ota_slow_gmid_ctrl_buff_1.ota_slow_gmid_ctrl_inv_0.x 0.01623f
C69 VDD a_n7165_763# 0.7207f
C70 a_n2196_3318# a_n2151_3092# 0.04856f
C71 RAMP_RESET VCAL 0.0371f
C72 ota_lv_gmid_comparator_0.ota_slow_gmid_common_0/ota_slow_gmid_tail_0.ibiasn ota_lv_gmid_comparator_0.ota_slow_gmid_common_0/ota_slow_gmid_pairs_0.tail 0.40234f
C73 a_n17365_1315# a_n17365_1499# 0.15028f
C74 RAMP_RESET RAMP_REF 0.7942f
C75 VBIAS RAMP_EN 3.23947f
C76 ota_lv_gmid_comparator_0.ota_slow_gmid_ctrl_buff_1.y ota_lv_gmid_comparator_0.ota_slow_gmid_mirror_0.vout1 0.8386f
C77 VRAMP ota_lv_gmid_comparator_0.ota_slow_gmid_ctrl_buff_1.y 0.0119f
C78 ota_lv_gmid_comparator_0.ota_slow_gmid_mirror_0.vota ota_lv_gmid_comparator_0.ota_slow_gmid_mirror_0.vref 4.5582f
C79 ota_lv_gmid_comparator_0.ota_slow_gmid_mirror_0.vref ramp_generator_0.ramp_generator_input_select_0.v_cmp 0.12811f
C80 VDD RAMP_RESET 0.04118f
C81 ota_lv_gmid_comparator_0.ota_slow_gmid_mirror_0.vout1 ota_lv_gmid_comparator_0.ota_slow_gmid_common_0/ota_slow_gmid_tail_0.ibiasn 0.42214f
C82 a_n7165_1315# a_n7165_1131# 0.15028f
C83 VDD a_n7165_1499# 0.7207f
C84 a_n17365_1867# a_n17365_1683# 0.15028f
C85 VMEAS SEL_MEAS 5.78571f
C86 ota_lv_gmid_comparator_0.ota_slow_gmid_mirror_0.vota ota_lv_gmid_comparator_0.ota_slow_gmid_ctrl_buff_1.y 0.08907f
C87 ota_lv_gmid_comparator_0.ota_slow_gmid_mirror_0.vout1 a_1251_3470# 0.01576f
C88 VDD a_n2151_2812# 0.1949f
C89 ota_lv_gmid_comparator_0.ota_slow_gmid_mirror_0.vout1 a_971_3470# 0.01584f
C90 CMP_OUTPUT ota_lv_gmid_comparator_0.ota_slow_gmid_mirror_0.vout1 0.12768f
C91 VDD a_n7165_947# 0.7207f
C92 VDD ota_lv_gmid_comparator_0.ota_slow_gmid_common_0/ota_slow_gmid_pairs_0.tail 0.57426f
C93 VRAMP VCAL 0.4594f
C94 VRAMP RAMP_REF 2.2057f
C95 ota_lv_gmid_comparator_0.ota_slow_gmid_ctrl_buff_1.y ota_lv_gmid_comparator_0.ota_slow_gmid_ctrl_buff_1.ota_slow_gmid_ctrl_inv_0.x 0.06653f
C96 a_1650_3092# a_1650_2812# 0.0333f
C97 ota_lv_gmid_comparator_0.ota_slow_gmid_mirror_0.vref ota_lv_gmid_comparator_0.ota_slow_gmid_ctrl_buff_1.y 0.71076f
C98 VDD ota_lv_gmid_comparator_0.ota_slow_gmid_mirror_0.vout1 5.08394f
C99 VDD VRAMP 9.76027f
C100 a_n17365_1315# a_n17365_1131# 0.15028f
C101 VDD a_n7165_1683# 0.7207f
C102 a_n7165_763# a_n7165_579# 0.15028f
C103 CMP_OUTPUT ota_lv_gmid_comparator_0.ota_slow_gmid_ctrl_buff_0.ota_slow_gmid_ctrl_inv_0.x 0.0681f
C104 VBIAS ota_lv_gmid_comparator_0.ota_slow_gmid_common_0/ota_slow_gmid_pairs_0.tail 0.24683f
C105 VCAL ramp_generator_0.ramp_generator_input_select_0.v_cmp 3.01668f
C106 SEL_CAL VCAL 3.95666f
C107 RAMP_REF ramp_generator_0.ramp_generator_input_select_0.v_cmp 0.0249f
C108 RAMP_REF SEL_CAL 0.04394f
C109 RAMP_EN ramp_generator_0.ramp_generator_nmos_mirror_0.pmos_ref 1.4547f
C110 VDD a_1650_3092# 0.04863f
C111 RAMP_RESET a_n7165_579# 0.01076f
C112 VDD a_n7165_1131# 0.7207f
C113 VDD ota_lv_gmid_comparator_0.ota_slow_gmid_mirror_0.vota 3.35592f
C114 VRAMP VMEAS 0.96532f
C115 VBIAS ota_lv_gmid_comparator_0.ota_slow_gmid_mirror_0.vout1 0.22861f
C116 VDD ramp_generator_0.ramp_generator_input_select_0.v_cmp 4.0273f
C117 CMP_OUTPUT ota_lv_gmid_comparator_0.ota_slow_gmid_mirror_0.vref 0.09892f
C118 VDD ota_lv_gmid_comparator_0.ota_slow_gmid_ctrl_buff_0.ota_slow_gmid_ctrl_inv_0.x 0.57045f
C119 VBIAS VRAMP 1.63985f
C120 a_n2151_3092# a_n2151_2812# 0.0333f
C121 VDD a_n1352_3470# 0.1236f
C122 VDD ota_lv_gmid_comparator_0.ota_slow_gmid_ctrl_buff_1.ota_slow_gmid_ctrl_inv_0.x 0.57146f
C123 VDD a_n7165_1867# 0.83068f
C124 a_n17365_763# a_n17365_579# 0.15028f
C125 VDD ota_lv_gmid_comparator_0.ota_slow_gmid_mirror_0.vref 2.31934f
C126 VBIAS ota_lv_gmid_comparator_0.ota_slow_gmid_mirror_0.vota 0.57297f
C127 VMEAS ramp_generator_0.ramp_generator_input_select_0.v_cmp 0.34887f
C128 SEL_CAL VMEAS 0.02116f
C129 VBIAS ramp_generator_0.ramp_generator_input_select_0.v_cmp 0.22742f
C130 RAMP_RESET ramp_generator_0.ramp_generator_nmos_mirror_0.pmos_ref 0.31259f
C131 VDD a_n7165_1315# 0.7207f
C132 VDD a_n17365_579# 0.83068f
C133 ota_lv_gmid_comparator_0.ota_slow_gmid_ctrl_buff_0.x ota_lv_gmid_comparator_0.ota_slow_gmid_mirror_0.vout1 0.45106f
C134 VRAMP ota_lv_gmid_comparator_0.ota_slow_gmid_ctrl_buff_0.x 0.01105f
C135 VBIAS a_n1352_3470# 0.0167f
C136 VDD ota_lv_gmid_comparator_0.ota_slow_gmid_ctrl_buff_1.y 4.692f
C137 a_971_3470# a_1251_3470# 0.03996f
C138 a_n1352_3470# a_n1072_3470# 0.03996f
C139 RAMP_EN VRAMP 3.05389f
C140 VDD ota_lv_gmid_comparator_0.ota_slow_gmid_common_0/ota_slow_gmid_tail_0.ibiasn 1.16222f
C141 VRAMP a_n17365_1867# 0.0101f
C142 a_n7165_947# a_n7165_763# 0.15028f
R0 VBIAS.n4 VBIAS 17.2012
R1 VBIAS.n0 VBIAS.t5 9.25218
R2 VBIAS.n1 VBIAS.t4 9.25218
R3 VBIAS.n2 VBIAS.t6 9.25218
R4 VBIAS.n3 VBIAS.t7 9.25218
R5 VBIAS.n0 VBIAS.t2 9.14586
R6 VBIAS.n1 VBIAS.t0 9.14586
R7 VBIAS.n2 VBIAS.t1 9.14586
R8 VBIAS.n3 VBIAS.t3 9.14586
R9 VBIAS VBIAS.t8 7.49552
R10 VBIAS.n4 VBIAS 4.0177
R11 VBIAS VBIAS.n4 0.5461
R12 VBIAS VBIAS.n3 0.532245
R13 VBIAS.n2 VBIAS.n1 0.382457
R14 VBIAS.n1 VBIAS.n0 0.380585
R15 VBIAS.n3 VBIAS.n2 0.380585
R16 ota_lv_gmid_comparator_0.ota_slow_gmid_common_0/ota_slow_gmid_pairs_0.tail.n3 ota_lv_gmid_comparator_0.ota_slow_gmid_common_0/ota_slow_gmid_pairs_0.tail.t0 7.71313
R17 ota_lv_gmid_comparator_0.ota_slow_gmid_common_0/ota_slow_gmid_pairs_0.tail.n3 ota_lv_gmid_comparator_0.ota_slow_gmid_common_0/ota_slow_gmid_pairs_0.tail.t1 5.6454
R18 ota_lv_gmid_comparator_0.ota_slow_gmid_common_0/ota_slow_gmid_pairs_0.tail.n4 ota_lv_gmid_comparator_0.ota_slow_gmid_common_0/ota_slow_gmid_pairs_0.tail.n3 5.31864
R19 ota_lv_gmid_comparator_0.ota_slow_gmid_common_0/ota_slow_gmid_pairs_0.tail.n0 ota_lv_gmid_comparator_0.ota_slow_gmid_common_0/ota_slow_gmid_pairs_0.tail.t2 4.21922
R20 ota_lv_gmid_comparator_0.ota_slow_gmid_common_0/ota_slow_gmid_pairs_0.tail ota_lv_gmid_comparator_0.ota_slow_gmid_common_0/ota_slow_gmid_pairs_0.tail.n0 3.42129
R21 ota_lv_gmid_comparator_0.ota_slow_gmid_common_0/ota_slow_gmid_pairs_0.tail.n0 ota_lv_gmid_comparator_0.ota_slow_gmid_common_0/ota_slow_gmid_pairs_0.tail.t3 2.31242
R22 ota_lv_gmid_comparator_0.ota_slow_gmid_common_0/ota_slow_gmid_pairs_0.tail.n2 ota_lv_gmid_comparator_0.ota_slow_gmid_common_0/ota_slow_gmid_pairs_0.tail.n1 0.3833
R23 ota_lv_gmid_comparator_0.ota_slow_gmid_common_0/ota_slow_gmid_pairs_0.tail.n2 ota_lv_gmid_comparator_0.ota_slow_gmid_common_0/ota_slow_gmid_pairs_0.tail 0.196667
R24 ota_lv_gmid_comparator_0.ota_slow_gmid_common_0/ota_slow_gmid_pairs_0.tail ota_lv_gmid_comparator_0.ota_slow_gmid_common_0/ota_slow_gmid_pairs_0.tail.n2 0.125167
R25 ota_lv_gmid_comparator_0.ota_slow_gmid_common_0/ota_slow_gmid_pairs_0.tail ota_lv_gmid_comparator_0.ota_slow_gmid_common_0/ota_slow_gmid_pairs_0.tail.n4 0.1061
R26 ota_lv_gmid_comparator_0.ota_slow_gmid_common_0/ota_slow_gmid_pairs_0.tail.n1 ota_lv_gmid_comparator_0.ota_slow_gmid_common_0/ota_slow_gmid_pairs_0.tail 0.0885
R27 ota_lv_gmid_comparator_0.ota_slow_gmid_common_0/ota_slow_gmid_pairs_0.tail.n1 ota_lv_gmid_comparator_0.ota_slow_gmid_common_0/ota_slow_gmid_pairs_0.tail 0.0511
R28 ota_lv_gmid_comparator_0.ota_slow_gmid_common_0/ota_slow_gmid_pairs_0.tail.n4 ota_lv_gmid_comparator_0.ota_slow_gmid_common_0/ota_slow_gmid_pairs_0.tail 0.0371667
R29 VDD.n563 VDD.n562 20.1019
R30 VDD.n553 VDD.t75 18.5233
R31 VDD.n559 VDD.t79 18.5199
R32 VDD.n464 VDD.t20 17.7293
R33 VDD.n266 VDD.t180 17.5141
R34 VDD.n575 VDD.t21 17.5129
R35 VDD.n556 VDD.t74 17.2308
R36 VDD.n555 VDD.t73 17.2308
R37 VDD.n554 VDD.t71 17.2308
R38 VDD.n553 VDD.t72 17.2308
R39 VDD.n559 VDD.t80 17.2274
R40 VDD.n560 VDD.t81 17.2274
R41 VDD.n561 VDD.t76 17.2274
R42 VDD.n113 VDD.t12 17.0005
R43 VDD.n113 VDD.t11 17.0005
R44 VDD.n113 VDD.t66 17.0005
R45 VDD.n115 VDD.t175 17.0005
R46 VDD.n115 VDD.t58 17.0005
R47 VDD.n115 VDD.t176 17.0005
R48 VDD.n117 VDD.t84 17.0005
R49 VDD.n117 VDD.t67 17.0005
R50 VDD.n117 VDD.t85 17.0005
R51 VDD.n119 VDD.t178 17.0005
R52 VDD.n119 VDD.t177 17.0005
R53 VDD.n119 VDD.t48 17.0005
R54 VDD.n121 VDD.t230 17.0005
R55 VDD.n121 VDD.t68 17.0005
R56 VDD.n121 VDD.t231 17.0005
R57 VDD.n123 VDD.t34 17.0005
R58 VDD.n123 VDD.t33 17.0005
R59 VDD.n123 VDD.t39 17.0005
R60 VDD.n125 VDD.t187 17.0005
R61 VDD.n125 VDD.t186 17.0005
R62 VDD.n125 VDD.t61 17.0005
R63 VDD.n181 VDD.t234 17.0005
R64 VDD.n181 VDD.t51 17.0005
R65 VDD.n181 VDD.t235 17.0005
R66 VDD.n183 VDD.t37 17.0005
R67 VDD.n183 VDD.t182 17.0005
R68 VDD.n183 VDD.t181 17.0005
R69 VDD.n185 VDD.t55 17.0005
R70 VDD.n185 VDD.t87 17.0005
R71 VDD.n185 VDD.t86 17.0005
R72 VDD.n187 VDD.t63 17.0005
R73 VDD.n187 VDD.t9 17.0005
R74 VDD.n187 VDD.t8 17.0005
R75 VDD.n189 VDD.t54 17.0005
R76 VDD.n189 VDD.t237 17.0005
R77 VDD.n189 VDD.t236 17.0005
R78 VDD.n191 VDD.t62 17.0005
R79 VDD.n191 VDD.t26 17.0005
R80 VDD.n191 VDD.t25 17.0005
R81 VDD.n193 VDD.t53 17.0005
R82 VDD.n193 VDD.t191 17.0005
R83 VDD.n193 VDD.t190 17.0005
R84 VDD.n195 VDD.t38 17.0005
R85 VDD.n195 VDD.t83 17.0005
R86 VDD.n195 VDD.t82 17.0005
R87 VDD.n196 VDD.t52 17.0005
R88 VDD.n196 VDD.t189 17.0005
R89 VDD.n196 VDD.t188 17.0005
R90 VDD.n100 VDD.t45 17.0005
R91 VDD.n100 VDD.t41 17.0005
R92 VDD.n101 VDD.t59 17.0005
R93 VDD.n101 VDD.t56 17.0005
R94 VDD.n102 VDD.t70 17.0005
R95 VDD.n102 VDD.t65 17.0005
R96 VDD.n103 VDD.t46 17.0005
R97 VDD.n103 VDD.t50 17.0005
R98 VDD.n104 VDD.t57 17.0005
R99 VDD.n104 VDD.t60 17.0005
R100 VDD.n105 VDD.t44 17.0005
R101 VDD.n105 VDD.t49 17.0005
R102 VDD.n106 VDD.t64 17.0005
R103 VDD.n106 VDD.t69 17.0005
R104 VDD.n107 VDD.t43 17.0005
R105 VDD.n107 VDD.t47 17.0005
R106 VDD.n200 VDD.n65 17.0005
R107 VDD.n200 VDD.n110 17.0005
R108 VDD.n200 VDD.n34 17.0005
R109 VDD.n1 VDD.n0 17.0005
R110 VDD.n557 VDD.t78 17.0005
R111 VDD.n558 VDD.t77 17.0005
R112 VDD.n387 VDD.t224 17.0005
R113 VDD.n383 VDD.t224 17.0005
R114 VDD.n382 VDD.t224 17.0005
R115 VDD.n388 VDD.t224 17.0005
R116 VDD.n381 VDD.t224 17.0005
R117 VDD.n389 VDD.t224 17.0005
R118 VDD.n385 VDD.t224 17.0005
R119 VDD.t205 VDD.n387 17.0005
R120 VDD.t205 VDD.n385 17.0005
R121 VDD.n387 VDD.n386 17.0005
R122 VDD.n386 VDD.n385 17.0005
R123 VDD.n360 VDD.t208 17.0005
R124 VDD.n356 VDD.t208 17.0005
R125 VDD.n355 VDD.t208 17.0005
R126 VDD.n361 VDD.t208 17.0005
R127 VDD.n354 VDD.t208 17.0005
R128 VDD.n362 VDD.t208 17.0005
R129 VDD.n358 VDD.t208 17.0005
R130 VDD.t207 VDD.n360 17.0005
R131 VDD.t207 VDD.n358 17.0005
R132 VDD.n360 VDD.n359 17.0005
R133 VDD.n359 VDD.n358 17.0005
R134 VDD.n521 VDD.n226 17.0005
R135 VDD.n532 VDD.n226 17.0005
R136 VDD.n565 VDD.n258 17.0005
R137 VDD.n565 VDD.n257 17.0005
R138 VDD.n565 VDD.n255 17.0005
R139 VDD.n565 VDD.n254 17.0005
R140 VDD.n565 VDD.n252 17.0005
R141 VDD.n565 VDD.n251 17.0005
R142 VDD.n565 VDD.t32 17.0005
R143 VDD.n565 VDD.n241 17.0005
R144 VDD.n565 VDD.n240 17.0005
R145 VDD.n565 VDD.n238 17.0005
R146 VDD.n565 VDD.n237 17.0005
R147 VDD.n565 VDD.n261 17.0005
R148 VDD.n449 VDD.n348 17.0005
R149 VDD.n449 VDD.n350 17.0005
R150 VDD.n449 VDD.n351 17.0005
R151 VDD.n449 VDD.n352 17.0005
R152 VDD.n449 VDD.n353 17.0005
R153 VDD.n449 VDD.n363 17.0005
R154 VDD.n449 VDD.n364 17.0005
R155 VDD.n449 VDD.n374 17.0005
R156 VDD.n449 VDD.n375 17.0005
R157 VDD.n449 VDD.n376 17.0005
R158 VDD.n449 VDD.n377 17.0005
R159 VDD.n449 VDD.n378 17.0005
R160 VDD.n449 VDD.n380 17.0005
R161 VDD.n462 VDD.n333 17.0005
R162 VDD.n462 VDD.n461 17.0005
R163 VDD.n476 VDD.n332 17.0005
R164 VDD.n476 VDD.n331 17.0005
R165 VDD.n476 VDD.n465 17.0005
R166 VDD.n476 VDD.n329 17.0005
R167 VDD.n476 VDD.n467 17.0005
R168 VDD.n476 VDD.n315 17.0005
R169 VDD.n476 VDD.n475 17.0005
R170 VDD.n472 VDD.n468 17.0005
R171 VDD.n472 VDD.n471 17.0005
R172 VDD.n551 VDD.n226 17.0005
R173 VDD.n316 VDD.n226 17.0005
R174 VDD.t3 VDD.n226 17.0005
R175 VDD.n313 VDD.n226 17.0005
R176 VDD.n326 VDD.n226 17.0005
R177 VDD.n230 VDD.n226 17.0005
R178 VDD.n246 VDD.n226 17.0005
R179 VDD.t4 VDD.n226 17.0005
R180 VDD.n324 VDD.n226 17.0005
R181 VDD.n322 VDD.n226 17.0005
R182 VDD.n321 VDD.n226 17.0005
R183 VDD.t0 VDD.n226 17.0005
R184 VDD.n478 VDD.n281 17.0005
R185 VDD.n478 VDD.n277 17.0005
R186 VDD.n478 VDD.n284 17.0005
R187 VDD.n478 VDD.t19 17.0005
R188 VDD.n310 VDD.n308 17.0005
R189 VDD.n308 VDD.n286 17.0005
R190 VDD.n308 VDD.n289 17.0005
R191 VDD.n288 VDD.n286 17.0005
R192 VDD.n289 VDD.n288 17.0005
R193 VDD.n272 VDD.t24 15.5428
R194 VDD.n206 VDD.t36 15.5126
R195 VDD.n493 VDD.t179 15.1459
R196 VDD.n390 VDD.t22 15.093
R197 VDD.n267 VDD.t23 15.0005
R198 VDD.n270 VDD.t30 15.0005
R199 VDD.n272 VDD.t31 15.0005
R200 VDD.n206 VDD.t6 15.0005
R201 VDD.n571 VDD.t5 15.0005
R202 VDD.n574 VDD.t35 15.0005
R203 VDD.n582 VDD 11.8271
R204 VDD.n291 VDD.t16 10.9543
R205 VDD.n291 VDD.t14 10.2126
R206 VDD.n177 VDD.n111 8.501
R207 VDD.n177 VDD.n176 8.501
R208 VDD.n177 VDD.n175 8.501
R209 VDD.n177 VDD.n174 8.501
R210 VDD.n177 VDD.n173 8.501
R211 VDD.n177 VDD.n172 8.501
R212 VDD.n177 VDD.n171 8.501
R213 VDD.n177 VDD.n170 8.501
R214 VDD.n177 VDD.n169 8.501
R215 VDD.n178 VDD.n177 8.501
R216 VDD.n177 VDD.n66 8.501
R217 VDD.n384 VDD.n383 8.501
R218 VDD.n357 VDD.n356 8.501
R219 VDD.n458 VDD.n342 8.501
R220 VDD.n458 VDD.n341 8.501
R221 VDD.n458 VDD.n340 8.501
R222 VDD.n458 VDD.n339 8.501
R223 VDD.n458 VDD.n338 8.501
R224 VDD.n458 VDD.n337 8.501
R225 VDD.n458 VDD.n336 8.501
R226 VDD.n463 VDD.n278 8.501
R227 VDD.n476 VDD.n330 8.501
R228 VDD.n476 VDD.n328 8.501
R229 VDD.n476 VDD.n327 8.501
R230 VDD.n476 VDD.n325 8.501
R231 VDD.n476 VDD.n323 8.501
R232 VDD.n476 VDD.n320 8.501
R233 VDD.n476 VDD.n317 8.501
R234 VDD.n476 VDD.n314 8.501
R235 VDD.n474 VDD.n473 8.501
R236 VDD.n413 VDD.t88 8.501
R237 VDD.n415 VDD.t88 8.501
R238 VDD.n416 VDD.t88 8.501
R239 VDD.n443 VDD.t88 8.501
R240 VDD.n445 VDD.t88 8.501
R241 VDD.t2 VDD.n285 8.501
R242 VDD.n305 VDD.n302 8.501
R243 VDD.t1 VDD.n224 8.501
R244 VDD.t1 VDD.n223 8.501
R245 VDD.t1 VDD.n222 8.501
R246 VDD.t1 VDD.n221 8.501
R247 VDD.t1 VDD.n220 8.501
R248 VDD.t1 VDD.n219 8.501
R249 VDD.n567 VDD.t1 8.501
R250 VDD.t1 VDD.n218 8.501
R251 VDD.t1 VDD.n217 8.501
R252 VDD.n435 VDD.n394 8.50079
R253 VDD.t10 VDD.n160 8.5005
R254 VDD.t10 VDD.n161 8.5005
R255 VDD.t10 VDD.n162 8.5005
R256 VDD.t10 VDD.n163 8.5005
R257 VDD.t10 VDD.n164 8.5005
R258 VDD.t10 VDD.n165 8.5005
R259 VDD.t10 VDD.n166 8.5005
R260 VDD.t10 VDD.n167 8.5005
R261 VDD.t10 VDD.n168 8.5005
R262 VDD.t10 VDD.n179 8.5005
R263 VDD.t205 VDD.n382 8.5005
R264 VDD.t205 VDD.n388 8.5005
R265 VDD.t205 VDD.n381 8.5005
R266 VDD.n389 VDD.t205 8.5005
R267 VDD.t207 VDD.n355 8.5005
R268 VDD.t207 VDD.n361 8.5005
R269 VDD.t207 VDD.n354 8.5005
R270 VDD.n362 VDD.t207 8.5005
R271 VDD.n513 VDD.n226 8.5005
R272 VDD.n478 VDD.n278 8.5005
R273 VDD.n473 VDD.n226 8.5005
R274 VDD.n487 VDD.n226 8.5005
R275 VDD.n495 VDD.n226 8.5005
R276 VDD.n494 VDD.n226 8.5005
R277 VDD.n497 VDD.n226 8.5005
R278 VDD.n540 VDD.n226 8.5005
R279 VDD.n500 VDD.n226 8.5005
R280 VDD.n499 VDD.n226 8.5005
R281 VDD.n503 VDD.n226 8.5005
R282 VDD.n502 VDD.n226 8.5005
R283 VDD.n544 VDD.n226 8.5005
R284 VDD.n308 VDD.n299 8.5005
R285 VDD.n308 VDD.n297 8.5005
R286 VDD.n308 VDD.n295 8.5005
R287 VDD.n308 VDD.n275 8.5005
R288 VDD.t32 VDD.n226 8.5005
R289 VDD.t1 VDD.n226 8.5005
R290 VDD.n478 VDD.t27 8.5005
R291 VDD.n569 VDD.n208 8.5005
R292 VDD.n569 VDD.n209 8.5005
R293 VDD.n569 VDD.n210 8.5005
R294 VDD.n569 VDD.n211 8.5005
R295 VDD.n569 VDD.n212 8.5005
R296 VDD.n569 VDD.n213 8.5005
R297 VDD.n569 VDD.n214 8.5005
R298 VDD.n308 VDD.n307 8.5005
R299 VDD.n428 VDD.n394 8.50037
R300 VDD.n200 VDD.n126 8.49976
R301 VDD.n200 VDD.n114 8.49976
R302 VDD.n200 VDD.n197 8.49976
R303 VDD.n200 VDD.n184 8.49976
R304 VDD.n423 VDD.n394 8.49972
R305 VDD.n599 VDD.n1 8.4997
R306 VDD.n309 VDD.n216 8.49959
R307 VDD.n449 VDD.n349 8.49947
R308 VDD.n449 VDD.n379 8.49947
R309 VDD.n449 VDD.n391 8.49947
R310 VDD.n400 VDD.n394 8.49929
R311 VDD.n421 VDD.n394 8.49929
R312 VDD.n200 VDD.n120 8.49918
R313 VDD.n200 VDD.n190 8.49918
R314 VDD.n519 VDD.n226 8.49387
R315 VDD.n200 VDD.n63 8.49223
R316 VDD.n200 VDD.n61 8.49223
R317 VDD.n200 VDD.n59 8.49223
R318 VDD.n200 VDD.n57 8.49223
R319 VDD.n200 VDD.n55 8.49223
R320 VDD.n200 VDD.n53 8.49223
R321 VDD.n200 VDD.n51 8.49223
R322 VDD.n200 VDD.n49 8.49223
R323 VDD.n200 VDD.n47 8.49223
R324 VDD.n200 VDD.n45 8.49223
R325 VDD.n200 VDD.n43 8.49223
R326 VDD.n200 VDD.n41 8.49223
R327 VDD.n200 VDD.n39 8.49223
R328 VDD.n200 VDD.n37 8.49223
R329 VDD.n200 VDD.n35 8.49223
R330 VDD.n200 VDD.n32 8.49223
R331 VDD.n200 VDD.n30 8.49223
R332 VDD.n200 VDD.n28 8.49223
R333 VDD.n200 VDD.n26 8.49223
R334 VDD.n200 VDD.n24 8.49223
R335 VDD.n200 VDD.n22 8.49223
R336 VDD.n200 VDD.n20 8.49223
R337 VDD.n200 VDD.n18 8.49223
R338 VDD.n200 VDD.n16 8.49223
R339 VDD.n200 VDD.n14 8.49223
R340 VDD.n200 VDD.n12 8.49223
R341 VDD.n200 VDD.n10 8.49223
R342 VDD.n200 VDD.n8 8.49223
R343 VDD.n200 VDD.n6 8.49223
R344 VDD.n200 VDD.n4 8.49223
R345 VDD.n201 VDD.n200 8.49223
R346 VDD.n64 VDD.n1 8.49223
R347 VDD.n62 VDD.n1 8.49223
R348 VDD.n60 VDD.n1 8.49223
R349 VDD.n58 VDD.n1 8.49223
R350 VDD.n56 VDD.n1 8.49223
R351 VDD.n54 VDD.n1 8.49223
R352 VDD.n52 VDD.n1 8.49223
R353 VDD.n50 VDD.n1 8.49223
R354 VDD.n48 VDD.n1 8.49223
R355 VDD.n46 VDD.n1 8.49223
R356 VDD.n44 VDD.n1 8.49223
R357 VDD.n42 VDD.n1 8.49223
R358 VDD.n40 VDD.n1 8.49223
R359 VDD.n38 VDD.n1 8.49223
R360 VDD.n36 VDD.n1 8.49223
R361 VDD.n109 VDD.n1 8.49223
R362 VDD.n33 VDD.n1 8.49223
R363 VDD.n31 VDD.n1 8.49223
R364 VDD.n29 VDD.n1 8.49223
R365 VDD.n27 VDD.n1 8.49223
R366 VDD.n25 VDD.n1 8.49223
R367 VDD.n23 VDD.n1 8.49223
R368 VDD.n21 VDD.n1 8.49223
R369 VDD.n19 VDD.n1 8.49223
R370 VDD.n17 VDD.n1 8.49223
R371 VDD.n15 VDD.n1 8.49223
R372 VDD.n13 VDD.n1 8.49223
R373 VDD.n11 VDD.n1 8.49223
R374 VDD.n9 VDD.n1 8.49223
R375 VDD.n7 VDD.n1 8.49223
R376 VDD.n5 VDD.n1 8.49223
R377 VDD.n3 VDD.n1 8.49223
R378 VDD.n202 VDD.n1 8.49223
R379 VDD.n482 VDD.n226 8.49137
R380 VDD.n478 VDD.n312 8.49137
R381 VDD.n74 VDD.n1 8.48982
R382 VDD.n450 VDD.n449 8.47359
R383 VDD.n452 VDD.n451 8.47359
R384 VDD.n454 VDD.n453 8.47359
R385 VDD.n456 VDD.n455 8.47359
R386 VDD.n404 VDD.n403 8.47359
R387 VDD.n406 VDD.n405 8.47359
R388 VDD.n408 VDD.n407 8.47359
R389 VDD.n530 VDD.n226 8.46995
R390 VDD.n565 VDD.n231 8.46995
R391 VDD.n412 VDD.n411 8.46995
R392 VDD.n414 VDD.n401 8.46995
R393 VDD.n418 VDD.n417 8.46995
R394 VDD.n442 VDD.n441 8.46995
R395 VDD.n444 VDD.n392 8.46995
R396 VDD.n447 VDD.n446 8.46995
R397 VDD.n449 VDD.n448 8.46995
R398 VDD.n479 VDD.n478 8.46995
R399 VDD.n371 VDD.n369 7.501
R400 VDD.n371 VDD.n368 7.501
R401 VDD.n373 VDD.n365 7.5005
R402 VDD.n373 VDD.n366 7.5005
R403 VDD.n373 VDD.n367 7.5005
R404 VDD.n373 VDD.t206 7.5005
R405 VDD.n546 VDD.t195 7.5005
R406 VDD.t195 VDD.n492 7.5005
R407 VDD.t195 VDD.n496 7.5005
R408 VDD.t195 VDD.n491 7.5005
R409 VDD.t195 VDD.n498 7.5005
R410 VDD.t195 VDD.n490 7.5005
R411 VDD.t195 VDD.n501 7.5005
R412 VDD.t195 VDD.n489 7.5005
R413 VDD.t195 VDD.n539 7.5005
R414 VDD.t195 VDD.n488 7.5005
R415 VDD.t195 VDD.n545 7.5005
R416 VDD.n296 VDD.t198 7.5005
R417 VDD.n304 VDD.t192 7.5005
R418 VDD.n265 VDD 7.244
R419 VDD.n264 VDD 6.81542
R420 VDD.n269 VDD 6.51433
R421 VDD.n93 VDD.t123 6.09207
R422 VDD.n91 VDD.t141 6.09207
R423 VDD.n89 VDD.t140 6.09207
R424 VDD.n87 VDD.t150 6.09207
R425 VDD.n85 VDD.t121 6.09207
R426 VDD.n83 VDD.t128 6.09207
R427 VDD.n81 VDD.t154 6.09207
R428 VDD.n79 VDD.t127 6.09207
R429 VDD.n77 VDD.t125 6.09207
R430 VDD.n75 VDD.t142 6.09207
R431 VDD.n73 VDD.t147 6.09207
R432 VDD.n71 VDD.t132 6.09207
R433 VDD.n69 VDD.t145 6.09207
R434 VDD.n67 VDD.t130 6.09207
R435 VDD.n598 VDD.t137 6.09207
R436 VDD.n596 VDD.t161 6.09207
R437 VDD.n594 VDD.t135 6.09207
R438 VDD.n592 VDD.t159 6.09207
R439 VDD.n590 VDD.t134 6.09207
R440 VDD.n588 VDD.t119 6.09207
R441 VDD.n586 VDD.t162 6.09207
R442 VDD.n273 VDD 6.0065
R443 VDD.n458 VDD.n334 5.66778
R444 VDD.n476 VDD.n227 5.66778
R445 VDD.t1 VDD.n215 5.66778
R446 VDD.n294 VDD.t212 5.66717
R447 VDD.n298 VDD.t213 5.66717
R448 VDD.n294 VDD.t228 5.66717
R449 VDD.n298 VDD.t229 5.66717
R450 VDD.n294 VDD.t199 5.66717
R451 VDD.n298 VDD.t200 5.66717
R452 VDD.n306 VDD.t218 5.66717
R453 VDD.n287 VDD.t219 5.66717
R454 VDD.n306 VDD.t193 5.66717
R455 VDD.n287 VDD.t194 5.66717
R456 VDD.n306 VDD.t202 5.66717
R457 VDD.n287 VDD.t203 5.66717
R458 VDD.n569 VDD.n568 5.66717
R459 VDD.n308 VDD.n207 5.66641
R460 VDD.n200 VDD.n124 5.66557
R461 VDD.n200 VDD.n122 5.66557
R462 VDD.n200 VDD.n118 5.66557
R463 VDD.n200 VDD.n116 5.66557
R464 VDD.n200 VDD.n112 5.66557
R465 VDD.n200 VDD.n194 5.66557
R466 VDD.n200 VDD.n192 5.66557
R467 VDD.n200 VDD.n188 5.66557
R468 VDD.n200 VDD.n186 5.66557
R469 VDD.n597 VDD.n1 5.66547
R470 VDD.n595 VDD.n1 5.66547
R471 VDD.n593 VDD.n1 5.66547
R472 VDD.n591 VDD.n1 5.66547
R473 VDD.n589 VDD.n1 5.66547
R474 VDD.n587 VDD.n1 5.66547
R475 VDD.n583 VDD.n1 5.66529
R476 VDD.n449 VDD.n335 5.66505
R477 VDD.n292 VDD.t13 5.66011
R478 VDD.n430 VDD.n394 5.65604
R479 VDD.n484 VDD.n226 5.65069
R480 VDD.n478 VDD.n283 5.65069
R481 VDD.n92 VDD.n1 5.64793
R482 VDD.n90 VDD.n1 5.64793
R483 VDD.n88 VDD.n1 5.64793
R484 VDD.n86 VDD.n1 5.64793
R485 VDD.n84 VDD.n1 5.64793
R486 VDD.n82 VDD.n1 5.64793
R487 VDD.n80 VDD.n1 5.64793
R488 VDD.n78 VDD.n1 5.64793
R489 VDD.n76 VDD.n1 5.64793
R490 VDD.n72 VDD.n1 5.64793
R491 VDD.n70 VDD.n1 5.64793
R492 VDD.n68 VDD.n1 5.64793
R493 VDD.n410 VDD.n409 5.62808
R494 VDD.n550 VDD.n226 5.61281
R495 VDD.n95 VDD.n1 5.61281
R496 VDD.n292 VDD.n291 5.32813
R497 VDD.n268 VDD 5.08087
R498 VDD.n372 VDD.n371 5.00111
R499 VDD.n373 VDD.t204 5.0005
R500 VDD.n485 VDD 4.94683
R501 VDD.n344 VDD.t96 4.86866
R502 VDD.n343 VDD.t97 4.86866
R503 VDD.n506 VDD.t115 4.86866
R504 VDD.n505 VDD.t114 4.86866
R505 VDD.n271 VDD 4.70062
R506 VDD.n425 VDD.t90 4.69994
R507 VDD.n429 VDD.t101 4.69994
R508 VDD.n432 VDD.t92 4.69994
R509 VDD.n434 VDD.t91 4.69994
R510 VDD.n344 VDD.t93 4.69994
R511 VDD.n343 VDD.t94 4.69994
R512 VDD.n506 VDD.t112 4.69994
R513 VDD.n505 VDD.t111 4.69994
R514 VDD.n514 VDD.t107 4.69994
R515 VDD.n517 VDD.t104 4.69994
R516 VDD.n520 VDD.t105 4.69994
R517 VDD.n524 VDD.t109 4.69994
R518 VDD.n403 VDD.t88 4.25125
R519 VDD.n477 VDD.n476 4.25113
R520 VDD.t1 VDD.n228 4.25111
R521 VDD.n200 VDD.n158 4.251
R522 VDD.n200 VDD.n156 4.251
R523 VDD.n200 VDD.n155 4.251
R524 VDD.n200 VDD.n154 4.251
R525 VDD.n200 VDD.n153 4.251
R526 VDD.n200 VDD.n152 4.251
R527 VDD.n200 VDD.n151 4.251
R528 VDD.n200 VDD.n150 4.251
R529 VDD.n200 VDD.n149 4.251
R530 VDD.n200 VDD.n148 4.251
R531 VDD.n200 VDD.n147 4.251
R532 VDD.n200 VDD.n146 4.251
R533 VDD.n200 VDD.n145 4.251
R534 VDD.n200 VDD.n144 4.251
R535 VDD.n200 VDD.n143 4.251
R536 VDD.n200 VDD.n142 4.251
R537 VDD.n200 VDD.n141 4.251
R538 VDD.n200 VDD.n140 4.251
R539 VDD.n200 VDD.n139 4.251
R540 VDD.n200 VDD.n138 4.251
R541 VDD.n200 VDD.n137 4.251
R542 VDD.n200 VDD.n136 4.251
R543 VDD.n200 VDD.n135 4.251
R544 VDD.n200 VDD.n134 4.251
R545 VDD.n200 VDD.n133 4.251
R546 VDD.n200 VDD.n132 4.251
R547 VDD.n200 VDD.n131 4.251
R548 VDD.n200 VDD.n130 4.251
R549 VDD.n200 VDD.n129 4.251
R550 VDD.n200 VDD.n128 4.251
R551 VDD.n200 VDD.n127 4.251
R552 VDD.n565 VDD.n256 4.251
R553 VDD.n565 VDD.n253 4.251
R554 VDD.n565 VDD.n247 4.251
R555 VDD.n565 VDD.n245 4.251
R556 VDD.n565 VDD.n242 4.251
R557 VDD.n565 VDD.n239 4.251
R558 VDD.n565 VDD.n236 4.251
R559 VDD.n470 VDD.n469 4.251
R560 VDD.n159 VDD.n1 4.2505
R561 VDD.n157 VDD.n1 4.2505
R562 VDD.t122 VDD.n1 4.2505
R563 VDD.t151 VDD.n1 4.2505
R564 VDD.t164 VDD.n1 4.2505
R565 VDD.t139 VDD.n1 4.2505
R566 VDD.t163 VDD.n1 4.2505
R567 VDD.t120 VDD.n1 4.2505
R568 VDD.t42 VDD.n1 4.2505
R569 VDD.t143 VDD.n1 4.2505
R570 VDD.t153 VDD.n1 4.2505
R571 VDD.t126 VDD.n1 4.2505
R572 VDD.t152 VDD.n1 4.2505
R573 VDD.t165 VDD.n1 4.2505
R574 VDD.t124 VDD.n1 4.2505
R575 VDD.t169 VDD.n1 4.2505
R576 VDD.t146 VDD.n1 4.2505
R577 VDD.t168 VDD.n1 4.2505
R578 VDD.t131 VDD.n1 4.2505
R579 VDD.t167 VDD.n1 4.2505
R580 VDD.t129 VDD.n1 4.2505
R581 VDD.n451 VDD.t88 4.2505
R582 VDD.n453 VDD.t88 4.2505
R583 VDD.n455 VDD.t88 4.2505
R584 VDD.n405 VDD.t88 4.2505
R585 VDD.n407 VDD.t88 4.2505
R586 VDD.n198 VDD.n1 4.2505
R587 VDD.t144 VDD.n1 4.2505
R588 VDD.t136 VDD.n1 4.2505
R589 VDD.t160 VDD.n1 4.2505
R590 VDD.t40 VDD.n1 4.2505
R591 VDD.t149 VDD.n1 4.2505
R592 VDD.t158 VDD.n1 4.2505
R593 VDD.t133 VDD.n1 4.2505
R594 VDD.t148 VDD.n1 4.2505
R595 VDD.t118 VDD.n1 4.2505
R596 VDD.t138 VDD.n1 4.2505
R597 VDD.n547 VDD.n226 4.24994
R598 VDD.n426 VDD.n394 4.24356
R599 VDD.n522 VDD.n226 4.23604
R600 VDD.n462 VDD.n460 4.18104
R601 VDD.n308 VDD.n290 4.17429
R602 VDD.n437 VDD.t89 3.8397
R603 VDD.n422 VDD.t233 3.8397
R604 VDD.n507 VDD.t29 3.8397
R605 VDD.n515 VDD.t232 3.8397
R606 VDD.n371 VDD.n370 3.751
R607 VDD.n234 VDD.n228 3.62297
R608 VDD.n565 VDD.n244 3.401
R609 VDD.n525 VDD.n226 3.38969
R610 VDD.n578 VDD.t173 3.32833
R611 VDD.n263 VDD.t185 3.32727
R612 VDD.n308 VDD.n293 3.3033
R613 VDD.n439 VDD.n395 3.10934
R614 VDD.n427 VDD.n397 3.1003
R615 VDD.n431 VDD.n396 3.09955
R616 VDD.n527 VDD.n526 3.09879
R617 VDD.n232 VDD.n229 2.98858
R618 VDD.t1 VDD.n229 2.83486
R619 VDD.n565 VDD.n249 2.83444
R620 VDD.n478 VDD.t88 2.83383
R621 VDD.n462 VDD.t88 2.83383
R622 VDD.n433 VDD.n394 2.82146
R623 VDD.n516 VDD.n226 2.82135
R624 VDD.n438 VDD.n394 2.80886
R625 VDD.n511 VDD.n226 2.80886
R626 VDD.n570 VDD 2.76883
R627 VDD.n565 VDD.n248 2.71665
R628 VDD.n276 VDD 2.69
R629 VDD.n529 VDD.n528 2.63562
R630 VDD.n262 VDD.t184 2.63359
R631 VDD.n518 VDD.n508 2.62624
R632 VDD.n565 VDD.n250 2.42957
R633 VDD.n566 VDD.n565 2.42957
R634 VDD.n402 VDD.t88 2.42957
R635 VDD.n548 VDD.t197 2.42907
R636 VDD.n541 VDD.t196 2.42907
R637 VDD.n542 VDD.t196 2.42907
R638 VDD.n548 VDD.t216 2.42907
R639 VDD.t210 VDD.n541 2.42907
R640 VDD.n542 VDD.t210 2.42907
R641 VDD.n536 VDD.n226 2.30817
R642 VDD.n478 VDD.n279 2.29333
R643 VDD.n486 VDD.n226 2.29289
R644 VDD.n510 VDD.n509 2.27965
R645 VDD.n399 VDD.n398 2.2728
R646 VDD.n573 VDD 2.2555
R647 VDD.n205 VDD.t174 2.25306
R648 VDD.t28 VDD.n527 2.12639
R649 VDD.n393 VDD.t88 2.126
R650 VDD.n419 VDD.n394 1.96204
R651 VDD.n204 VDD.n1 1.9617
R652 VDD.n572 VDD 1.92618
R653 VDD.n396 VDD.t88 1.89036
R654 VDD.t10 VDD.n1 1.88939
R655 VDD.n579 VDD.n205 1.82278
R656 VDD.n440 VDD.n394 1.73629
R657 VDD.n577 VDD 1.73117
R658 VDD.n97 VDD.n1 1.71094
R659 VDD.n308 VDD.n301 1.7075
R660 VDD.n397 VDD.t88 1.70155
R661 VDD.n565 VDD.n259 1.701
R662 VDD.n565 VDD.n260 1.701
R663 VDD.n262 VDD.t183 1.5509
R664 VDD.t7 VDD.n1 1.54595
R665 VDD.n557 VDD.n556 1.52331
R666 VDD.n580 VDD.n579 1.51623
R667 VDD.n576 VDD 1.38569
R668 VDD.n481 VDD 1.33241
R669 VDD.n480 VDD.n226 1.32181
R670 VDD.n203 VDD.n2 1.31099
R671 VDD.n561 VDD.n560 1.293
R672 VDD.n560 VDD.n559 1.293
R673 VDD.n556 VDD.n555 1.293
R674 VDD.n555 VDD.n554 1.293
R675 VDD.n554 VDD.n553 1.293
R676 VDD.n177 VDD.n99 1.27342
R677 VDD.t28 VDD.n509 1.21619
R678 VDD.n99 VDD.n98 1.18682
R679 VDD.n565 VDD.n243 1.1851
R680 VDD.n263 VDD.n262 1.16135
R681 VDD.n562 VDD.n558 1.15925
R682 VDD.n390 VDD 1.13717
R683 VDD.n510 VDD.n504 1.1334
R684 VDD.n565 VDD.n564 1.08488
R685 VDD.n538 VDD.n504 1.08248
R686 VDD.n565 VDD.n233 1.06386
R687 VDD.n319 VDD.n318 1.02218
R688 VDD.n466 VDD.n319 0.95896
R689 VDD.n390 VDD.n280 0.945444
R690 VDD.n579 VDD.t172 0.895237
R691 VDD.n235 VDD.n234 0.847055
R692 VDD.n580 VDD.n578 0.842493
R693 VDD.n534 VDD.n533 0.832711
R694 VDD.n480 VDD.n479 0.82924
R695 VDD.n535 VDD.n534 0.826037
R696 VDD.n233 VDD.n232 0.822735
R697 VDD VDD.n243 0.821535
R698 VDD.n303 VDD 0.8145
R699 VDD.n565 VDD.n235 0.801945
R700 VDD.n395 VDD.t88 0.775292
R701 VDD.n234 VDD.n233 0.774826
R702 VDD VDD.n292 0.764286
R703 VDD.n459 VDD.n235 0.752079
R704 VDD.n585 VDD.n584 0.741645
R705 VDD.n308 VDD.n274 0.738934
R706 VDD.n441 VDD.n440 0.73635
R707 VDD.n564 VDD.n563 0.735824
R708 VDD.n399 VDD 0.722833
R709 VDD.n398 VDD.t88 0.711075
R710 VDD.n528 VDD.t28 0.71107
R711 VDD.n534 VDD.n226 0.70963
R712 VDD.n419 VDD.n418 0.690081
R713 VDD.n466 VDD.n243 0.685669
R714 VDD.n476 VDD.n319 0.6415
R715 VDD.n282 VDD 0.634418
R716 VDD.n564 VDD.n552 0.621499
R717 VDD.n581 VDD.n580 0.619295
R718 VDD.n481 VDD.n480 0.617094
R719 VDD.n301 VDD.n300 0.611467
R720 VDD.n303 VDD.n301 0.607798
R721 VDD.n558 VDD.n557 0.560813
R722 VDD.n543 VDD.n226 0.527727
R723 VDD.n204 VDD.n203 0.52509
R724 VDD.n420 VDD.n419 0.500872
R725 VDD.n182 VDD.n181 0.486964
R726 VDD.n183 VDD.n182 0.47957
R727 VDD.n486 VDD.n485 0.468233
R728 VDD.n282 VDD.n279 0.46661
R729 VDD.n98 VDD.n97 0.460608
R730 VDD.n97 VDD.n96 0.452489
R731 VDD.n536 VDD.n535 0.433972
R732 VDD.n390 VDD.n279 0.428526
R733 VDD.n549 VDD.n486 0.426839
R734 VDD.n196 VDD.n2 0.420805
R735 VDD.n504 VDD.n226 0.418118
R736 VDD.n318 VDD.n248 0.407821
R737 VDD.n582 VDD.n204 0.401331
R738 VDD.n347 VDD.t88 0.378758
R739 VDD.n303 VDD.n293 0.36097
R740 VDD.n585 VDD 0.359031
R741 VDD.n269 VDD.n268 0.345167
R742 VDD.n573 VDD.n572 0.345167
R743 VDD.n537 VDD.n536 0.344532
R744 VDD.n570 VDD 0.3415
R745 VDD.n273 VDD.n271 0.339667
R746 VDD VDD.n290 0.333262
R747 VDD.n440 VDD.n439 0.33111
R748 VDD.n248 VDD 0.323129
R749 VDD.n562 VDD.n561 0.30675
R750 VDD.n300 VDD.n290 0.300524
R751 VDD.t1 VDD.n225 0.289286
R752 VDD.n411 VDD.n410 0.271279
R753 VDD.n293 VDD 0.269314
R754 VDD.n581 VDD.n205 0.264205
R755 VDD.n410 VDD.n408 0.263017
R756 VDD.n512 VDD 0.262283
R757 VDD.n448 VDD.n447 0.250378
R758 VDD.n447 VDD.n392 0.250378
R759 VDD.n441 VDD.n392 0.250378
R760 VDD.n411 VDD.n401 0.250378
R761 VDD.n418 VDD.n401 0.250378
R762 VDD.n96 VDD.n95 0.250092
R763 VDD.n232 VDD.n231 0.240939
R764 VDD.n460 VDD.n458 0.240551
R765 VDD.n273 VDD.n272 0.237977
R766 VDD VDD.n600 0.224775
R767 VDD.n549 VDD 0.224139
R768 VDD.n408 VDD.n406 0.221145
R769 VDD.n406 VDD.n404 0.221145
R770 VDD.n456 VDD.n454 0.221145
R771 VDD.n454 VDD.n452 0.221145
R772 VDD.n452 VDD.n450 0.221145
R773 VDD.n552 VDD.n550 0.200549
R774 VDD.n575 VDD.n574 0.194698
R775 VDD.n200 VDD.n99 0.194021
R776 VDD.n267 VDD.n266 0.19334
R777 VDD.n530 VDD.n529 0.187772
R778 VDD.n550 VDD.n549 0.187419
R779 VDD.n531 VDD 0.181275
R780 VDD.n523 VDD 0.172218
R781 VDD.n424 VDD 0.168485
R782 VDD.n460 VDD.n459 0.161102
R783 VDD.n457 VDD.n456 0.159352
R784 VDD.n94 VDD 0.155949
R785 VDD.n200 VDD.n180 0.150123
R786 VDD.n531 VDD.n530 0.147439
R787 VDD.t28 VDD.n508 0.141357
R788 VDD.n265 VDD.n264 0.139833
R789 VDD.n577 VDD.n576 0.139833
R790 VDD.n448 VDD.n346 0.132772
R791 VDD.n95 VDD.n94 0.128752
R792 VDD.n436 VDD 0.126034
R793 VDD.n200 VDD.n199 0.125986
R794 VDD.n439 VDD.n438 0.117242
R795 VDD.n511 VDD.n510 0.116903
R796 VDD.n108 VDD.n107 0.115283
R797 VDD.n512 VDD.n511 0.114684
R798 VDD.n107 VDD.n106 0.1105
R799 VDD.n106 VDD.n105 0.1105
R800 VDD.n105 VDD.n104 0.1105
R801 VDD.n104 VDD.n103 0.1105
R802 VDD.n103 VDD.n102 0.1105
R803 VDD.n102 VDD.n101 0.1105
R804 VDD.n101 VDD.n100 0.1105
R805 VDD.n563 VDD.n231 0.108939
R806 VDD.n300 VDD 0.0948807
R807 VDD VDD.n206 0.0867162
R808 VDD.n345 VDD.n343 0.0848609
R809 VDD.n345 VDD.n344 0.0848609
R810 VDD.n537 VDD.n505 0.0848609
R811 VDD.n537 VDD.n506 0.0848609
R812 VDD.n457 VDD.n345 0.083
R813 VDD.n538 VDD.n537 0.083
R814 VDD.n74 VDD.n73 0.0800125
R815 VDD.n79 VDD.n78 0.0792734
R816 VDD.n83 VDD.n82 0.0792734
R817 VDD.n87 VDD.n86 0.0792734
R818 VDD.n91 VDD.n90 0.0792734
R819 VDD.n70 VDD.n69 0.0792734
R820 VDD.n68 VDD.n67 0.0789377
R821 VDD.n72 VDD.n71 0.0789377
R822 VDD.n77 VDD.n76 0.0789377
R823 VDD.n81 VDD.n80 0.0789377
R824 VDD.n85 VDD.n84 0.0789377
R825 VDD.n89 VDD.n88 0.0789377
R826 VDD.n93 VDD.n92 0.0789377
R827 VDD.n522 VDD.n507 0.0779153
R828 VDD.n404 VDD.n345 0.076852
R829 VDD.n438 VDD.n437 0.0742674
R830 VDD.n479 VDD.n276 0.0686056
R831 VDD.n268 VDD.n267 0.0629691
R832 VDD.n270 VDD.n269 0.0629691
R833 VDD.n271 VDD.n270 0.0629691
R834 VDD.n571 VDD.n570 0.0629691
R835 VDD.n572 VDD.n571 0.0629691
R836 VDD.n574 VDD.n573 0.0629691
R837 VDD.n200 VDD.n2 0.0618846
R838 VDD.n523 VDD.n522 0.0597564
R839 VDD.n69 VDD.n68 0.0581955
R840 VDD.n73 VDD.n72 0.0581955
R841 VDD.n92 VDD.n91 0.0581955
R842 VDD.n88 VDD.n87 0.0581955
R843 VDD.n84 VDD.n83 0.0581955
R844 VDD.n80 VDD.n79 0.0581955
R845 VDD.n76 VDD.n75 0.0581955
R846 VDD.n71 VDD.n70 0.0578599
R847 VDD.n78 VDD.n77 0.0578599
R848 VDD.n82 VDD.n81 0.0578599
R849 VDD.n86 VDD.n85 0.0578599
R850 VDD.n90 VDD.n89 0.0578599
R851 VDD.n482 VDD.n481 0.0571122
R852 VDD.n312 VDD.n276 0.0571122
R853 VDD.n75 VDD.n74 0.0562999
R854 VDD.n450 VDD.n346 0.0558226
R855 VDD.n421 VDD.n420 0.055573
R856 VDD.n96 VDD 0.0555
R857 VDD.n529 VDD 0.0555
R858 VDD.n484 VDD.n483 0.0554453
R859 VDD.n434 VDD.n433 0.0547887
R860 VDD.n311 VDD.n283 0.0545429
R861 VDD VDD.n581 0.0512692
R862 VDD.n346 VDD 0.0490294
R863 VDD.n535 VDD 0.0490294
R864 VDD.n283 VDD.n282 0.0469401
R865 VDD.n485 VDD.n484 0.0466048
R866 VDD.n110 VDD.n108 0.0449131
R867 VDD.n312 VDD.n311 0.0440709
R868 VDD.n427 VDD.n426 0.0435391
R869 VDD.n483 VDD.n482 0.0435039
R870 VDD.n422 VDD.n421 0.0419295
R871 VDD.n437 VDD.n436 0.0405775
R872 VDD.n516 VDD.n515 0.0385827
R873 VDD.n430 VDD.n429 0.0375909
R874 VDD.n433 VDD.n432 0.0366519
R875 VDD.n202 VDD.n201 0.0365811
R876 VDD.n4 VDD.n3 0.0365811
R877 VDD.n6 VDD.n5 0.0365811
R878 VDD.n8 VDD.n7 0.0365811
R879 VDD.n10 VDD.n9 0.0365811
R880 VDD.n12 VDD.n11 0.0365811
R881 VDD.n14 VDD.n13 0.0365811
R882 VDD.n16 VDD.n15 0.0365811
R883 VDD.n18 VDD.n17 0.0365811
R884 VDD.n20 VDD.n19 0.0365811
R885 VDD.n22 VDD.n21 0.0365811
R886 VDD.n24 VDD.n23 0.0365811
R887 VDD.n26 VDD.n25 0.0365811
R888 VDD.n28 VDD.n27 0.0365811
R889 VDD.n30 VDD.n29 0.0365811
R890 VDD.n32 VDD.n31 0.0365811
R891 VDD.n109 VDD.n35 0.0365811
R892 VDD.n37 VDD.n36 0.0365811
R893 VDD.n39 VDD.n38 0.0365811
R894 VDD.n41 VDD.n40 0.0365811
R895 VDD.n43 VDD.n42 0.0365811
R896 VDD.n45 VDD.n44 0.0365811
R897 VDD.n47 VDD.n46 0.0365811
R898 VDD.n49 VDD.n48 0.0365811
R899 VDD.n51 VDD.n50 0.0365811
R900 VDD.n53 VDD.n52 0.0365811
R901 VDD.n55 VDD.n54 0.0365811
R902 VDD.n57 VDD.n56 0.0365811
R903 VDD.n59 VDD.n58 0.0365811
R904 VDD.n61 VDD.n60 0.0365811
R905 VDD.n63 VDD.n62 0.0365811
R906 VDD.n64 VDD.n63 0.0365811
R907 VDD.n62 VDD.n61 0.0365811
R908 VDD.n60 VDD.n59 0.0365811
R909 VDD.n58 VDD.n57 0.0365811
R910 VDD.n56 VDD.n55 0.0365811
R911 VDD.n54 VDD.n53 0.0365811
R912 VDD.n52 VDD.n51 0.0365811
R913 VDD.n50 VDD.n49 0.0365811
R914 VDD.n48 VDD.n47 0.0365811
R915 VDD.n46 VDD.n45 0.0365811
R916 VDD.n44 VDD.n43 0.0365811
R917 VDD.n42 VDD.n41 0.0365811
R918 VDD.n40 VDD.n39 0.0365811
R919 VDD.n38 VDD.n37 0.0365811
R920 VDD.n36 VDD.n35 0.0365811
R921 VDD.n33 VDD.n32 0.0365811
R922 VDD.n31 VDD.n30 0.0365811
R923 VDD.n29 VDD.n28 0.0365811
R924 VDD.n27 VDD.n26 0.0365811
R925 VDD.n25 VDD.n24 0.0365811
R926 VDD.n23 VDD.n22 0.0365811
R927 VDD.n21 VDD.n20 0.0365811
R928 VDD.n19 VDD.n18 0.0365811
R929 VDD.n17 VDD.n16 0.0365811
R930 VDD.n15 VDD.n14 0.0365811
R931 VDD.n13 VDD.n12 0.0365811
R932 VDD.n11 VDD.n10 0.0365811
R933 VDD.n9 VDD.n8 0.0365811
R934 VDD.n7 VDD.n6 0.0365811
R935 VDD.n5 VDD.n4 0.0365811
R936 VDD.n201 VDD.n3 0.0365811
R937 VDD.n517 VDD.n516 0.0364835
R938 VDD.n526 VDD.n525 0.0359765
R939 VDD.n98 VDD.n65 0.0356174
R940 VDD.n525 VDD.n524 0.0322835
R941 VDD.n266 VDD.n265 0.0303765
R942 VDD.n424 VDD.n423 0.0299919
R943 VDD.n576 VDD.n575 0.0290185
R944 VDD.n329 VDD.n252 0.0277868
R945 VDD.n331 VDD.n255 0.0277868
R946 VDD.n332 VDD.n257 0.0277868
R947 VDD.n461 VDD.n258 0.0277868
R948 VDD.n459 VDD.n333 0.0277868
R949 VDD.n551 VDD.n261 0.0277868
R950 VDD.n471 VDD.n237 0.0277868
R951 VDD.n468 VDD.n238 0.0277868
R952 VDD.n475 VDD.n240 0.0277868
R953 VDD.n315 VDD.n241 0.0277868
R954 VDD.n264 VDD.n263 0.0275769
R955 VDD.n578 VDD.n577 0.0275769
R956 VDD.n431 VDD.n430 0.0270428
R957 VDD.n519 VDD 0.0270186
R958 VDD.n439 VDD 0.0260814
R959 VDD.n432 VDD.n431 0.0244313
R960 VDD.n518 VDD.n517 0.0244313
R961 VDD.n520 VDD.n519 0.0240796
R962 VDD.n426 VDD.n425 0.0238062
R963 VDD.n400 VDD.n399 0.0231699
R964 VDD.n464 VDD.n254 0.0213915
R965 VDD.n521 VDD.n520 0.0202328
R966 VDD.n532 VDD.n531 0.0192597
R967 VDD.n423 VDD.n422 0.0189066
R968 VDD.n110 VDD.n109 0.0185406
R969 VDD.n65 VDD.n64 0.0185406
R970 VDD.n34 VDD.n33 0.0185406
R971 VDD.n203 VDD.n202 0.0185406
R972 VDD.n467 VDD.n466 0.018407
R973 VDD.n515 VDD.n514 0.016874
R974 VDD.n483 VDD.n274 0.0146599
R975 VDD.n358 VDD.n335 0.0132054
R976 VDD VDD.n518 0.0130954
R977 VDD.n583 VDD.n582 0.0125456
R978 VDD.n67 VDD.n0 0.0123563
R979 VDD VDD.n428 0.0123358
R980 VDD.n545 VDD.n543 0.0122234
R981 VDD.n177 VDD.n112 0.0115856
R982 VDD.n600 VDD.n0 0.0110389
R983 VDD.n94 VDD.n93 0.0110389
R984 VDD.n591 VDD.n590 0.0106727
R985 VDD.n595 VDD.n594 0.0106727
R986 VDD.n587 VDD.n586 0.0106727
R987 VDD.n589 VDD.n588 0.0103391
R988 VDD.n593 VDD.n592 0.0103391
R989 VDD.n597 VDD.n596 0.0103391
R990 VDD.n429 VDD 0.0101565
R991 VDD.n117 VDD.n116 0.00998086
R992 VDD.n124 VDD.n123 0.00998086
R993 VDD.n194 VDD.n193 0.00998086
R994 VDD.n108 VDD.n34 0.00979577
R995 VDD.n187 VDD.n186 0.00964725
R996 VDD.n391 VDD.n389 0.00947486
R997 VDD.n533 VDD.n507 0.00902713
R998 VDD.n192 VDD.n191 0.00852197
R999 VDD.n115 VDD.n114 0.00829407
R1000 VDD.n126 VDD.n125 0.00829407
R1001 VDD.n197 VDD.n195 0.00829407
R1002 VDD.n185 VDD.n184 0.00829407
R1003 VDD.n118 VDD.n117 0.00823019
R1004 VDD.n123 VDD.n122 0.00823019
R1005 VDD.n188 VDD.n187 0.00823019
R1006 VDD.n590 VDD.n589 0.00822995
R1007 VDD.n594 VDD.n593 0.00822995
R1008 VDD.n598 VDD.n597 0.00822995
R1009 VDD.n119 VDD.n118 0.00818836
R1010 VDD.n122 VDD.n121 0.00818836
R1011 VDD.n189 VDD.n188 0.00818836
R1012 VDD.n547 VDD.n546 0.00810172
R1013 VDD.n309 VDD.n207 0.00808983
R1014 VDD.n193 VDD.n192 0.00789658
R1015 VDD.n588 VDD.n587 0.00789633
R1016 VDD.n592 VDD.n591 0.00789633
R1017 VDD.n596 VDD.n595 0.00789633
R1018 VDD.n120 VDD.n119 0.00771009
R1019 VDD.n121 VDD.n120 0.00771009
R1020 VDD.n191 VDD.n190 0.00771009
R1021 VDD.n190 VDD.n189 0.00771009
R1022 VDD.n113 VDD.n112 0.00760481
R1023 VDD.n600 VDD.n599 0.00756449
R1024 VDD.n391 VDD 0.00749125
R1025 VDD.n458 VDD.n335 0.00746192
R1026 VDD.n585 VDD.n583 0.00743692
R1027 VDD.n599 VDD.n598 0.00741182
R1028 VDD.n533 VDD.n532 0.00732171
R1029 VDD.n425 VDD.n424 0.00721756
R1030 VDD.n524 VDD.n523 0.00721756
R1031 VDD.n114 VDD.n113 0.00712696
R1032 VDD.n181 VDD.n126 0.00712696
R1033 VDD.n197 VDD.n196 0.00712696
R1034 VDD.n184 VDD.n183 0.00712696
R1035 VDD.n465 VDD.n464 0.00689535
R1036 VDD.n186 VDD.n185 0.00677131
R1037 VDD.n528 VDD.n226 0.006756
R1038 VDD.n398 VDD.n394 0.00675031
R1039 VDD.n381 VDD.n380 0.00645082
R1040 VDD.n356 VDD.n350 0.00645082
R1041 VDD.n116 VDD.n115 0.0064377
R1042 VDD.n125 VDD.n124 0.0064377
R1043 VDD.n195 VDD.n194 0.0064377
R1044 VDD.n388 VDD.n378 0.00636066
R1045 VDD.n360 VDD.n348 0.00636066
R1046 VDD.n395 VDD.n394 0.00626652
R1047 VDD.n318 VDD.n251 0.00604264
R1048 VDD.n435 VDD.n434 0.00603816
R1049 VDD.n514 VDD.n513 0.00595802
R1050 VDD.n382 VDD.n377 0.00590984
R1051 VDD.n355 VDD.n351 0.00590984
R1052 VDD.n274 VDD.n273 0.00585474
R1053 VDD.n548 VDD.n547 0.00576287
R1054 VDD.n311 VDD.n286 0.00548489
R1055 VDD.n361 VDD.n352 0.00545902
R1056 VDD.n483 VDD.n275 0.00540181
R1057 VDD.n383 VDD.n376 0.00536885
R1058 VDD.n298 VDD.n297 0.00531873
R1059 VDD.n306 VDD.n305 0.00531873
R1060 VDD.n354 VDD.n353 0.0050082
R1061 VDD.n387 VDD.n375 0.00491803
R1062 VDD.n295 VDD.n294 0.00465408
R1063 VDD.n289 VDD.n287 0.00465408
R1064 VDD.n385 VDD.n374 0.00446721
R1065 VDD.n363 VDD.n362 0.00446721
R1066 VDD.n420 VDD.n400 0.00441017
R1067 VDD.n374 VDD.n373 0.00437705
R1068 VDD.n371 VDD.n364 0.00437705
R1069 VDD.n545 VDD.n544 0.0043486
R1070 VDD.n502 VDD.n488 0.0043486
R1071 VDD.n499 VDD.n489 0.0043486
R1072 VDD.n501 VDD.n500 0.0043486
R1073 VDD.n498 VDD.n497 0.0043486
R1074 VDD.n496 VDD.n495 0.0043486
R1075 VDD.n492 VDD.n487 0.0043486
R1076 VDD.n388 VDD.n379 0.00433551
R1077 VDD.n360 VDD.n349 0.00433551
R1078 VDD.n509 VDD.n226 0.00428075
R1079 VDD.n381 VDD.n379 0.00424535
R1080 VDD.n356 VDD.n349 0.00424535
R1081 VDD.n371 VDD.n363 0.00419672
R1082 VDD.n539 VDD.n538 0.0040687
R1083 VDD.n541 VDD.n540 0.00399873
R1084 VDD.n310 VDD.n309 0.0038243
R1085 VDD.n296 VDD.n295 0.00374018
R1086 VDD.n305 VDD.n304 0.00332477
R1087 VDD.n304 VDD.n289 0.00332477
R1088 VDD.n397 VDD.n394 0.00331398
R1089 VDD VDD.n390 0.00320492
R1090 VDD.n458 VDD.n457 0.00320492
R1091 VDD.n493 VDD.n491 0.00308906
R1092 VDD.n396 VDD.n394 0.00307157
R1093 VDD.n526 VDD.n521 0.00301908
R1094 VDD VDD.n569 0.00299245
R1095 VDD.n297 VDD.n296 0.00290937
R1096 VDD.n569 VDD.n207 0.00288277
R1097 VDD.n527 VDD.n226 0.00283091
R1098 VDD.n373 VDD.n364 0.0027541
R1099 VDD.n436 VDD.n435 0.00267938
R1100 VDD.n385 VDD.n375 0.00266393
R1101 VDD.n362 VDD.n353 0.00266393
R1102 VDD.n565 VDD.n229 0.00247691
R1103 VDD.n200 VDD.n182 0.00246699
R1104 VDD.n428 VDD.n427 0.00225945
R1105 VDD.n387 VDD.n376 0.00221311
R1106 VDD.n329 VDD.n251 0.00220543
R1107 VDD.n465 VDD.n252 0.00220543
R1108 VDD.n331 VDD.n254 0.00220543
R1109 VDD.n332 VDD.n255 0.00220543
R1110 VDD.n461 VDD.n257 0.00220543
R1111 VDD.n333 VDD.n258 0.00220543
R1112 VDD.n552 VDD.n551 0.00220543
R1113 VDD.n471 VDD.n261 0.00220543
R1114 VDD.n468 VDD.n237 0.00220543
R1115 VDD.n475 VDD.n238 0.00220543
R1116 VDD.n315 VDD.n240 0.00220543
R1117 VDD.n467 VDD.n241 0.00220543
R1118 VDD.n477 VDD.t2 0.002125
R1119 VDD.n354 VDD.n352 0.00212295
R1120 VDD.n294 VDD.n275 0.00199547
R1121 VDD.n287 VDD.n286 0.00199547
R1122 VDD.n199 VDD.n198 0.00198524
R1123 VDD.n446 VDD.n347 0.00197775
R1124 VDD.n543 VDD.n542 0.0019299
R1125 VDD.t27 VDD.n477 0.00187493
R1126 VDD.n565 VDD.n228 0.00182343
R1127 VDD.n383 VDD.n377 0.0017623
R1128 VDD.n494 VDD.n493 0.00175954
R1129 VDD.n513 VDD.n512 0.00175954
R1130 VDD.n472 VDD.n470 0.00175
R1131 VDD.n370 VDD.n365 0.00175
R1132 VDD.n586 VDD.n585 0.00172137
R1133 VDD.n361 VDD.n351 0.00167213
R1134 VDD.n326 VDD.n249 0.00166667
R1135 VDD.n372 VDD.n367 0.00166667
R1136 VDD.n215 VDD.n208 0.00166667
R1137 VDD.n462 VDD.n334 0.00166667
R1138 VDD.n246 VDD.n227 0.00166667
R1139 VDD.n225 VDD.n214 0.00164414
R1140 VDD.n549 VDD.n548 0.00161959
R1141 VDD.n302 VDD.n217 0.0015
R1142 VDD.n544 VDD.n488 0.00140967
R1143 VDD.n539 VDD.n502 0.00140967
R1144 VDD.n503 VDD.n489 0.00140967
R1145 VDD.n501 VDD.n499 0.00140967
R1146 VDD.n500 VDD.n490 0.00140967
R1147 VDD.n540 VDD.n498 0.00140967
R1148 VDD.n497 VDD.n491 0.00140967
R1149 VDD.n496 VDD.n494 0.00140967
R1150 VDD.n495 VDD.n492 0.00140967
R1151 VDD.n546 VDD.n487 0.00140967
R1152 VDD.n308 VDD.n225 0.00135568
R1153 VDD.n409 VDD.n334 0.00133332
R1154 VDD.t1 VDD.n227 0.00133332
R1155 VDD.n568 VDD.n215 0.00133332
R1156 VDD.t206 VDD.n372 0.00133332
R1157 VDD.t2 VDD.n249 0.00133331
R1158 VDD.n299 VDD.n298 0.00133082
R1159 VDD.n307 VDD.n306 0.00133082
R1160 VDD.n470 VDD.n226 0.00124998
R1161 VDD.n370 VDD.t204 0.00124998
R1162 VDD.n389 VDD.n380 0.00122131
R1163 VDD.n382 VDD.n378 0.00122131
R1164 VDD.n355 VDD.n350 0.00122131
R1165 VDD.n358 VDD.n348 0.00122131
R1166 VDD.n311 VDD.n310 0.00116465
R1167 VDD.n508 VDD.n226 0.00115306
R1168 VDD.n449 VDD.n347 0.00102222
R1169 VDD.n199 VDD.t7 0.0010147
R1170 VDD.n198 VDD.n127 0.001
R1171 VDD.n128 VDD.t138 0.001
R1172 VDD.n129 VDD.t118 0.001
R1173 VDD.n130 VDD.t148 0.001
R1174 VDD.n131 VDD.t133 0.001
R1175 VDD.n132 VDD.t158 0.001
R1176 VDD.n133 VDD.t149 0.001
R1177 VDD.n134 VDD.t40 0.001
R1178 VDD.n135 VDD.t160 0.001
R1179 VDD.n136 VDD.t136 0.001
R1180 VDD.n137 VDD.t144 0.001
R1181 VDD.n138 VDD.t129 0.001
R1182 VDD.n139 VDD.t167 0.001
R1183 VDD.n140 VDD.t131 0.001
R1184 VDD.n141 VDD.t168 0.001
R1185 VDD.n142 VDD.t146 0.001
R1186 VDD.n143 VDD.t169 0.001
R1187 VDD.n144 VDD.t124 0.001
R1188 VDD.n145 VDD.t165 0.001
R1189 VDD.n146 VDD.t152 0.001
R1190 VDD.n147 VDD.t126 0.001
R1191 VDD.n148 VDD.t153 0.001
R1192 VDD.n149 VDD.t143 0.001
R1193 VDD.n150 VDD.t42 0.001
R1194 VDD.n151 VDD.t120 0.001
R1195 VDD.n152 VDD.t163 0.001
R1196 VDD.n153 VDD.t139 0.001
R1197 VDD.n154 VDD.t164 0.001
R1198 VDD.n155 VDD.t151 0.001
R1199 VDD.n156 VDD.t122 0.001
R1200 VDD.n158 VDD.n157 0.001
R1201 VDD.n180 VDD.n159 0.001
R1202 VDD.n159 VDD.n158 0.001
R1203 VDD.n157 VDD.n156 0.001
R1204 VDD.t122 VDD.n155 0.001
R1205 VDD.t151 VDD.n154 0.001
R1206 VDD.t164 VDD.n153 0.001
R1207 VDD.t139 VDD.n152 0.001
R1208 VDD.t163 VDD.n151 0.001
R1209 VDD.t120 VDD.n150 0.001
R1210 VDD.t42 VDD.n149 0.001
R1211 VDD.t143 VDD.n148 0.001
R1212 VDD.t153 VDD.n147 0.001
R1213 VDD.t126 VDD.n146 0.001
R1214 VDD.t152 VDD.n145 0.001
R1215 VDD.t165 VDD.n144 0.001
R1216 VDD.t124 VDD.n143 0.001
R1217 VDD.t169 VDD.n142 0.001
R1218 VDD.t146 VDD.n141 0.001
R1219 VDD.t168 VDD.n140 0.001
R1220 VDD.t131 VDD.n139 0.001
R1221 VDD.t167 VDD.n138 0.001
R1222 VDD.t129 VDD.n137 0.001
R1223 VDD.t144 VDD.n136 0.001
R1224 VDD.t136 VDD.n135 0.001
R1225 VDD.t160 VDD.n134 0.001
R1226 VDD.t40 VDD.n133 0.001
R1227 VDD.t149 VDD.n132 0.001
R1228 VDD.t158 VDD.n131 0.001
R1229 VDD.t133 VDD.n130 0.001
R1230 VDD.t148 VDD.n129 0.001
R1231 VDD.t118 VDD.n128 0.001
R1232 VDD.t138 VDD.n127 0.001
R1233 VDD.n180 VDD.t10 0.001
R1234 VDD.n200 VDD.n66 0.001
R1235 VDD.n179 VDD.n178 0.001
R1236 VDD.n169 VDD.n168 0.001
R1237 VDD.n170 VDD.n167 0.001
R1238 VDD.n171 VDD.n166 0.001
R1239 VDD.n172 VDD.n165 0.001
R1240 VDD.n173 VDD.n164 0.001
R1241 VDD.n174 VDD.n163 0.001
R1242 VDD.n175 VDD.n162 0.001
R1243 VDD.n176 VDD.n161 0.001
R1244 VDD.n160 VDD.n111 0.001
R1245 VDD.n200 VDD.n111 0.001
R1246 VDD.n176 VDD.n160 0.001
R1247 VDD.n175 VDD.n161 0.001
R1248 VDD.n174 VDD.n162 0.001
R1249 VDD.n173 VDD.n163 0.001
R1250 VDD.n172 VDD.n164 0.001
R1251 VDD.n171 VDD.n165 0.001
R1252 VDD.n170 VDD.n166 0.001
R1253 VDD.n169 VDD.n167 0.001
R1254 VDD.n178 VDD.n168 0.001
R1255 VDD.n179 VDD.n66 0.001
R1256 VDD.n219 VDD.n214 0.001
R1257 VDD.n220 VDD.n213 0.001
R1258 VDD.n221 VDD.n212 0.001
R1259 VDD.n222 VDD.n211 0.001
R1260 VDD.n223 VDD.n210 0.001
R1261 VDD.n224 VDD.n209 0.001
R1262 VDD.n446 VDD.n445 0.001
R1263 VDD.n444 VDD.n443 0.001
R1264 VDD.n442 VDD.n393 0.001
R1265 VDD.n412 VDD.n402 0.001
R1266 VDD.n413 VDD.n412 0.001
R1267 VDD.n415 VDD.n414 0.001
R1268 VDD.n417 VDD.n416 0.001
R1269 VDD.n394 VDD.n393 0.001
R1270 VDD.n478 VDD.n285 0.001
R1271 VDD.n449 VDD.n280 0.001
R1272 VDD.n409 VDD.n336 0.001
R1273 VDD.n407 VDD.n337 0.001
R1274 VDD.n405 VDD.n338 0.001
R1275 VDD.n403 VDD.n339 0.001
R1276 VDD.n455 VDD.n340 0.001
R1277 VDD.n453 VDD.n341 0.001
R1278 VDD.n451 VDD.n342 0.001
R1279 VDD.n476 VDD.n474 0.001
R1280 VDD.n463 VDD.n462 0.001
R1281 VDD.n368 VDD.n367 0.001
R1282 VDD.n369 VDD.n366 0.001
R1283 VDD.t207 VDD.n357 0.001
R1284 VDD.t205 VDD.n384 0.001
R1285 VDD.n386 VDD.n384 0.001
R1286 VDD.n359 VDD.n357 0.001
R1287 VDD.n369 VDD.n365 0.001
R1288 VDD.n368 VDD.n366 0.001
R1289 VDD.n469 VDD.n260 0.001
R1290 VDD.n469 VDD.n236 0.001
R1291 VDD.n473 VDD.n239 0.001
R1292 VDD.n314 VDD.n313 0.001
R1293 VDD.t3 VDD.n242 0.001
R1294 VDD.n317 VDD.n316 0.001
R1295 VDD.n320 VDD.t32 0.001
R1296 VDD.t0 VDD.n244 0.001
R1297 VDD.n323 VDD.n321 0.001
R1298 VDD.n322 VDD.n245 0.001
R1299 VDD.n325 VDD.n324 0.001
R1300 VDD.t4 VDD.n247 0.001
R1301 VDD.t1 VDD.n566 0.001
R1302 VDD.n327 VDD.n326 0.001
R1303 VDD.t27 VDD.n250 0.001
R1304 VDD.n328 VDD.n284 0.001
R1305 VDD.n284 VDD.n253 0.001
R1306 VDD.n330 VDD.n281 0.001
R1307 VDD.n281 VDD.n256 0.001
R1308 VDD.n278 VDD.n259 0.001
R1309 VDD.n278 VDD.n256 0.001
R1310 VDD.n277 VDD.n253 0.001
R1311 VDD.t19 VDD.n250 0.001
R1312 VDD.n566 VDD.n230 0.001
R1313 VDD.n247 VDD.n246 0.001
R1314 VDD.n324 VDD.n245 0.001
R1315 VDD.n321 VDD.n244 0.001
R1316 VDD.n316 VDD.n242 0.001
R1317 VDD.n313 VDD.n239 0.001
R1318 VDD.n473 VDD.n236 0.001
R1319 VDD.t88 VDD.n259 0.001
R1320 VDD.t28 VDD.n260 0.001
R1321 VDD.n478 VDD.n280 0.001
R1322 VDD.n449 VDD.n342 0.001
R1323 VDD.n451 VDD.n341 0.001
R1324 VDD.n453 VDD.n340 0.001
R1325 VDD.n455 VDD.n339 0.001
R1326 VDD.n403 VDD.n338 0.001
R1327 VDD.n405 VDD.n337 0.001
R1328 VDD.n407 VDD.n336 0.001
R1329 VDD.n476 VDD.n463 0.001
R1330 VDD.n330 VDD.n277 0.001
R1331 VDD.n328 VDD.t19 0.001
R1332 VDD.n327 VDD.n230 0.001
R1333 VDD.n325 VDD.t4 0.001
R1334 VDD.n323 VDD.n322 0.001
R1335 VDD.n320 VDD.t0 0.001
R1336 VDD.n317 VDD.t32 0.001
R1337 VDD.n314 VDD.t3 0.001
R1338 VDD.n474 VDD.n472 0.001
R1339 VDD.n409 VDD.n402 0.001
R1340 VDD.n414 VDD.n413 0.001
R1341 VDD.n417 VDD.n415 0.001
R1342 VDD.n416 VDD.n394 0.001
R1343 VDD.n443 VDD.n442 0.001
R1344 VDD.n445 VDD.n444 0.001
R1345 VDD.n308 VDD.n302 0.001
R1346 VDD.n288 VDD.n218 0.001
R1347 VDD.n567 VDD.n216 0.001
R1348 VDD.n285 VDD.n226 0.001
R1349 VDD.n224 VDD.n208 0.001
R1350 VDD.n223 VDD.n209 0.001
R1351 VDD.n222 VDD.n210 0.001
R1352 VDD.n221 VDD.n211 0.001
R1353 VDD.n220 VDD.n212 0.001
R1354 VDD.n219 VDD.n213 0.001
R1355 VDD.n568 VDD.n567 0.001
R1356 VDD.n218 VDD.n216 0.001
R1357 VDD.n288 VDD.n217 0.001
R1358 VDD.n300 VDD.n299 0.000998489
R1359 VDD.n307 VDD.n303 0.000998489
R1360 VDD.n541 VDD.n490 0.000849873
R1361 VDD.n538 VDD.n503 0.000779898
R1362 RAMP_RESET.n0 RAMP_RESET.t0 12.0858
R1363 RAMP_RESET.n2 RAMP_RESET.t1 12.045
R1364 RAMP_RESET.n1 RAMP_RESET.n0 11.3391
R1365 RAMP_RESET.n0 RAMP_RESET 7.50556
R1366 RAMP_RESET.n1 RAMP_RESET 4.40172
R1367 RAMP_RESET.n3 RAMP_RESET 4.23061
R1368 RAMP_RESET RAMP_RESET.n3 2.01751
R1369 RAMP_RESET.n2 RAMP_RESET.n1 0.0412947
R1370 RAMP_RESET.n3 RAMP_RESET.n2 0.0412947
R1371 VSS.n1044 VSS.n365 46605.6
R1372 VSS.t66 VSS.t3 41241.3
R1373 VSS.n648 VSS.t133 28647
R1374 VSS.n1045 VSS.n1044 25116.9
R1375 VSS.n1044 VSS.n1043 2795.09
R1376 VSS.n1043 VSS.n1042 1242.91
R1377 VSS.n1043 VSS.n784 857.617
R1378 VSS.t57 VSS.n603 855.54
R1379 VSS.n618 VSS.t56 855.529
R1380 VSS.t3 VSS.t72 529.968
R1381 VSS.t63 VSS.t66 529.968
R1382 VSS.n365 VSS.t62 495.413
R1383 VSS.t56 VSS.t60 412.399
R1384 VSS.t60 VSS.t58 412.399
R1385 VSS.t59 VSS.t57 412.399
R1386 VSS.n616 VSS.t59 396.226
R1387 VSS.t133 VSS.n647 362.659
R1388 VSS.t72 VSS.n365 310.411
R1389 VSS.n647 VSS.t63 310.411
R1390 VSS.n365 VSS.t61 275.229
R1391 VSS.n647 VSS.t134 200.245
R1392 VSS.n644 VSS.n481 59.5104
R1393 VSS.n648 VSS.n481 56.0098
R1394 VSS.n703 VSS.n464 56.0098
R1395 VSS.n692 VSS.n463 56.0098
R1396 VSS.n702 VSS.n462 56.0098
R1397 VSS.n717 VSS.n420 56.0098
R1398 VSS.n721 VSS.n419 56.0098
R1399 VSS.n731 VSS.n418 56.0098
R1400 VSS.n492 VSS.n478 54.2595
R1401 VSS.n669 VSS.n475 54.2595
R1402 VSS.n674 VSS.n474 54.2595
R1403 VSS.n768 VSS.n411 54.2595
R1404 VSS.n759 VSS.n410 54.2595
R1405 VSS.n757 VSS.n379 54.2595
R1406 VSS.n651 VSS.t13 50.759
R1407 VSS.t64 VSS.n461 49.8838
R1408 VSS.n1017 VSS.t158 49.8234
R1409 VSS.n340 VSS.t143 49.8234
R1410 VSS.t159 VSS.n473 48.1335
R1411 VSS.n1056 VSS.n1055 47.8304
R1412 VSS.n1008 VSS.n1005 47.1661
R1413 VSS.n784 VSS.n366 45.1732
R1414 VSS.t116 VSS.n220 44.5089
R1415 VSS.n700 VSS.n460 43.7578
R1416 VSS.n697 VSS.n459 43.7578
R1417 VSS.n707 VSS.n628 43.7578
R1418 VSS.n724 VSS.n496 43.7578
R1419 VSS.n729 VSS.n423 43.7578
R1420 VSS.n715 VSS.n422 43.7578
R1421 VSS.n723 VSS.n421 43.7578
R1422 VSS.n655 VSS.n472 42.0075
R1423 VSS.n658 VSS.n468 42.0075
R1424 VSS.n679 VSS.n467 42.0075
R1425 VSS.n626 VSS.n457 42.0075
R1426 VSS.n602 VSS.n455 42.0075
R1427 VSS.n533 VSS.n454 42.0075
R1428 VSS.n600 VSS.n453 42.0075
R1429 VSS.n535 VSS.n452 42.0075
R1430 VSS.n537 VSS.n450 42.0075
R1431 VSS.n596 VSS.n449 42.0075
R1432 VSS.n762 VSS.n738 42.0075
R1433 VSS.n760 VSS.n414 42.0075
R1434 VSS.n765 VSS.n413 42.0075
R1435 VSS.n767 VSS.n412 42.0075
R1436 VSS.n1022 VSS.t137 40.5231
R1437 VSS.t152 VSS.n796 40.5231
R1438 VSS.t153 VSS.n798 40.5231
R1439 VSS.n1011 VSS.t139 40.5231
R1440 VSS.n67 VSS.t97 40.5231
R1441 VSS.n346 VSS.t141 40.5231
R1442 VSS.t149 VSS.n324 40.5231
R1443 VSS.t145 VSS.n326 40.5231
R1444 VSS.n334 VSS.t150 40.5231
R1445 VSS.n409 VSS.n408 39.4405
R1446 VSS.t83 VSS.n456 38.5069
R1447 VSS.n390 VSS.n188 37.2016
R1448 VSS.n189 VSS.n6 37.2016
R1449 VSS.n190 VSS.n9 37.2016
R1450 VSS.n193 VSS.n16 37.2016
R1451 VSS.n196 VSS.n21 37.2016
R1452 VSS.n199 VSS.n28 37.2016
R1453 VSS.n205 VSS.n40 37.2016
R1454 VSS.n208 VSS.n45 37.2016
R1455 VSS.n211 VSS.n52 37.2016
R1456 VSS.n214 VSS.n57 37.2016
R1457 VSS.n217 VSS.n64 37.2016
R1458 VSS.n553 VSS.n433 35.0063
R1459 VSS.n577 VSS.n432 35.0063
R1460 VSS.n575 VSS.n430 35.0063
R1461 VSS.n557 VSS.n429 35.0063
R1462 VSS.n559 VSS.n427 35.0063
R1463 VSS.n571 VSS.n426 35.0063
R1464 VSS.n565 VSS.n497 35.0063
R1465 VSS.n613 VSS.n440 34.1312
R1466 VSS.n612 VSS.n438 34.1312
R1467 VSS.n608 VSS.n437 34.1312
R1468 VSS.n611 VSS.n436 34.1312
R1469 VSS.n609 VSS.n435 34.1312
R1470 VSS.n610 VSS.n434 34.1312
R1471 VSS.n191 VSS.t98 32.5514
R1472 VSS.n194 VSS.t99 32.5514
R1473 VSS.n197 VSS.t107 32.5514
R1474 VSS.n200 VSS.t100 32.5514
R1475 VSS.n203 VSS.t88 32.5514
R1476 VSS.n206 VSS.t101 32.5514
R1477 VSS.n209 VSS.t89 32.5514
R1478 VSS.n212 VSS.t96 32.5514
R1479 VSS.n215 VSS.t90 32.5514
R1480 VSS.n617 VSS.n447 32.3809
R1481 VSS.n604 VSS.n446 32.3809
R1482 VSS.n615 VSS.n445 32.3809
R1483 VSS.n605 VSS.n444 32.3809
R1484 VSS.n614 VSS.n443 32.3809
R1485 VSS.n606 VSS.n442 32.3809
R1486 VSS.t109 VSS.n33 31.8871
R1487 VSS.n598 VSS.t75 29.7555
R1488 VSS.n555 VSS.t80 29.7555
R1489 VSS.t5 VSS.n830 27.9013
R1490 VSS.n278 VSS.t17 27.9013
R1491 VSS.n1022 VSS.t157 27.237
R1492 VSS.t146 VSS.n796 27.237
R1493 VSS.t158 VSS.n798 27.237
R1494 VSS.n1011 VSS.t148 27.237
R1495 VSS.t105 VSS.n13 27.237
R1496 VSS.t92 VSS.n20 27.237
R1497 VSS.t106 VSS.n25 27.237
R1498 VSS.t93 VSS.n32 27.237
R1499 VSS.t102 VSS.n37 27.237
R1500 VSS.t94 VSS.n44 27.237
R1501 VSS.t103 VSS.n49 27.237
R1502 VSS.t95 VSS.n56 27.237
R1503 VSS.t104 VSS.n61 27.237
R1504 VSS.n346 VSS.t155 27.237
R1505 VSS.t143 VSS.n324 27.237
R1506 VSS.t135 VSS.n326 27.237
R1507 VSS.n334 VSS.t156 27.237
R1508 VSS.n221 VSS.n71 26.5727
R1509 VSS.n223 VSS.n75 26.5727
R1510 VSS.n224 VSS.n76 26.5727
R1511 VSS.n226 VSS.n80 26.5727
R1512 VSS.n227 VSS.n83 26.5727
R1513 VSS.n229 VSS.n87 26.5727
R1514 VSS.n230 VSS.n88 26.5727
R1515 VSS.n232 VSS.n92 26.5727
R1516 VSS.n235 VSS.n99 26.5727
R1517 VSS.n236 VSS.n100 26.5727
R1518 VSS.n238 VSS.n104 26.5727
R1519 VSS.n239 VSS.n107 26.5727
R1520 VSS.n241 VSS.n111 26.5727
R1521 VSS.n242 VSS.n112 26.5727
R1522 VSS.n244 VSS.n116 26.5727
R1523 VSS.n245 VSS.n119 26.5727
R1524 VSS.n247 VSS.n123 26.5727
R1525 VSS.n248 VSS.n124 26.5727
R1526 VSS.n250 VSS.n128 26.5727
R1527 VSS.n254 VSS.n131 26.5727
R1528 VSS.n1062 VSS.n132 26.5727
R1529 VSS.t78 VSS.n448 26.2549
R1530 VSS.n585 VSS.t84 26.0062
R1531 VSS.n547 VSS.n440 24.5046
R1532 VSS.n583 VSS.n439 24.5046
R1533 VSS.n549 VSS.n438 24.5046
R1534 VSS.n551 VSS.n436 24.5046
R1535 VSS.n579 VSS.n435 24.5046
R1536 VSS.n577 VSS.n433 24.5046
R1537 VSS.n555 VSS.n432 24.5046
R1538 VSS.n575 VSS.n431 24.5046
R1539 VSS.n557 VSS.n430 24.5046
R1540 VSS.n573 VSS.n429 24.5046
R1541 VSS.n559 VSS.n428 24.5046
R1542 VSS.n571 VSS.n427 24.5046
R1543 VSS.n561 VSS.n426 24.5046
R1544 VSS.n565 VSS.n425 24.5046
R1545 VSS.t79 VSS.n439 22.7543
R1546 VSS.t74 VSS.n437 22.7543
R1547 VSS.n219 VSS.t91 21.9226
R1548 VSS.n222 VSS.t131 21.9226
R1549 VSS.n225 VSS.t120 21.9226
R1550 VSS.n228 VSS.t125 21.9226
R1551 VSS.n231 VSS.t132 21.9226
R1552 VSS.n234 VSS.t121 21.9226
R1553 VSS.n237 VSS.t114 21.9226
R1554 VSS.n240 VSS.t123 21.9226
R1555 VSS.n243 VSS.t115 21.9226
R1556 VSS.n246 VSS.t124 21.9226
R1557 VSS.n249 VSS.t130 21.9226
R1558 VSS.n408 VSS.t9 21.9043
R1559 VSS.n650 VSS.n487 21.6392
R1560 VSS.n683 VSS.n466 21.6392
R1561 VSS.n684 VSS.n466 21.6392
R1562 VSS.n684 VSS.n465 21.6392
R1563 VSS.n737 VSS.n416 21.6392
R1564 VSS.n737 VSS.n415 21.6392
R1565 VSS.n735 VSS.n416 21.6392
R1566 VSS.n650 VSS.n483 21.6392
R1567 VSS.t67 VSS.n95 21.2582
R1568 VSS.t85 VSS.n425 21.004
R1569 VSS.n803 VSS.n802 20.5678
R1570 VSS.n311 VSS.n300 20.5678
R1571 VSS.n331 VSS.n330 20.5678
R1572 VSS.n621 VSS.n620 19.8135
R1573 VSS.n405 VSS.n384 19.4005
R1574 VSS.n1041 VSS.n1040 19.4005
R1575 VSS.n819 VSS.n137 19.4005
R1576 VSS.n821 VSS.n141 19.4005
R1577 VSS.n824 VSS.n143 19.4005
R1578 VSS.n825 VSS.n146 19.4005
R1579 VSS.n826 VSS.n149 19.4005
R1580 VSS.n827 VSS.n152 19.4005
R1581 VSS.n828 VSS.n155 19.4005
R1582 VSS.n829 VSS.n158 19.4005
R1583 VSS.n831 VSS.n164 19.4005
R1584 VSS.n832 VSS.n167 19.4005
R1585 VSS.n833 VSS.n170 19.4005
R1586 VSS.n834 VSS.n173 19.4005
R1587 VSS.n835 VSS.n176 19.4005
R1588 VSS.n836 VSS.n179 19.4005
R1589 VSS.n837 VSS.n182 19.4005
R1590 VSS.n839 VSS.n184 19.4005
R1591 VSS.n840 VSS.n186 19.4005
R1592 VSS.n871 VSS.n259 19.4005
R1593 VSS.n872 VSS.n262 19.4005
R1594 VSS.n873 VSS.n265 19.4005
R1595 VSS.n874 VSS.n268 19.4005
R1596 VSS.n875 VSS.n271 19.4005
R1597 VSS.n876 VSS.n274 19.4005
R1598 VSS.n878 VSS.n281 19.4005
R1599 VSS.n879 VSS.n284 19.4005
R1600 VSS.n880 VSS.n287 19.4005
R1601 VSS.n881 VSS.n290 19.4005
R1602 VSS.n882 VSS.n293 19.4005
R1603 VSS.n883 VSS.n296 19.4005
R1604 VSS.n918 VSS.n298 19.4005
R1605 VSS.n1054 VSS.n1053 19.4005
R1606 VSS.n802 VSS.n800 19.4005
R1607 VSS.n1040 VSS.n793 19.4005
R1608 VSS.n918 VSS.n300 19.4005
R1609 VSS.n883 VSS.n298 19.4005
R1610 VSS.n882 VSS.n296 19.4005
R1611 VSS.n881 VSS.n293 19.4005
R1612 VSS.n880 VSS.n290 19.4005
R1613 VSS.n879 VSS.n287 19.4005
R1614 VSS.n878 VSS.n284 19.4005
R1615 VSS.n877 VSS.n281 19.4005
R1616 VSS.n875 VSS.n274 19.4005
R1617 VSS.n874 VSS.n271 19.4005
R1618 VSS.n873 VSS.n268 19.4005
R1619 VSS.n872 VSS.n265 19.4005
R1620 VSS.n871 VSS.n262 19.4005
R1621 VSS.n259 VSS.n135 19.4005
R1622 VSS.n839 VSS.n186 19.4005
R1623 VSS.n837 VSS.n184 19.4005
R1624 VSS.n836 VSS.n182 19.4005
R1625 VSS.n835 VSS.n179 19.4005
R1626 VSS.n834 VSS.n176 19.4005
R1627 VSS.n833 VSS.n173 19.4005
R1628 VSS.n832 VSS.n170 19.4005
R1629 VSS.n831 VSS.n167 19.4005
R1630 VSS.n829 VSS.n161 19.4005
R1631 VSS.n828 VSS.n158 19.4005
R1632 VSS.n827 VSS.n155 19.4005
R1633 VSS.n826 VSS.n152 19.4005
R1634 VSS.n825 VSS.n149 19.4005
R1635 VSS.n824 VSS.n146 19.4005
R1636 VSS.n821 VSS.n143 19.4005
R1637 VSS.n819 VSS.n141 19.4005
R1638 VSS.n330 VSS.n328 19.4005
R1639 VSS.n1053 VSS.n320 19.4005
R1640 VSS.n405 VSS.n386 19.4005
R1641 VSS.n616 VSS.n588 19.2537
R1642 VSS.t82 VSS.n428 19.2537
R1643 VSS.n619 VSS.t0 19.1936
R1644 VSS.n620 VSS.t2 18.8244
R1645 VSS.n222 VSS.n71 18.601
R1646 VSS.n223 VSS.n72 18.601
R1647 VSS.n225 VSS.n76 18.601
R1648 VSS.n226 VSS.n79 18.601
R1649 VSS.n228 VSS.n83 18.601
R1650 VSS.n229 VSS.n84 18.601
R1651 VSS.n231 VSS.n88 18.601
R1652 VSS.n232 VSS.n91 18.601
R1653 VSS.n234 VSS.n95 18.601
R1654 VSS.n235 VSS.n96 18.601
R1655 VSS.n237 VSS.n100 18.601
R1656 VSS.n238 VSS.n103 18.601
R1657 VSS.n240 VSS.n107 18.601
R1658 VSS.n241 VSS.n108 18.601
R1659 VSS.n243 VSS.n112 18.601
R1660 VSS.n244 VSS.n115 18.601
R1661 VSS.n246 VSS.n119 18.601
R1662 VSS.n247 VSS.n120 18.601
R1663 VSS.n249 VSS.n124 18.601
R1664 VSS.n250 VSS.n127 18.601
R1665 VSS.n254 VSS.n128 18.601
R1666 VSS.n132 VSS.n131 18.601
R1667 VSS.n1062 VSS.n1061 18.601
R1668 VSS.n470 VSS.n469 18.3222
R1669 VSS.t157 VSS.n795 17.9367
R1670 VSS.n1017 VSS.t146 17.9367
R1671 VSS.t148 VSS.n799 17.9367
R1672 VSS.t91 VSS.n68 17.9367
R1673 VSS.t126 VSS.n75 17.9367
R1674 VSS.t113 VSS.n80 17.9367
R1675 VSS.t119 VSS.n87 17.9367
R1676 VSS.t127 VSS.n92 17.9367
R1677 VSS.t122 VSS.n99 17.9367
R1678 VSS.t128 VSS.n104 17.9367
R1679 VSS.t117 VSS.n111 17.9367
R1680 VSS.t129 VSS.n116 17.9367
R1681 VSS.t118 VSS.n123 17.9367
R1682 VSS.t155 VSS.n323 17.9367
R1683 VSS.n340 VSS.t135 17.9367
R1684 VSS.t156 VSS.n327 17.9367
R1685 VSS.n584 VSS.t167 17.7897
R1686 VSS.n655 VSS.n473 17.5034
R1687 VSS.n658 VSS.n472 17.5034
R1688 VSS.n679 VSS.n468 17.5034
R1689 VSS.n627 VSS.n626 17.5034
R1690 VSS.n531 VSS.n457 17.5034
R1691 VSS.n602 VSS.n456 17.5034
R1692 VSS.n533 VSS.n455 17.5034
R1693 VSS.n535 VSS.n453 17.5034
R1694 VSS.n598 VSS.n452 17.5034
R1695 VSS.n537 VSS.n451 17.5034
R1696 VSS.n596 VSS.n450 17.5034
R1697 VSS.n539 VSS.n449 17.5034
R1698 VSS.n594 VSS.n448 17.5034
R1699 VSS.n541 VSS.n447 17.5034
R1700 VSS.n592 VSS.n446 17.5034
R1701 VSS.n543 VSS.n445 17.5034
R1702 VSS.n590 VSS.n444 17.5034
R1703 VSS.n588 VSS.n442 17.5034
R1704 VSS.n762 VSS.n414 17.5034
R1705 VSS.n760 VSS.n413 17.5034
R1706 VSS.n765 VSS.n412 17.5034
R1707 VSS.n564 VSS.t108 17.3848
R1708 VSS.n619 VSS.t1 17.2961
R1709 VSS.n966 VSS.t5 17.2724
R1710 VSS.t17 VSS.n275 17.2724
R1711 VSS.n469 VSS.t163 17.0062
R1712 VSS.n584 VSS.t165 17.0024
R1713 VSS.n919 VSS.t43 17.0005
R1714 VSS.n919 VSS.t55 17.0005
R1715 VSS.n919 VSS.t19 17.0005
R1716 VSS.n919 VSS.t22 17.0005
R1717 VSS.n822 VSS.t48 17.0005
R1718 VSS.n964 VSS.t49 17.0005
R1719 VSS.n822 VSS.t6 17.0005
R1720 VSS.n964 VSS.t7 17.0005
R1721 VSS.n822 VSS.t45 17.0005
R1722 VSS.n964 VSS.t46 17.0005
R1723 VSS.n822 VSS.t51 17.0005
R1724 VSS.n964 VSS.t52 17.0005
R1725 VSS.n942 VSS.t71 17.0005
R1726 VSS.n941 VSS.t68 17.0005
R1727 VSS.n940 VSS.t69 17.0005
R1728 VSS.n939 VSS.t70 17.0005
R1729 VSS.n252 VSS.t42 17.0005
R1730 VSS.n252 VSS.t54 17.0005
R1731 VSS.n252 VSS.t18 17.0005
R1732 VSS.n252 VSS.t21 17.0005
R1733 VSS.n1064 VSS.n130 17.0005
R1734 VSS.n1064 VSS.n131 17.0005
R1735 VSS.n1064 VSS.n129 17.0005
R1736 VSS.n1064 VSS.n128 17.0005
R1737 VSS.n1064 VSS.n126 17.0005
R1738 VSS.n1064 VSS.n127 17.0005
R1739 VSS.n1064 VSS.n125 17.0005
R1740 VSS.n1064 VSS.n124 17.0005
R1741 VSS.n1064 VSS.n122 17.0005
R1742 VSS.n1064 VSS.n123 17.0005
R1743 VSS.n1064 VSS.n121 17.0005
R1744 VSS.n1064 VSS.n120 17.0005
R1745 VSS.n1064 VSS.n118 17.0005
R1746 VSS.n1064 VSS.n119 17.0005
R1747 VSS.n1064 VSS.n117 17.0005
R1748 VSS.n1064 VSS.n116 17.0005
R1749 VSS.n1064 VSS.n114 17.0005
R1750 VSS.n1064 VSS.n115 17.0005
R1751 VSS.n1064 VSS.n113 17.0005
R1752 VSS.n1064 VSS.n112 17.0005
R1753 VSS.n1064 VSS.n110 17.0005
R1754 VSS.n1064 VSS.n111 17.0005
R1755 VSS.n1064 VSS.n109 17.0005
R1756 VSS.n1064 VSS.n108 17.0005
R1757 VSS.n1064 VSS.n106 17.0005
R1758 VSS.n1064 VSS.n107 17.0005
R1759 VSS.n1064 VSS.n105 17.0005
R1760 VSS.n1064 VSS.n104 17.0005
R1761 VSS.n1064 VSS.n102 17.0005
R1762 VSS.n1064 VSS.n103 17.0005
R1763 VSS.n1064 VSS.n101 17.0005
R1764 VSS.n1064 VSS.n100 17.0005
R1765 VSS.n1064 VSS.n98 17.0005
R1766 VSS.n1064 VSS.n99 17.0005
R1767 VSS.n1064 VSS.n97 17.0005
R1768 VSS.n1064 VSS.n96 17.0005
R1769 VSS.n1064 VSS.n94 17.0005
R1770 VSS.n1064 VSS.n95 17.0005
R1771 VSS.n1064 VSS.n93 17.0005
R1772 VSS.n1064 VSS.n92 17.0005
R1773 VSS.n1064 VSS.n90 17.0005
R1774 VSS.n1064 VSS.n91 17.0005
R1775 VSS.n1064 VSS.n89 17.0005
R1776 VSS.n1064 VSS.n88 17.0005
R1777 VSS.n1064 VSS.n86 17.0005
R1778 VSS.n1064 VSS.n87 17.0005
R1779 VSS.n1064 VSS.n85 17.0005
R1780 VSS.n1064 VSS.n84 17.0005
R1781 VSS.n1064 VSS.n82 17.0005
R1782 VSS.n1064 VSS.n83 17.0005
R1783 VSS.n1064 VSS.n81 17.0005
R1784 VSS.n1064 VSS.n80 17.0005
R1785 VSS.n1064 VSS.n78 17.0005
R1786 VSS.n1064 VSS.n79 17.0005
R1787 VSS.n1064 VSS.n77 17.0005
R1788 VSS.n1064 VSS.n76 17.0005
R1789 VSS.n1064 VSS.n74 17.0005
R1790 VSS.n1064 VSS.n75 17.0005
R1791 VSS.n1064 VSS.n73 17.0005
R1792 VSS.n1064 VSS.n72 17.0005
R1793 VSS.n1064 VSS.n70 17.0005
R1794 VSS.n1064 VSS.n71 17.0005
R1795 VSS.n1064 VSS.n69 17.0005
R1796 VSS.n1064 VSS.n68 17.0005
R1797 VSS.n1064 VSS.n67 17.0005
R1798 VSS.n1064 VSS.n65 17.0005
R1799 VSS.n1064 VSS.n63 17.0005
R1800 VSS.n1064 VSS.n64 17.0005
R1801 VSS.n1064 VSS.n62 17.0005
R1802 VSS.n1064 VSS.n61 17.0005
R1803 VSS.n1064 VSS.n59 17.0005
R1804 VSS.n1064 VSS.n60 17.0005
R1805 VSS.n1064 VSS.n58 17.0005
R1806 VSS.n1064 VSS.n57 17.0005
R1807 VSS.n1064 VSS.n55 17.0005
R1808 VSS.n1064 VSS.n56 17.0005
R1809 VSS.n1064 VSS.n54 17.0005
R1810 VSS.n1064 VSS.n53 17.0005
R1811 VSS.n1064 VSS.n51 17.0005
R1812 VSS.n1064 VSS.n52 17.0005
R1813 VSS.n1064 VSS.n50 17.0005
R1814 VSS.n1064 VSS.n49 17.0005
R1815 VSS.n1064 VSS.n47 17.0005
R1816 VSS.n1064 VSS.n48 17.0005
R1817 VSS.n1064 VSS.n46 17.0005
R1818 VSS.n1064 VSS.n45 17.0005
R1819 VSS.n1064 VSS.n43 17.0005
R1820 VSS.n1064 VSS.n44 17.0005
R1821 VSS.n1064 VSS.n42 17.0005
R1822 VSS.n1064 VSS.n41 17.0005
R1823 VSS.n1064 VSS.n39 17.0005
R1824 VSS.n1064 VSS.n40 17.0005
R1825 VSS.n1064 VSS.n38 17.0005
R1826 VSS.n1064 VSS.n37 17.0005
R1827 VSS.n1064 VSS.n35 17.0005
R1828 VSS.n1064 VSS.n36 17.0005
R1829 VSS.n1064 VSS.n34 17.0005
R1830 VSS.n1064 VSS.n33 17.0005
R1831 VSS.n1064 VSS.n31 17.0005
R1832 VSS.n1064 VSS.n32 17.0005
R1833 VSS.n1064 VSS.n30 17.0005
R1834 VSS.n1064 VSS.n29 17.0005
R1835 VSS.n1064 VSS.n27 17.0005
R1836 VSS.n1064 VSS.n28 17.0005
R1837 VSS.n1064 VSS.n26 17.0005
R1838 VSS.n1064 VSS.n25 17.0005
R1839 VSS.n1064 VSS.n23 17.0005
R1840 VSS.n1064 VSS.n24 17.0005
R1841 VSS.n1064 VSS.n22 17.0005
R1842 VSS.n1064 VSS.n21 17.0005
R1843 VSS.n1064 VSS.n19 17.0005
R1844 VSS.n1064 VSS.n20 17.0005
R1845 VSS.n1064 VSS.n18 17.0005
R1846 VSS.n1064 VSS.n17 17.0005
R1847 VSS.n1064 VSS.n15 17.0005
R1848 VSS.n1064 VSS.n16 17.0005
R1849 VSS.n1064 VSS.n14 17.0005
R1850 VSS.n1064 VSS.n13 17.0005
R1851 VSS.n1064 VSS.n11 17.0005
R1852 VSS.n1064 VSS.n12 17.0005
R1853 VSS.n1064 VSS.n10 17.0005
R1854 VSS.n1064 VSS.n9 17.0005
R1855 VSS.n1064 VSS.n7 17.0005
R1856 VSS.n1064 VSS.n6 17.0005
R1857 VSS.n1010 VSS.n792 17.0005
R1858 VSS.n1011 VSS.n792 17.0005
R1859 VSS.n798 VSS.n792 17.0005
R1860 VSS.n1017 VSS.n792 17.0005
R1861 VSS.n796 VSS.n792 17.0005
R1862 VSS.n1022 VSS.n792 17.0005
R1863 VSS.n1039 VSS.n1011 17.0005
R1864 VSS.n1039 VSS.n799 17.0005
R1865 VSS.n1039 VSS.n1016 17.0005
R1866 VSS.n1039 VSS.n798 17.0005
R1867 VSS.n1039 VSS.n1017 17.0005
R1868 VSS.n1039 VSS.n796 17.0005
R1869 VSS.n1039 VSS.n1019 17.0005
R1870 VSS.n1039 VSS.n795 17.0005
R1871 VSS.n1039 VSS.n1022 17.0005
R1872 VSS.n1039 VSS.n794 17.0005
R1873 VSS.n1060 VSS.n297 17.0005
R1874 VSS.n1060 VSS.n294 17.0005
R1875 VSS.n1060 VSS.n292 17.0005
R1876 VSS.n1060 VSS.n291 17.0005
R1877 VSS.n1060 VSS.n289 17.0005
R1878 VSS.n1060 VSS.n288 17.0005
R1879 VSS.n1060 VSS.n286 17.0005
R1880 VSS.n1060 VSS.n285 17.0005
R1881 VSS.n1060 VSS.n283 17.0005
R1882 VSS.n1060 VSS.n282 17.0005
R1883 VSS.n1060 VSS.n280 17.0005
R1884 VSS.n1060 VSS.n279 17.0005
R1885 VSS.n1060 VSS.n277 17.0005
R1886 VSS.n1060 VSS.n278 17.0005
R1887 VSS.n1060 VSS.n276 17.0005
R1888 VSS.n1060 VSS.n275 17.0005
R1889 VSS.n1060 VSS.n273 17.0005
R1890 VSS.n1060 VSS.n272 17.0005
R1891 VSS.n1060 VSS.n270 17.0005
R1892 VSS.n1060 VSS.n269 17.0005
R1893 VSS.n1060 VSS.n267 17.0005
R1894 VSS.n1060 VSS.n266 17.0005
R1895 VSS.n1060 VSS.n264 17.0005
R1896 VSS.n1060 VSS.n263 17.0005
R1897 VSS.n1060 VSS.n261 17.0005
R1898 VSS.n1060 VSS.n260 17.0005
R1899 VSS.n1060 VSS.n258 17.0005
R1900 VSS.n1060 VSS.n257 17.0005
R1901 VSS.n1060 VSS.n256 17.0005
R1902 VSS.n1061 VSS.n1060 17.0005
R1903 VSS.n1060 VSS.n255 17.0005
R1904 VSS.n1060 VSS.n132 17.0005
R1905 VSS.n1060 VSS.n253 17.0005
R1906 VSS.n1060 VSS.n254 17.0005
R1907 VSS.n1060 VSS.n250 17.0005
R1908 VSS.n1060 VSS.n249 17.0005
R1909 VSS.n1060 VSS.n248 17.0005
R1910 VSS.n1060 VSS.n247 17.0005
R1911 VSS.n1060 VSS.n246 17.0005
R1912 VSS.n1060 VSS.n245 17.0005
R1913 VSS.n1060 VSS.n244 17.0005
R1914 VSS.n1060 VSS.n243 17.0005
R1915 VSS.n1060 VSS.n242 17.0005
R1916 VSS.n1060 VSS.n241 17.0005
R1917 VSS.n1060 VSS.n240 17.0005
R1918 VSS.n1060 VSS.n239 17.0005
R1919 VSS.n1060 VSS.n238 17.0005
R1920 VSS.n1060 VSS.n237 17.0005
R1921 VSS.n1060 VSS.n236 17.0005
R1922 VSS.n1060 VSS.n235 17.0005
R1923 VSS.n1060 VSS.n234 17.0005
R1924 VSS.n1060 VSS.n233 17.0005
R1925 VSS.n1060 VSS.n232 17.0005
R1926 VSS.n1060 VSS.n231 17.0005
R1927 VSS.n1060 VSS.n230 17.0005
R1928 VSS.n1060 VSS.n229 17.0005
R1929 VSS.n1060 VSS.n228 17.0005
R1930 VSS.n1060 VSS.n227 17.0005
R1931 VSS.n1060 VSS.n226 17.0005
R1932 VSS.n1060 VSS.n225 17.0005
R1933 VSS.n1060 VSS.n224 17.0005
R1934 VSS.n1060 VSS.n223 17.0005
R1935 VSS.n1060 VSS.n222 17.0005
R1936 VSS.n1060 VSS.n221 17.0005
R1937 VSS.n1060 VSS.n220 17.0005
R1938 VSS.n1060 VSS.n219 17.0005
R1939 VSS.n1060 VSS.n217 17.0005
R1940 VSS.n1060 VSS.n216 17.0005
R1941 VSS.n1060 VSS.n215 17.0005
R1942 VSS.n1060 VSS.n214 17.0005
R1943 VSS.n1060 VSS.n213 17.0005
R1944 VSS.n1060 VSS.n212 17.0005
R1945 VSS.n1060 VSS.n211 17.0005
R1946 VSS.n1060 VSS.n210 17.0005
R1947 VSS.n1060 VSS.n209 17.0005
R1948 VSS.n1060 VSS.n208 17.0005
R1949 VSS.n1060 VSS.n207 17.0005
R1950 VSS.n1060 VSS.n206 17.0005
R1951 VSS.n1060 VSS.n205 17.0005
R1952 VSS.n1060 VSS.n204 17.0005
R1953 VSS.n1060 VSS.n203 17.0005
R1954 VSS.n1060 VSS.n202 17.0005
R1955 VSS.n1060 VSS.n201 17.0005
R1956 VSS.n1060 VSS.n200 17.0005
R1957 VSS.n1060 VSS.n199 17.0005
R1958 VSS.n1060 VSS.n198 17.0005
R1959 VSS.n1060 VSS.n197 17.0005
R1960 VSS.n1060 VSS.n196 17.0005
R1961 VSS.n1060 VSS.n195 17.0005
R1962 VSS.n1060 VSS.n194 17.0005
R1963 VSS.n1060 VSS.n193 17.0005
R1964 VSS.n1060 VSS.n192 17.0005
R1965 VSS.n1060 VSS.n191 17.0005
R1966 VSS.n1060 VSS.n190 17.0005
R1967 VSS.n1060 VSS.n189 17.0005
R1968 VSS.n1060 VSS.n188 17.0005
R1969 VSS.n1060 VSS.n187 17.0005
R1970 VSS.n1060 VSS.n183 17.0005
R1971 VSS.n1060 VSS.n180 17.0005
R1972 VSS.n1060 VSS.n178 17.0005
R1973 VSS.n1060 VSS.n177 17.0005
R1974 VSS.n1060 VSS.n175 17.0005
R1975 VSS.n1060 VSS.n174 17.0005
R1976 VSS.n1060 VSS.n172 17.0005
R1977 VSS.n1060 VSS.n171 17.0005
R1978 VSS.n1060 VSS.n169 17.0005
R1979 VSS.n1060 VSS.n168 17.0005
R1980 VSS.n1060 VSS.n166 17.0005
R1981 VSS.n1060 VSS.n165 17.0005
R1982 VSS.n1060 VSS.n163 17.0005
R1983 VSS.n1060 VSS.n162 17.0005
R1984 VSS.n1060 VSS.n160 17.0005
R1985 VSS.n1060 VSS.n159 17.0005
R1986 VSS.n1060 VSS.n157 17.0005
R1987 VSS.n1060 VSS.n156 17.0005
R1988 VSS.n1060 VSS.n154 17.0005
R1989 VSS.n1060 VSS.n153 17.0005
R1990 VSS.n1060 VSS.n151 17.0005
R1991 VSS.n1060 VSS.n150 17.0005
R1992 VSS.n1060 VSS.n148 17.0005
R1993 VSS.n1060 VSS.n147 17.0005
R1994 VSS.n1060 VSS.n145 17.0005
R1995 VSS.n1060 VSS.n144 17.0005
R1996 VSS.n1060 VSS.n142 17.0005
R1997 VSS.n1060 VSS.n139 17.0005
R1998 VSS.n1003 VSS.n920 17.0005
R1999 VSS.n1003 VSS.n917 17.0005
R2000 VSS.n1003 VSS.n294 17.0005
R2001 VSS.n1003 VSS.n292 17.0005
R2002 VSS.n1003 VSS.n291 17.0005
R2003 VSS.n1003 VSS.n289 17.0005
R2004 VSS.n1003 VSS.n288 17.0005
R2005 VSS.n1003 VSS.n286 17.0005
R2006 VSS.n1003 VSS.n285 17.0005
R2007 VSS.n1003 VSS.n283 17.0005
R2008 VSS.n1003 VSS.n282 17.0005
R2009 VSS.n1003 VSS.n280 17.0005
R2010 VSS.n1003 VSS.n279 17.0005
R2011 VSS.n1003 VSS.n277 17.0005
R2012 VSS.n1003 VSS.n276 17.0005
R2013 VSS.n1003 VSS.n273 17.0005
R2014 VSS.n1003 VSS.n272 17.0005
R2015 VSS.n1003 VSS.n270 17.0005
R2016 VSS.n1003 VSS.n269 17.0005
R2017 VSS.n1003 VSS.n267 17.0005
R2018 VSS.n1003 VSS.n266 17.0005
R2019 VSS.n1003 VSS.n264 17.0005
R2020 VSS.n1003 VSS.n263 17.0005
R2021 VSS.n1003 VSS.n261 17.0005
R2022 VSS.n1003 VSS.n260 17.0005
R2023 VSS.n1003 VSS.n258 17.0005
R2024 VSS.n1003 VSS.n257 17.0005
R2025 VSS.n1003 VSS.n256 17.0005
R2026 VSS.n1003 VSS.n255 17.0005
R2027 VSS.n1003 VSS.n132 17.0005
R2028 VSS.n1003 VSS.n253 17.0005
R2029 VSS.n1003 VSS.n254 17.0005
R2030 VSS.n1003 VSS.n922 17.0005
R2031 VSS.n1003 VSS.n250 17.0005
R2032 VSS.n1003 VSS.n870 17.0005
R2033 VSS.n1003 VSS.n249 17.0005
R2034 VSS.n1003 VSS.n923 17.0005
R2035 VSS.n1003 VSS.n248 17.0005
R2036 VSS.n1003 VSS.n869 17.0005
R2037 VSS.n1003 VSS.n247 17.0005
R2038 VSS.n1003 VSS.n924 17.0005
R2039 VSS.n1003 VSS.n246 17.0005
R2040 VSS.n1003 VSS.n868 17.0005
R2041 VSS.n1003 VSS.n245 17.0005
R2042 VSS.n1003 VSS.n925 17.0005
R2043 VSS.n1003 VSS.n244 17.0005
R2044 VSS.n1003 VSS.n867 17.0005
R2045 VSS.n1003 VSS.n243 17.0005
R2046 VSS.n1003 VSS.n926 17.0005
R2047 VSS.n1003 VSS.n242 17.0005
R2048 VSS.n1003 VSS.n866 17.0005
R2049 VSS.n1003 VSS.n241 17.0005
R2050 VSS.n1003 VSS.n927 17.0005
R2051 VSS.n1003 VSS.n240 17.0005
R2052 VSS.n1003 VSS.n865 17.0005
R2053 VSS.n1003 VSS.n239 17.0005
R2054 VSS.n1003 VSS.n928 17.0005
R2055 VSS.n1003 VSS.n238 17.0005
R2056 VSS.n1003 VSS.n864 17.0005
R2057 VSS.n1003 VSS.n237 17.0005
R2058 VSS.n1003 VSS.n929 17.0005
R2059 VSS.n1003 VSS.n236 17.0005
R2060 VSS.n1003 VSS.n863 17.0005
R2061 VSS.n1003 VSS.n235 17.0005
R2062 VSS.n1003 VSS.n930 17.0005
R2063 VSS.n1003 VSS.n234 17.0005
R2064 VSS.n1003 VSS.n862 17.0005
R2065 VSS.n1003 VSS.n233 17.0005
R2066 VSS.n1003 VSS.n931 17.0005
R2067 VSS.n1003 VSS.n232 17.0005
R2068 VSS.n1003 VSS.n861 17.0005
R2069 VSS.n1003 VSS.n231 17.0005
R2070 VSS.n1003 VSS.n932 17.0005
R2071 VSS.n1003 VSS.n230 17.0005
R2072 VSS.n1003 VSS.n860 17.0005
R2073 VSS.n1003 VSS.n229 17.0005
R2074 VSS.n1003 VSS.n933 17.0005
R2075 VSS.n1003 VSS.n228 17.0005
R2076 VSS.n1003 VSS.n859 17.0005
R2077 VSS.n1003 VSS.n227 17.0005
R2078 VSS.n1003 VSS.n934 17.0005
R2079 VSS.n1003 VSS.n226 17.0005
R2080 VSS.n1003 VSS.n858 17.0005
R2081 VSS.n1003 VSS.n225 17.0005
R2082 VSS.n1003 VSS.n935 17.0005
R2083 VSS.n1003 VSS.n224 17.0005
R2084 VSS.n1003 VSS.n857 17.0005
R2085 VSS.n1003 VSS.n223 17.0005
R2086 VSS.n1003 VSS.n936 17.0005
R2087 VSS.n1003 VSS.n222 17.0005
R2088 VSS.n1003 VSS.n221 17.0005
R2089 VSS.n1003 VSS.n220 17.0005
R2090 VSS.n1003 VSS.n856 17.0005
R2091 VSS.n1003 VSS.n219 17.0005
R2092 VSS.n1003 VSS.n944 17.0005
R2093 VSS.n1003 VSS.n217 17.0005
R2094 VSS.n1003 VSS.n855 17.0005
R2095 VSS.n1003 VSS.n216 17.0005
R2096 VSS.n1003 VSS.n945 17.0005
R2097 VSS.n1003 VSS.n215 17.0005
R2098 VSS.n1003 VSS.n854 17.0005
R2099 VSS.n1003 VSS.n214 17.0005
R2100 VSS.n1003 VSS.n946 17.0005
R2101 VSS.n1003 VSS.n213 17.0005
R2102 VSS.n1003 VSS.n853 17.0005
R2103 VSS.n1003 VSS.n212 17.0005
R2104 VSS.n1003 VSS.n947 17.0005
R2105 VSS.n1003 VSS.n211 17.0005
R2106 VSS.n1003 VSS.n852 17.0005
R2107 VSS.n1003 VSS.n210 17.0005
R2108 VSS.n1003 VSS.n948 17.0005
R2109 VSS.n1003 VSS.n209 17.0005
R2110 VSS.n1003 VSS.n851 17.0005
R2111 VSS.n1003 VSS.n208 17.0005
R2112 VSS.n1003 VSS.n949 17.0005
R2113 VSS.n1003 VSS.n207 17.0005
R2114 VSS.n1003 VSS.n850 17.0005
R2115 VSS.n1003 VSS.n206 17.0005
R2116 VSS.n1003 VSS.n950 17.0005
R2117 VSS.n1003 VSS.n205 17.0005
R2118 VSS.n1003 VSS.n849 17.0005
R2119 VSS.n1003 VSS.n204 17.0005
R2120 VSS.n1003 VSS.n951 17.0005
R2121 VSS.n1003 VSS.n203 17.0005
R2122 VSS.n1003 VSS.n848 17.0005
R2123 VSS.n1003 VSS.n202 17.0005
R2124 VSS.n1003 VSS.n952 17.0005
R2125 VSS.n1003 VSS.n201 17.0005
R2126 VSS.n1003 VSS.n847 17.0005
R2127 VSS.n1003 VSS.n200 17.0005
R2128 VSS.n1003 VSS.n953 17.0005
R2129 VSS.n1003 VSS.n199 17.0005
R2130 VSS.n1003 VSS.n846 17.0005
R2131 VSS.n1003 VSS.n198 17.0005
R2132 VSS.n1003 VSS.n954 17.0005
R2133 VSS.n1003 VSS.n197 17.0005
R2134 VSS.n1003 VSS.n845 17.0005
R2135 VSS.n1003 VSS.n196 17.0005
R2136 VSS.n1003 VSS.n955 17.0005
R2137 VSS.n1003 VSS.n195 17.0005
R2138 VSS.n1003 VSS.n844 17.0005
R2139 VSS.n1003 VSS.n194 17.0005
R2140 VSS.n1003 VSS.n956 17.0005
R2141 VSS.n1003 VSS.n193 17.0005
R2142 VSS.n1003 VSS.n843 17.0005
R2143 VSS.n1003 VSS.n192 17.0005
R2144 VSS.n1003 VSS.n957 17.0005
R2145 VSS.n1003 VSS.n191 17.0005
R2146 VSS.n1003 VSS.n842 17.0005
R2147 VSS.n1003 VSS.n190 17.0005
R2148 VSS.n1003 VSS.n958 17.0005
R2149 VSS.n1003 VSS.n189 17.0005
R2150 VSS.n1003 VSS.n841 17.0005
R2151 VSS.n1003 VSS.n188 17.0005
R2152 VSS.n1003 VSS.n960 17.0005
R2153 VSS.n1003 VSS.n183 17.0005
R2154 VSS.n1003 VSS.n965 17.0005
R2155 VSS.n1003 VSS.n838 17.0005
R2156 VSS.n1003 VSS.n180 17.0005
R2157 VSS.n1003 VSS.n178 17.0005
R2158 VSS.n1003 VSS.n177 17.0005
R2159 VSS.n1003 VSS.n175 17.0005
R2160 VSS.n1003 VSS.n174 17.0005
R2161 VSS.n1003 VSS.n172 17.0005
R2162 VSS.n1003 VSS.n171 17.0005
R2163 VSS.n1003 VSS.n169 17.0005
R2164 VSS.n1003 VSS.n168 17.0005
R2165 VSS.n1003 VSS.n166 17.0005
R2166 VSS.n1003 VSS.n165 17.0005
R2167 VSS.n1003 VSS.n163 17.0005
R2168 VSS.n1003 VSS.n162 17.0005
R2169 VSS.n1003 VSS.n966 17.0005
R2170 VSS.n1003 VSS.n160 17.0005
R2171 VSS.n1003 VSS.n830 17.0005
R2172 VSS.n1003 VSS.n159 17.0005
R2173 VSS.n1003 VSS.n157 17.0005
R2174 VSS.n1003 VSS.n156 17.0005
R2175 VSS.n1003 VSS.n154 17.0005
R2176 VSS.n1003 VSS.n153 17.0005
R2177 VSS.n1003 VSS.n151 17.0005
R2178 VSS.n1003 VSS.n150 17.0005
R2179 VSS.n1003 VSS.n148 17.0005
R2180 VSS.n1003 VSS.n147 17.0005
R2181 VSS.n1003 VSS.n145 17.0005
R2182 VSS.n1003 VSS.n144 17.0005
R2183 VSS.n1003 VSS.n142 17.0005
R2184 VSS.n1003 VSS.n996 17.0005
R2185 VSS.n1003 VSS.n823 17.0005
R2186 VSS.n1003 VSS.n1002 17.0005
R2187 VSS.n333 VSS.n319 17.0005
R2188 VSS.n334 VSS.n319 17.0005
R2189 VSS.n326 VSS.n319 17.0005
R2190 VSS.n340 VSS.n319 17.0005
R2191 VSS.n324 VSS.n319 17.0005
R2192 VSS.n346 VSS.n319 17.0005
R2193 VSS.n1052 VSS.n334 17.0005
R2194 VSS.n1052 VSS.n327 17.0005
R2195 VSS.n1052 VSS.n339 17.0005
R2196 VSS.n1052 VSS.n326 17.0005
R2197 VSS.n1052 VSS.n340 17.0005
R2198 VSS.n1052 VSS.n324 17.0005
R2199 VSS.n1052 VSS.n342 17.0005
R2200 VSS.n1052 VSS.n323 17.0005
R2201 VSS.n1052 VSS.n346 17.0005
R2202 VSS.n1052 VSS.n322 17.0005
R2203 VSS.n1052 VSS.n1051 17.0005
R2204 VSS.n779 VSS.n411 17.0005
R2205 VSS.n779 VSS.n412 17.0005
R2206 VSS.n779 VSS.n413 17.0005
R2207 VSS.n779 VSS.n414 17.0005
R2208 VSS.n779 VSS.n417 17.0005
R2209 VSS.n779 VSS.n418 17.0005
R2210 VSS.n779 VSS.n419 17.0005
R2211 VSS.n779 VSS.n420 17.0005
R2212 VSS.n779 VSS.n421 17.0005
R2213 VSS.n779 VSS.n422 17.0005
R2214 VSS.n779 VSS.n423 17.0005
R2215 VSS.n779 VSS.n425 17.0005
R2216 VSS.n779 VSS.n426 17.0005
R2217 VSS.n779 VSS.n427 17.0005
R2218 VSS.n779 VSS.n428 17.0005
R2219 VSS.n779 VSS.n429 17.0005
R2220 VSS.n779 VSS.n430 17.0005
R2221 VSS.n779 VSS.n431 17.0005
R2222 VSS.n779 VSS.n432 17.0005
R2223 VSS.n779 VSS.n433 17.0005
R2224 VSS.n779 VSS.n434 17.0005
R2225 VSS.n779 VSS.n435 17.0005
R2226 VSS.n779 VSS.n436 17.0005
R2227 VSS.n779 VSS.n437 17.0005
R2228 VSS.n779 VSS.n438 17.0005
R2229 VSS.n779 VSS.n439 17.0005
R2230 VSS.n779 VSS.n440 17.0005
R2231 VSS.n779 VSS.n442 17.0005
R2232 VSS.n779 VSS.n443 17.0005
R2233 VSS.n779 VSS.n444 17.0005
R2234 VSS.n779 VSS.n445 17.0005
R2235 VSS.n779 VSS.n446 17.0005
R2236 VSS.n779 VSS.n447 17.0005
R2237 VSS.n779 VSS.n448 17.0005
R2238 VSS.n779 VSS.n449 17.0005
R2239 VSS.n779 VSS.n450 17.0005
R2240 VSS.n779 VSS.n451 17.0005
R2241 VSS.n779 VSS.n452 17.0005
R2242 VSS.n779 VSS.n453 17.0005
R2243 VSS.n779 VSS.n454 17.0005
R2244 VSS.n779 VSS.n455 17.0005
R2245 VSS.n779 VSS.n456 17.0005
R2246 VSS.n779 VSS.n457 17.0005
R2247 VSS.n779 VSS.n459 17.0005
R2248 VSS.n779 VSS.n460 17.0005
R2249 VSS.n779 VSS.n461 17.0005
R2250 VSS.n779 VSS.n462 17.0005
R2251 VSS.n779 VSS.n463 17.0005
R2252 VSS.n779 VSS.n464 17.0005
R2253 VSS.n779 VSS.n467 17.0005
R2254 VSS.n779 VSS.n468 17.0005
R2255 VSS.n779 VSS.n472 17.0005
R2256 VSS.n779 VSS.n473 17.0005
R2257 VSS.n779 VSS.n474 17.0005
R2258 VSS.n618 VSS.n610 17.0005
R2259 VSS.n618 VSS.n609 17.0005
R2260 VSS.n618 VSS.n611 17.0005
R2261 VSS.n618 VSS.n608 17.0005
R2262 VSS.n618 VSS.n612 17.0005
R2263 VSS.n618 VSS.n607 17.0005
R2264 VSS.n618 VSS.n613 17.0005
R2265 VSS.n618 VSS.n606 17.0005
R2266 VSS.n618 VSS.n614 17.0005
R2267 VSS.n618 VSS.n605 17.0005
R2268 VSS.n618 VSS.n615 17.0005
R2269 VSS.n618 VSS.n604 17.0005
R2270 VSS.n618 VSS.n617 17.0005
R2271 VSS.n484 VSS.t14 17.0005
R2272 VSS.n484 VSS.t33 17.0005
R2273 VSS.n484 VSS.t27 17.0005
R2274 VSS.n484 VSS.t39 17.0005
R2275 VSS.n775 VSS.n489 17.0005
R2276 VSS.n775 VSS.n491 17.0005
R2277 VSS.n775 VSS.n488 17.0005
R2278 VSS.n775 VSS.n651 17.0005
R2279 VSS.n775 VSS.n486 17.0005
R2280 VSS.n775 VSS.n485 17.0005
R2281 VSS.n775 VSS.n649 17.0005
R2282 VSS.n775 VSS.n481 17.0005
R2283 VSS.n779 VSS.n489 17.0005
R2284 VSS.n779 VSS.n488 17.0005
R2285 VSS.n779 VSS.n486 17.0005
R2286 VSS.n779 VSS.n485 17.0005
R2287 VSS.n779 VSS.n482 17.0005
R2288 VSS.n779 VSS.n481 17.0005
R2289 VSS.n672 VSS.t15 17.0005
R2290 VSS.n672 VSS.t34 17.0005
R2291 VSS.n672 VSS.t28 17.0005
R2292 VSS.n672 VSS.t40 17.0005
R2293 VSS.n775 VSS.n476 17.0005
R2294 VSS.n775 VSS.n475 17.0005
R2295 VSS.n775 VSS.n477 17.0005
R2296 VSS.n775 VSS.n478 17.0005
R2297 VSS.n775 VSS.n490 17.0005
R2298 VSS.n776 VSS.n775 17.0005
R2299 VSS.n779 VSS.n476 17.0005
R2300 VSS.n779 VSS.n475 17.0005
R2301 VSS.n779 VSS.n477 17.0005
R2302 VSS.n779 VSS.n478 17.0005
R2303 VSS.n779 VSS.n490 17.0005
R2304 VSS.n678 VSS.n673 17.0005
R2305 VSS.n678 VSS.n674 17.0005
R2306 VSS.n678 VSS.n670 17.0005
R2307 VSS.n678 VSS.n669 17.0005
R2308 VSS.n775 VSS.n690 17.0005
R2309 VSS.n775 VSS.n460 17.0005
R2310 VSS.n775 VSS.n689 17.0005
R2311 VSS.n775 VSS.n461 17.0005
R2312 VSS.n775 VSS.n688 17.0005
R2313 VSS.n775 VSS.n462 17.0005
R2314 VSS.n775 VSS.n687 17.0005
R2315 VSS.n775 VSS.n463 17.0005
R2316 VSS.n775 VSS.n686 17.0005
R2317 VSS.n775 VSS.n464 17.0005
R2318 VSS.n775 VSS.n685 17.0005
R2319 VSS.n775 VSS.n654 17.0005
R2320 VSS.n775 VSS.n468 17.0005
R2321 VSS.n775 VSS.n653 17.0005
R2322 VSS.n775 VSS.n472 17.0005
R2323 VSS.n775 VSS.n652 17.0005
R2324 VSS.n775 VSS.n473 17.0005
R2325 VSS.n775 VSS.n629 17.0005
R2326 VSS.n775 VSS.n474 17.0005
R2327 VSS.n678 VSS.n657 17.0005
R2328 VSS.n678 VSS.n658 17.0005
R2329 VSS.n678 VSS.n656 17.0005
R2330 VSS.n678 VSS.n655 17.0005
R2331 VSS.n678 VSS.n676 17.0005
R2332 VSS.n678 VSS.n677 17.0005
R2333 VSS.n706 VSS.n698 17.0005
R2334 VSS.n706 VSS.n697 17.0005
R2335 VSS.n706 VSS.n699 17.0005
R2336 VSS.n706 VSS.n700 17.0005
R2337 VSS.n706 VSS.n696 17.0005
R2338 VSS.n706 VSS.n694 17.0005
R2339 VSS.n706 VSS.n701 17.0005
R2340 VSS.n706 VSS.n702 17.0005
R2341 VSS.n706 VSS.n693 17.0005
R2342 VSS.n706 VSS.n692 17.0005
R2343 VSS.n775 VSS.n494 17.0005
R2344 VSS.n775 VSS.n423 17.0005
R2345 VSS.n775 VSS.n496 17.0005
R2346 VSS.n775 VSS.n497 17.0005
R2347 VSS.n775 VSS.n498 17.0005
R2348 VSS.n775 VSS.n425 17.0005
R2349 VSS.n775 VSS.n499 17.0005
R2350 VSS.n775 VSS.n426 17.0005
R2351 VSS.n775 VSS.n500 17.0005
R2352 VSS.n775 VSS.n427 17.0005
R2353 VSS.n775 VSS.n501 17.0005
R2354 VSS.n775 VSS.n428 17.0005
R2355 VSS.n775 VSS.n502 17.0005
R2356 VSS.n775 VSS.n429 17.0005
R2357 VSS.n775 VSS.n503 17.0005
R2358 VSS.n775 VSS.n430 17.0005
R2359 VSS.n775 VSS.n504 17.0005
R2360 VSS.n775 VSS.n431 17.0005
R2361 VSS.n775 VSS.n505 17.0005
R2362 VSS.n775 VSS.n432 17.0005
R2363 VSS.n775 VSS.n506 17.0005
R2364 VSS.n775 VSS.n433 17.0005
R2365 VSS.n775 VSS.n507 17.0005
R2366 VSS.n775 VSS.n434 17.0005
R2367 VSS.n775 VSS.n508 17.0005
R2368 VSS.n775 VSS.n435 17.0005
R2369 VSS.n775 VSS.n509 17.0005
R2370 VSS.n775 VSS.n436 17.0005
R2371 VSS.n775 VSS.n510 17.0005
R2372 VSS.n775 VSS.n437 17.0005
R2373 VSS.n775 VSS.n511 17.0005
R2374 VSS.n775 VSS.n438 17.0005
R2375 VSS.n775 VSS.n512 17.0005
R2376 VSS.n775 VSS.n439 17.0005
R2377 VSS.n775 VSS.n513 17.0005
R2378 VSS.n775 VSS.n440 17.0005
R2379 VSS.n775 VSS.n514 17.0005
R2380 VSS.n775 VSS.n442 17.0005
R2381 VSS.n775 VSS.n515 17.0005
R2382 VSS.n775 VSS.n443 17.0005
R2383 VSS.n775 VSS.n516 17.0005
R2384 VSS.n775 VSS.n444 17.0005
R2385 VSS.n775 VSS.n517 17.0005
R2386 VSS.n775 VSS.n445 17.0005
R2387 VSS.n775 VSS.n518 17.0005
R2388 VSS.n775 VSS.n446 17.0005
R2389 VSS.n775 VSS.n519 17.0005
R2390 VSS.n775 VSS.n447 17.0005
R2391 VSS.n775 VSS.n520 17.0005
R2392 VSS.n775 VSS.n448 17.0005
R2393 VSS.n775 VSS.n521 17.0005
R2394 VSS.n775 VSS.n449 17.0005
R2395 VSS.n775 VSS.n522 17.0005
R2396 VSS.n775 VSS.n450 17.0005
R2397 VSS.n775 VSS.n523 17.0005
R2398 VSS.n775 VSS.n451 17.0005
R2399 VSS.n775 VSS.n524 17.0005
R2400 VSS.n775 VSS.n452 17.0005
R2401 VSS.n775 VSS.n525 17.0005
R2402 VSS.n775 VSS.n453 17.0005
R2403 VSS.n775 VSS.n526 17.0005
R2404 VSS.n775 VSS.n454 17.0005
R2405 VSS.n775 VSS.n527 17.0005
R2406 VSS.n775 VSS.n455 17.0005
R2407 VSS.n775 VSS.n528 17.0005
R2408 VSS.n775 VSS.n456 17.0005
R2409 VSS.n775 VSS.n529 17.0005
R2410 VSS.n775 VSS.n457 17.0005
R2411 VSS.n775 VSS.n627 17.0005
R2412 VSS.n775 VSS.n628 17.0005
R2413 VSS.n775 VSS.n710 17.0005
R2414 VSS.n775 VSS.n459 17.0005
R2415 VSS.n625 VSS.n569 17.0005
R2416 VSS.n625 VSS.n562 17.0005
R2417 VSS.n625 VSS.n561 17.0005
R2418 VSS.n625 VSS.n570 17.0005
R2419 VSS.n625 VSS.n571 17.0005
R2420 VSS.n625 VSS.n560 17.0005
R2421 VSS.n625 VSS.n559 17.0005
R2422 VSS.n625 VSS.n572 17.0005
R2423 VSS.n625 VSS.n573 17.0005
R2424 VSS.n625 VSS.n558 17.0005
R2425 VSS.n625 VSS.n557 17.0005
R2426 VSS.n625 VSS.n574 17.0005
R2427 VSS.n625 VSS.n575 17.0005
R2428 VSS.n625 VSS.n556 17.0005
R2429 VSS.n625 VSS.n555 17.0005
R2430 VSS.n625 VSS.n576 17.0005
R2431 VSS.n625 VSS.n577 17.0005
R2432 VSS.n625 VSS.n554 17.0005
R2433 VSS.n625 VSS.n553 17.0005
R2434 VSS.n625 VSS.n578 17.0005
R2435 VSS.n625 VSS.n579 17.0005
R2436 VSS.n625 VSS.n552 17.0005
R2437 VSS.n625 VSS.n551 17.0005
R2438 VSS.n625 VSS.n580 17.0005
R2439 VSS.n625 VSS.n581 17.0005
R2440 VSS.n625 VSS.n550 17.0005
R2441 VSS.n625 VSS.n549 17.0005
R2442 VSS.n625 VSS.n582 17.0005
R2443 VSS.n625 VSS.n583 17.0005
R2444 VSS.n625 VSS.n548 17.0005
R2445 VSS.n625 VSS.n547 17.0005
R2446 VSS.n625 VSS.n587 17.0005
R2447 VSS.n625 VSS.n588 17.0005
R2448 VSS.n625 VSS.n546 17.0005
R2449 VSS.n625 VSS.n545 17.0005
R2450 VSS.n625 VSS.n589 17.0005
R2451 VSS.n625 VSS.n590 17.0005
R2452 VSS.n625 VSS.n544 17.0005
R2453 VSS.n625 VSS.n543 17.0005
R2454 VSS.n625 VSS.n591 17.0005
R2455 VSS.n625 VSS.n592 17.0005
R2456 VSS.n625 VSS.n542 17.0005
R2457 VSS.n625 VSS.n541 17.0005
R2458 VSS.n625 VSS.n593 17.0005
R2459 VSS.n625 VSS.n594 17.0005
R2460 VSS.n625 VSS.n540 17.0005
R2461 VSS.n625 VSS.n539 17.0005
R2462 VSS.n625 VSS.n595 17.0005
R2463 VSS.n625 VSS.n596 17.0005
R2464 VSS.n625 VSS.n538 17.0005
R2465 VSS.n625 VSS.n537 17.0005
R2466 VSS.n625 VSS.n597 17.0005
R2467 VSS.n625 VSS.n598 17.0005
R2468 VSS.n625 VSS.n536 17.0005
R2469 VSS.n625 VSS.n535 17.0005
R2470 VSS.n625 VSS.n599 17.0005
R2471 VSS.n625 VSS.n600 17.0005
R2472 VSS.n625 VSS.n534 17.0005
R2473 VSS.n625 VSS.n533 17.0005
R2474 VSS.n625 VSS.n601 17.0005
R2475 VSS.n625 VSS.n602 17.0005
R2476 VSS.n625 VSS.n532 17.0005
R2477 VSS.n625 VSS.n531 17.0005
R2478 VSS.n775 VSS.n774 17.0005
R2479 VSS.n775 VSS.n411 17.0005
R2480 VSS.n775 VSS.n741 17.0005
R2481 VSS.n775 VSS.n412 17.0005
R2482 VSS.n775 VSS.n740 17.0005
R2483 VSS.n775 VSS.n413 17.0005
R2484 VSS.n775 VSS.n739 17.0005
R2485 VSS.n775 VSS.n414 17.0005
R2486 VSS.n775 VSS.n738 17.0005
R2487 VSS.n775 VSS.n734 17.0005
R2488 VSS.n775 VSS.n714 17.0005
R2489 VSS.n775 VSS.n418 17.0005
R2490 VSS.n775 VSS.n713 17.0005
R2491 VSS.n775 VSS.n419 17.0005
R2492 VSS.n775 VSS.n712 17.0005
R2493 VSS.n775 VSS.n420 17.0005
R2494 VSS.n775 VSS.n711 17.0005
R2495 VSS.n775 VSS.n421 17.0005
R2496 VSS.n775 VSS.n493 17.0005
R2497 VSS.n775 VSS.n422 17.0005
R2498 VSS.n730 VSS.n720 17.0005
R2499 VSS.n730 VSS.n721 17.0005
R2500 VSS.n730 VSS.n719 17.0005
R2501 VSS.n730 VSS.n717 17.0005
R2502 VSS.n730 VSS.n722 17.0005
R2503 VSS.n730 VSS.n723 17.0005
R2504 VSS.n730 VSS.n716 17.0005
R2505 VSS.n730 VSS.n715 17.0005
R2506 VSS.n730 VSS.n728 17.0005
R2507 VSS.n730 VSS.n729 17.0005
R2508 VSS.n769 VSS.n742 17.0005
R2509 VSS.n769 VSS.n767 17.0005
R2510 VSS.n769 VSS.n766 17.0005
R2511 VSS.n769 VSS.n765 17.0005
R2512 VSS.n769 VSS.n761 17.0005
R2513 VSS.n769 VSS.n760 17.0005
R2514 VSS.n750 VSS.t10 17.0005
R2515 VSS.n748 VSS.t30 17.0005
R2516 VSS.n743 VSS.t24 17.0005
R2517 VSS.n754 VSS.t36 17.0005
R2518 VSS.n782 VSS.n377 17.0005
R2519 VSS.n782 VSS.n379 17.0005
R2520 VSS.n775 VSS.n410 17.0005
R2521 VSS.n779 VSS.n379 17.0005
R2522 VSS.n779 VSS.n410 17.0005
R2523 VSS.n769 VSS.n759 17.0005
R2524 VSS.n769 VSS.n768 17.0005
R2525 VSS.n406 VSS.t11 17.0005
R2526 VSS.n406 VSS.t31 17.0005
R2527 VSS.n406 VSS.t25 17.0005
R2528 VSS.n406 VSS.t37 17.0005
R2529 VSS.n782 VSS.n383 17.0005
R2530 VSS.n782 VSS.n382 17.0005
R2531 VSS.n782 VSS.n380 17.0005
R2532 VSS.n782 VSS.n381 17.0005
R2533 VSS.n782 VSS.n376 17.0005
R2534 VSS.n782 VSS.n375 17.0005
R2535 VSS.n779 VSS.n366 17.0005
R2536 VSS.n779 VSS.n407 17.0005
R2537 VSS.n779 VSS.n383 17.0005
R2538 VSS.n779 VSS.n382 17.0005
R2539 VSS.n779 VSS.n409 17.0005
R2540 VSS.n779 VSS.n380 17.0005
R2541 VSS.n779 VSS.n381 17.0005
R2542 VSS.n779 VSS.n376 17.0005
R2543 VSS.n131 VSS.n1 17.0005
R2544 VSS.n128 VSS.n1 17.0005
R2545 VSS.n127 VSS.n1 17.0005
R2546 VSS.n124 VSS.n1 17.0005
R2547 VSS.n123 VSS.n1 17.0005
R2548 VSS.n120 VSS.n1 17.0005
R2549 VSS.n119 VSS.n1 17.0005
R2550 VSS.n116 VSS.n1 17.0005
R2551 VSS.n115 VSS.n1 17.0005
R2552 VSS.n112 VSS.n1 17.0005
R2553 VSS.n111 VSS.n1 17.0005
R2554 VSS.n108 VSS.n1 17.0005
R2555 VSS.n107 VSS.n1 17.0005
R2556 VSS.n104 VSS.n1 17.0005
R2557 VSS.n103 VSS.n1 17.0005
R2558 VSS.n100 VSS.n1 17.0005
R2559 VSS.n99 VSS.n1 17.0005
R2560 VSS.n96 VSS.n1 17.0005
R2561 VSS.n95 VSS.n1 17.0005
R2562 VSS.n92 VSS.n1 17.0005
R2563 VSS.n91 VSS.n1 17.0005
R2564 VSS.n88 VSS.n1 17.0005
R2565 VSS.n87 VSS.n1 17.0005
R2566 VSS.n84 VSS.n1 17.0005
R2567 VSS.n83 VSS.n1 17.0005
R2568 VSS.n80 VSS.n1 17.0005
R2569 VSS.n79 VSS.n1 17.0005
R2570 VSS.n76 VSS.n1 17.0005
R2571 VSS.n75 VSS.n1 17.0005
R2572 VSS.n72 VSS.n1 17.0005
R2573 VSS.n71 VSS.n1 17.0005
R2574 VSS.n68 VSS.n1 17.0005
R2575 VSS.n67 VSS.n1 17.0005
R2576 VSS.n65 VSS.n1 17.0005
R2577 VSS.n64 VSS.n1 17.0005
R2578 VSS.n61 VSS.n1 17.0005
R2579 VSS.n60 VSS.n1 17.0005
R2580 VSS.n57 VSS.n1 17.0005
R2581 VSS.n56 VSS.n1 17.0005
R2582 VSS.n53 VSS.n1 17.0005
R2583 VSS.n52 VSS.n1 17.0005
R2584 VSS.n49 VSS.n1 17.0005
R2585 VSS.n48 VSS.n1 17.0005
R2586 VSS.n45 VSS.n1 17.0005
R2587 VSS.n44 VSS.n1 17.0005
R2588 VSS.n41 VSS.n1 17.0005
R2589 VSS.n40 VSS.n1 17.0005
R2590 VSS.n37 VSS.n1 17.0005
R2591 VSS.n36 VSS.n1 17.0005
R2592 VSS.n33 VSS.n1 17.0005
R2593 VSS.n32 VSS.n1 17.0005
R2594 VSS.n29 VSS.n1 17.0005
R2595 VSS.n28 VSS.n1 17.0005
R2596 VSS.n25 VSS.n1 17.0005
R2597 VSS.n24 VSS.n1 17.0005
R2598 VSS.n21 VSS.n1 17.0005
R2599 VSS.n20 VSS.n1 17.0005
R2600 VSS.n17 VSS.n1 17.0005
R2601 VSS.n16 VSS.n1 17.0005
R2602 VSS.n13 VSS.n1 17.0005
R2603 VSS.n12 VSS.n1 17.0005
R2604 VSS.n9 VSS.n1 17.0005
R2605 VSS.n6 VSS.n1 17.0005
R2606 VSS.t58 VSS.n616 16.173
R2607 VSS.n700 VSS.n461 15.7531
R2608 VSS.n697 VSS.n460 15.7531
R2609 VSS.n707 VSS.n459 15.7531
R2610 VSS.n600 VSS.t76 15.7531
R2611 VSS.n539 VSS.t78 15.7531
R2612 VSS.n553 VSS.t73 15.7531
R2613 VSS.n573 VSS.t82 15.7531
R2614 VSS.n724 VSS.n423 15.7531
R2615 VSS.n729 VSS.n422 15.7531
R2616 VSS.n715 VSS.n421 15.7531
R2617 VSS.n916 VSS.n915 15.0005
R2618 VSS.n915 VSS.n907 15.0005
R2619 VSS.n915 VSS.n908 15.0005
R2620 VSS.n915 VSS.n906 15.0005
R2621 VSS.n915 VSS.n909 15.0005
R2622 VSS.n915 VSS.n905 15.0005
R2623 VSS.n915 VSS.n910 15.0005
R2624 VSS.n915 VSS.n904 15.0005
R2625 VSS.n915 VSS.n911 15.0005
R2626 VSS.n915 VSS.n903 15.0005
R2627 VSS.n915 VSS.n912 15.0005
R2628 VSS.n915 VSS.n902 15.0005
R2629 VSS.n899 VSS.n887 15.0005
R2630 VSS.n899 VSS.n888 15.0005
R2631 VSS.n899 VSS.n889 15.0005
R2632 VSS.n899 VSS.n890 15.0005
R2633 VSS.n899 VSS.n891 15.0005
R2634 VSS.n899 VSS.n892 15.0005
R2635 VSS.n899 VSS.n893 15.0005
R2636 VSS.n899 VSS.n894 15.0005
R2637 VSS.n899 VSS.n895 15.0005
R2638 VSS.n899 VSS.n896 15.0005
R2639 VSS.n900 VSS.n899 15.0005
R2640 VSS.n986 VSS.n979 15.0005
R2641 VSS.n986 VSS.n978 15.0005
R2642 VSS.n986 VSS.n980 15.0005
R2643 VSS.n986 VSS.n977 15.0005
R2644 VSS.n986 VSS.n981 15.0005
R2645 VSS.n986 VSS.n976 15.0005
R2646 VSS.n986 VSS.n982 15.0005
R2647 VSS.n986 VSS.n975 15.0005
R2648 VSS.n986 VSS.n983 15.0005
R2649 VSS.n986 VSS.n974 15.0005
R2650 VSS.n986 VSS.n984 15.0005
R2651 VSS.n986 VSS.n973 15.0005
R2652 VSS.n986 VSS.n985 15.0005
R2653 VSS.n899 VSS.n897 15.0005
R2654 VSS.n666 VSS.n665 15.0005
R2655 VSS.n665 VSS.n664 15.0005
R2656 VSS.n561 VSS.t85 14.0028
R2657 VSS.t75 VSS.n451 12.2525
R2658 VSS.n545 VSS.t77 12.2525
R2659 VSS.n961 VSS 12.0932
R2660 VSS.n607 VSS.t79 11.3774
R2661 VSS.t86 VSS.n411 11.3774
R2662 VSS.n649 VSS.n483 10.8198
R2663 VSS.n777 VSS.n776 10.8198
R2664 VSS.n685 VSS.n465 10.8198
R2665 VSS.n627 VSS.n458 10.8198
R2666 VSS.n496 VSS.n424 10.8198
R2667 VSS.n735 VSS.n417 10.8198
R2668 VSS.n738 VSS.n415 10.8198
R2669 VSS.n778 VSS.n375 10.8198
R2670 VSS.n497 VSS.n424 10.8198
R2671 VSS.n628 VSS.n458 10.8198
R2672 VSS.n777 VSS.n491 10.8198
R2673 VSS.n651 VSS.n487 10.8198
R2674 VSS.n683 VSS.n467 10.8198
R2675 VSS.n778 VSS.n377 10.8198
R2676 VSS.n192 VSS.t105 9.96507
R2677 VSS.n195 VSS.t92 9.96507
R2678 VSS.n198 VSS.t106 9.96507
R2679 VSS.n201 VSS.t93 9.96507
R2680 VSS.n204 VSS.t102 9.96507
R2681 VSS.n207 VSS.t94 9.96507
R2682 VSS.n210 VSS.t103 9.96507
R2683 VSS.n213 VSS.t95 9.96507
R2684 VSS.n216 VSS.t104 9.96507
R2685 VSS.n386 VSS.n366 9.7005
R2686 VSS.n794 VSS.n793 9.7005
R2687 VSS.n1018 VSS.n795 9.7005
R2688 VSS.n1015 VSS.n799 9.7005
R2689 VSS.n1010 VSS.n800 9.7005
R2690 VSS.n830 VSS.n161 9.7005
R2691 VSS.n1061 VSS.n135 9.7005
R2692 VSS.n877 VSS.n278 9.7005
R2693 VSS.n322 VSS.n320 9.7005
R2694 VSS.n341 VSS.n323 9.7005
R2695 VSS.n338 VSS.n327 9.7005
R2696 VSS.n333 VSS.n328 9.7005
R2697 VSS.n1016 VSS.n1015 9.7005
R2698 VSS.n1019 VSS.n1018 9.7005
R2699 VSS.n1042 VSS.n1041 9.7005
R2700 VSS.n966 VSS.n164 9.7005
R2701 VSS.n1005 VSS.n137 9.7005
R2702 VSS.n876 VSS.n275 9.7005
R2703 VSS.n840 VSS.n187 9.7005
R2704 VSS.n339 VSS.n338 9.7005
R2705 VSS.n342 VSS.n341 9.7005
R2706 VSS.n1055 VSS.n1054 9.7005
R2707 VSS.n409 VSS.n384 9.7005
R2708 VSS.n617 VSS.n594 9.6271
R2709 VSS.n604 VSS.n541 9.6271
R2710 VSS.n605 VSS.n543 9.6271
R2711 VSS.n614 VSS.n590 9.6271
R2712 VSS.n606 VSS.n545 9.6271
R2713 VSS.t161 VSS.n420 9.6271
R2714 VSS.n585 VSS.n584 9.37071
R2715 VSS.n586 VSS.n585 9.3176
R2716 VSS.t13 VSS.n491 8.75196
R2717 VSS.t73 VSS.n434 8.75196
R2718 VSS.t9 VSS.n375 8.75196
R2719 VSS.n390 VSS.n389 8.501
R2720 VSS.n1062 VSS.n133 8.501
R2721 VSS.n1042 VSS.n785 8.501
R2722 VSS.n1042 VSS.n786 8.501
R2723 VSS.n1042 VSS.n787 8.501
R2724 VSS.n1042 VSS.n788 8.501
R2725 VSS.n1042 VSS.n789 8.501
R2726 VSS.n1042 VSS.n790 8.501
R2727 VSS.n1042 VSS.n791 8.501
R2728 VSS.n1009 VSS.n1008 8.501
R2729 VSS.n1008 VSS.n812 8.501
R2730 VSS.n1008 VSS.n810 8.501
R2731 VSS.n1008 VSS.n808 8.501
R2732 VSS.n1008 VSS.n806 8.501
R2733 VSS.n1005 VSS.n136 8.501
R2734 VSS.n1005 VSS.n813 8.501
R2735 VSS.n1005 VSS.n814 8.501
R2736 VSS.n1005 VSS.n815 8.501
R2737 VSS.n1005 VSS.n816 8.501
R2738 VSS.n1005 VSS.n817 8.501
R2739 VSS.n1005 VSS.n1004 8.501
R2740 VSS.n1056 VSS.n310 8.501
R2741 VSS.n1056 VSS.n309 8.501
R2742 VSS.n1056 VSS.n308 8.501
R2743 VSS.n1056 VSS.n307 8.501
R2744 VSS.n1057 VSS.n1056 8.501
R2745 VSS.n1055 VSS.n312 8.501
R2746 VSS.n1055 VSS.n313 8.501
R2747 VSS.n1055 VSS.n314 8.501
R2748 VSS.n1055 VSS.n315 8.501
R2749 VSS.n1055 VSS.n316 8.501
R2750 VSS.n1055 VSS.n317 8.501
R2751 VSS.n1055 VSS.n318 8.501
R2752 VSS.n1045 VSS.n332 8.501
R2753 VSS.n1045 VSS.n364 8.501
R2754 VSS.n1045 VSS.n357 8.501
R2755 VSS.n1045 VSS.n356 8.501
R2756 VSS.n1045 VSS.n354 8.501
R2757 VSS.n565 VSS.n563 8.501
R2758 VSS.n644 VSS.n632 8.501
R2759 VSS.n644 VSS.n634 8.501
R2760 VSS.n644 VSS.n636 8.501
R2761 VSS.n644 VSS.n638 8.501
R2762 VSS.n644 VSS.n640 8.501
R2763 VSS.n644 VSS.n643 8.501
R2764 VSS.n644 VSS.n479 8.501
R2765 VSS.n784 VSS.n373 8.501
R2766 VSS.n784 VSS.n372 8.501
R2767 VSS.n784 VSS.n371 8.501
R2768 VSS.n784 VSS.n370 8.501
R2769 VSS.n784 VSS.n369 8.501
R2770 VSS.n784 VSS.n368 8.501
R2771 VSS.n784 VSS.n367 8.501
R2772 VSS.n805 VSS.n804 8.5005
R2773 VSS.n811 VSS.n804 8.5005
R2774 VSS.n809 VSS.n804 8.5005
R2775 VSS.n807 VSS.n804 8.5005
R2776 VSS.n1006 VSS.n804 8.5005
R2777 VSS.n804 VSS.n792 8.5005
R2778 VSS.n1002 VSS.n1001 8.5005
R2779 VSS.n1002 VSS.n1000 8.5005
R2780 VSS.n1002 VSS.n999 8.5005
R2781 VSS.n1002 VSS.n998 8.5005
R2782 VSS.n1002 VSS.n997 8.5005
R2783 VSS.n1002 VSS.n818 8.5005
R2784 VSS.n1059 VSS.n303 8.5005
R2785 VSS.n1059 VSS.n304 8.5005
R2786 VSS.n1059 VSS.n305 8.5005
R2787 VSS.n1059 VSS.n306 8.5005
R2788 VSS.n1059 VSS.n1058 8.5005
R2789 VSS.n1060 VSS.n1059 8.5005
R2790 VSS.n1051 VSS.n319 8.5005
R2791 VSS.n1051 VSS.n352 8.5005
R2792 VSS.n1051 VSS.n351 8.5005
R2793 VSS.n1051 VSS.n350 8.5005
R2794 VSS.n1051 VSS.n349 8.5005
R2795 VSS.n1051 VSS.n348 8.5005
R2796 VSS.n1051 VSS.n347 8.5005
R2797 VSS.n775 VSS.n630 8.5005
R2798 VSS.n631 VSS.n630 8.5005
R2799 VSS.n633 VSS.n630 8.5005
R2800 VSS.n635 VSS.n630 8.5005
R2801 VSS.n637 VSS.n630 8.5005
R2802 VSS.n639 VSS.n630 8.5005
R2803 VSS.n641 VSS.n630 8.5005
R2804 VSS.n642 VSS.n630 8.5005
R2805 VSS.n781 VSS.n399 8.5005
R2806 VSS.n781 VSS.n400 8.5005
R2807 VSS.n781 VSS.n401 8.5005
R2808 VSS.n781 VSS.n402 8.5005
R2809 VSS.n781 VSS.n403 8.5005
R2810 VSS.n781 VSS.n404 8.5005
R2811 VSS.n781 VSS.n374 8.5005
R2812 VSS.n782 VSS.n781 8.5005
R2813 VSS.n775 VSS.n646 8.49944
R2814 VSS.n779 VSS.n480 8.49944
R2815 VSS.n782 VSS.n385 8.49944
R2816 VSS.n780 VSS.n779 8.49944
R2817 VSS.n1060 VSS.n299 8.49922
R2818 VSS.n1060 VSS.n295 8.49922
R2819 VSS.n1060 VSS.n181 8.49922
R2820 VSS.n1060 VSS.n140 8.49922
R2821 VSS.n1003 VSS.n921 8.49922
R2822 VSS.n1003 VSS.n820 8.49922
R2823 VSS.n775 VSS.n495 8.49291
R2824 VSS.n775 VSS.n530 8.49291
R2825 VSS.n1064 VSS.n66 8.48686
R2826 VSS.n1003 VSS.n937 8.48686
R2827 VSS.n1064 VSS.n5 8.48362
R2828 VSS.n1068 VSS.n1 8.48362
R2829 VSS.n1065 VSS.n1064 8.48362
R2830 VSS.n394 VSS.n1 8.48362
R2831 VSS.n566 VSS.n564 8.47045
R2832 VSS.n388 VSS.n387 8.46995
R2833 VSS.n393 VSS.n392 8.46995
R2834 VSS.n1067 VSS.n2 8.46995
R2835 VSS.n1066 VSS.n3 8.46995
R2836 VSS.n1027 VSS.n1026 8.46995
R2837 VSS.n1029 VSS.n1028 8.46995
R2838 VSS.n1031 VSS.n1030 8.46995
R2839 VSS.n1033 VSS.n1032 8.46995
R2840 VSS.n1035 VSS.n1034 8.46995
R2841 VSS.n1037 VSS.n1036 8.46995
R2842 VSS.n1003 VSS.n963 8.46995
R2843 VSS.n363 VSS.n362 8.46995
R2844 VSS.n361 VSS.n358 8.46995
R2845 VSS.n360 VSS.n359 8.46995
R2846 VSS.n355 VSS.n353 8.46995
R2847 VSS.n1048 VSS.n1047 8.46995
R2848 VSS.n568 VSS.n567 8.46995
R2849 VSS.n390 VSS.n187 7.97216
R2850 VSS.n188 VSS.n6 7.97216
R2851 VSS.n189 VSS.n9 7.97216
R2852 VSS.n190 VSS.n12 7.97216
R2853 VSS.n191 VSS.n13 7.97216
R2854 VSS.n192 VSS.n16 7.97216
R2855 VSS.n193 VSS.n17 7.97216
R2856 VSS.n194 VSS.n20 7.97216
R2857 VSS.n195 VSS.n21 7.97216
R2858 VSS.n196 VSS.n24 7.97216
R2859 VSS.n197 VSS.n25 7.97216
R2860 VSS.n198 VSS.n28 7.97216
R2861 VSS.n199 VSS.n29 7.97216
R2862 VSS.n200 VSS.n32 7.97216
R2863 VSS.n201 VSS.n33 7.97216
R2864 VSS.n202 VSS.n36 7.97216
R2865 VSS.n203 VSS.n37 7.97216
R2866 VSS.n204 VSS.n40 7.97216
R2867 VSS.n205 VSS.n41 7.97216
R2868 VSS.n206 VSS.n44 7.97216
R2869 VSS.n207 VSS.n45 7.97216
R2870 VSS.n208 VSS.n48 7.97216
R2871 VSS.n209 VSS.n49 7.97216
R2872 VSS.n210 VSS.n52 7.97216
R2873 VSS.n211 VSS.n53 7.97216
R2874 VSS.n212 VSS.n56 7.97216
R2875 VSS.n213 VSS.n57 7.97216
R2876 VSS.n214 VSS.n60 7.97216
R2877 VSS.n215 VSS.n61 7.97216
R2878 VSS.n216 VSS.n64 7.97216
R2879 VSS.n217 VSS.n65 7.97216
R2880 VSS.n615 VSS.t81 7.87681
R2881 VSS.n901 VSS.n900 7.50175
R2882 VSS.t8 VSS.n751 7.5015
R2883 VSS.n901 VSS.n897 7.501
R2884 VSS.n916 VSS.t16 7.5005
R2885 VSS.n907 VSS.t16 7.5005
R2886 VSS.n908 VSS.t16 7.5005
R2887 VSS.n906 VSS.t16 7.5005
R2888 VSS.n909 VSS.t16 7.5005
R2889 VSS.n905 VSS.t16 7.5005
R2890 VSS.n910 VSS.t16 7.5005
R2891 VSS.n904 VSS.t16 7.5005
R2892 VSS.n911 VSS.t16 7.5005
R2893 VSS.n903 VSS.t16 7.5005
R2894 VSS.n912 VSS.t16 7.5005
R2895 VSS.n902 VSS.t16 7.5005
R2896 VSS.t16 VSS.n887 7.5005
R2897 VSS.t16 VSS.n888 7.5005
R2898 VSS.t16 VSS.n889 7.5005
R2899 VSS.t16 VSS.n890 7.5005
R2900 VSS.t16 VSS.n891 7.5005
R2901 VSS.t16 VSS.n892 7.5005
R2902 VSS.t16 VSS.n893 7.5005
R2903 VSS.t16 VSS.n894 7.5005
R2904 VSS.t16 VSS.n895 7.5005
R2905 VSS.t16 VSS.n896 7.5005
R2906 VSS.t4 VSS.n979 7.5005
R2907 VSS.t4 VSS.n978 7.5005
R2908 VSS.t4 VSS.n980 7.5005
R2909 VSS.t4 VSS.n977 7.5005
R2910 VSS.t4 VSS.n981 7.5005
R2911 VSS.t4 VSS.n976 7.5005
R2912 VSS.t4 VSS.n982 7.5005
R2913 VSS.t4 VSS.n975 7.5005
R2914 VSS.t4 VSS.n983 7.5005
R2915 VSS.t4 VSS.n974 7.5005
R2916 VSS.t4 VSS.n984 7.5005
R2917 VSS.t4 VSS.n973 7.5005
R2918 VSS.t4 VSS.n985 7.5005
R2919 VSS.n666 VSS.t12 7.5005
R2920 VSS.n664 VSS.t12 7.5005
R2921 VSS.n753 VSS.t8 7.5005
R2922 VSS.t8 VSS.n747 7.5005
R2923 VSS.n408 VSS.n381 7.39975
R2924 VSS.n677 VSS.t159 6.12652
R2925 VSS.n694 VSS.t64 6.12652
R2926 VSS.n723 VSS.t161 6.12652
R2927 VSS.n767 VSS.t86 6.12652
R2928 VSS.n1062 VSS.n134 5.66778
R2929 VSS.n391 VSS.n390 5.66778
R2930 VSS.n390 VSS.n8 5.66767
R2931 VSS.n1063 VSS.n1062 5.66767
R2932 VSS.n1008 VSS.n1007 5.66767
R2933 VSS.n1056 VSS.n301 5.66767
R2934 VSS.n1046 VSS.n1045 5.66767
R2935 VSS.n566 VSS.n565 5.66767
R2936 VSS.n645 VSS.n644 5.66767
R2937 VSS.n755 VSS.n378 5.66767
R2938 VSS.n784 VSS.n783 5.66767
R2939 VSS.n1039 VSS.n804 5.66717
R2940 VSS.n770 VSS.n769 5.66717
R2941 VSS.n1060 VSS.n138 5.66609
R2942 VSS.n1039 VSS.n1014 5.6468
R2943 VSS.n1039 VSS.n1021 5.6468
R2944 VSS.n1052 VSS.n337 5.6468
R2945 VSS.n1052 VSS.n345 5.6468
R2946 VSS.n1039 VSS.n797 5.63943
R2947 VSS.n1052 VSS.n325 5.63943
R2948 VSS.n1039 VSS.n801 5.61281
R2949 VSS.n1052 VSS.n321 5.61281
R2950 VSS.n1008 VSS.n803 5.43415
R2951 VSS.n1056 VSS.n311 5.43415
R2952 VSS.n1045 VSS.n331 5.43415
R2953 VSS.n202 VSS.t109 5.31494
R2954 VSS.n219 VSS.n67 5.31494
R2955 VSS.n220 VSS.n68 5.31494
R2956 VSS.n233 VSS.t67 5.31494
R2957 VSS.n776 VSS.n492 5.25137
R2958 VSS.n669 VSS.n478 5.25137
R2959 VSS.n674 VSS.n475 5.25137
R2960 VSS.n677 VSS.n474 5.25137
R2961 VSS.t77 VSS.n443 5.25137
R2962 VSS.t80 VSS.n431 5.25137
R2963 VSS.n768 VSS.n410 5.25137
R2964 VSS.n759 VSS.n379 5.25137
R2965 VSS.n757 VSS.n377 5.25137
R2966 VSS.t12 VSS.n660 5.0015
R2967 VSS.n914 VSS.n913 5.001
R2968 VSS.n886 VSS.n885 5.001
R2969 VSS.n988 VSS.n987 5.001
R2970 VSS.n662 VSS.n661 5.001
R2971 VSS.t8 VSS.n745 5.00099
R2972 VSS.t8 VSS.n744 5.00099
R2973 VSS.t8 VSS.n752 5.00099
R2974 VSS.t16 VSS.n884 5.0005
R2975 VSS.t4 VSS.n989 5.0005
R2976 VSS.t4 VSS.n972 5.0005
R2977 VSS.t4 VSS.n990 5.0005
R2978 VSS.t4 VSS.n971 5.0005
R2979 VSS.t4 VSS.n991 5.0005
R2980 VSS.t4 VSS.n970 5.0005
R2981 VSS.t4 VSS.n992 5.0005
R2982 VSS.t4 VSS.n969 5.0005
R2983 VSS.t4 VSS.n993 5.0005
R2984 VSS.t4 VSS.n968 5.0005
R2985 VSS.t4 VSS.n994 5.0005
R2986 VSS.t4 VSS.n967 5.0005
R2987 VSS.n995 VSS.t4 5.0005
R2988 VSS.t12 VSS.n659 5.0005
R2989 VSS.t137 VSS.n794 4.65063
R2990 VSS.n1019 VSS.t152 4.65063
R2991 VSS.n1016 VSS.t153 4.65063
R2992 VSS.t139 VSS.n1010 4.65063
R2993 VSS.t98 VSS.n12 4.65063
R2994 VSS.t99 VSS.n17 4.65063
R2995 VSS.t107 VSS.n24 4.65063
R2996 VSS.t100 VSS.n29 4.65063
R2997 VSS.t88 VSS.n36 4.65063
R2998 VSS.t101 VSS.n41 4.65063
R2999 VSS.t89 VSS.n48 4.65063
R3000 VSS.t96 VSS.n53 4.65063
R3001 VSS.t90 VSS.n60 4.65063
R3002 VSS.t97 VSS.n65 4.65063
R3003 VSS.t131 VSS.n72 4.65063
R3004 VSS.t120 VSS.n79 4.65063
R3005 VSS.t125 VSS.n84 4.65063
R3006 VSS.t132 VSS.n91 4.65063
R3007 VSS.t121 VSS.n96 4.65063
R3008 VSS.t114 VSS.n103 4.65063
R3009 VSS.t123 VSS.n108 4.65063
R3010 VSS.t115 VSS.n115 4.65063
R3011 VSS.t124 VSS.n120 4.65063
R3012 VSS.t130 VSS.n127 4.65063
R3013 VSS.t141 VSS.n322 4.65063
R3014 VSS.n342 VSS.t149 4.65063
R3015 VSS.n339 VSS.t145 4.65063
R3016 VSS.t150 VSS.n333 4.65063
R3017 VSS.n773 VSS.n772 4.41846
R3018 VSS.n1003 VSS.n302 4.24967
R3019 VSS.n775 VSS.n736 4.22395
R3020 VSS.n1039 VSS.n1038 4.17435
R3021 VSS.n802 VSS.n792 3.65125
R3022 VSS.n1015 VSS.n792 3.65125
R3023 VSS.n1018 VSS.n792 3.65125
R3024 VSS.n793 VSS.n792 3.65125
R3025 VSS.n1041 VSS.n792 3.65125
R3026 VSS.n1039 VSS.n800 3.65125
R3027 VSS.n1040 VSS.n1039 3.65125
R3028 VSS.n1060 VSS.n300 3.65125
R3029 VSS.n1060 VSS.n298 3.65125
R3030 VSS.n1060 VSS.n296 3.65125
R3031 VSS.n1060 VSS.n293 3.65125
R3032 VSS.n1060 VSS.n290 3.65125
R3033 VSS.n1060 VSS.n287 3.65125
R3034 VSS.n1060 VSS.n284 3.65125
R3035 VSS.n1060 VSS.n281 3.65125
R3036 VSS.n1060 VSS.n274 3.65125
R3037 VSS.n1060 VSS.n271 3.65125
R3038 VSS.n1060 VSS.n268 3.65125
R3039 VSS.n1060 VSS.n265 3.65125
R3040 VSS.n1060 VSS.n262 3.65125
R3041 VSS.n1060 VSS.n259 3.65125
R3042 VSS.n1060 VSS.n186 3.65125
R3043 VSS.n1060 VSS.n184 3.65125
R3044 VSS.n1060 VSS.n182 3.65125
R3045 VSS.n1060 VSS.n179 3.65125
R3046 VSS.n1060 VSS.n176 3.65125
R3047 VSS.n1060 VSS.n173 3.65125
R3048 VSS.n1060 VSS.n170 3.65125
R3049 VSS.n1060 VSS.n167 3.65125
R3050 VSS.n1060 VSS.n164 3.65125
R3051 VSS.n1060 VSS.n161 3.65125
R3052 VSS.n1060 VSS.n158 3.65125
R3053 VSS.n1060 VSS.n155 3.65125
R3054 VSS.n1060 VSS.n152 3.65125
R3055 VSS.n1060 VSS.n149 3.65125
R3056 VSS.n1060 VSS.n146 3.65125
R3057 VSS.n1060 VSS.n143 3.65125
R3058 VSS.n1060 VSS.n141 3.65125
R3059 VSS.n1060 VSS.n137 3.65125
R3060 VSS.n1003 VSS.n918 3.65125
R3061 VSS.n1003 VSS.n883 3.65125
R3062 VSS.n1003 VSS.n882 3.65125
R3063 VSS.n1003 VSS.n881 3.65125
R3064 VSS.n1003 VSS.n880 3.65125
R3065 VSS.n1003 VSS.n879 3.65125
R3066 VSS.n1003 VSS.n878 3.65125
R3067 VSS.n1003 VSS.n877 3.65125
R3068 VSS.n1003 VSS.n876 3.65125
R3069 VSS.n1003 VSS.n875 3.65125
R3070 VSS.n1003 VSS.n874 3.65125
R3071 VSS.n1003 VSS.n873 3.65125
R3072 VSS.n1003 VSS.n872 3.65125
R3073 VSS.n1003 VSS.n871 3.65125
R3074 VSS.n1003 VSS.n135 3.65125
R3075 VSS.n1003 VSS.n840 3.65125
R3076 VSS.n1003 VSS.n839 3.65125
R3077 VSS.n1003 VSS.n837 3.65125
R3078 VSS.n1003 VSS.n836 3.65125
R3079 VSS.n1003 VSS.n835 3.65125
R3080 VSS.n1003 VSS.n834 3.65125
R3081 VSS.n1003 VSS.n833 3.65125
R3082 VSS.n1003 VSS.n832 3.65125
R3083 VSS.n1003 VSS.n831 3.65125
R3084 VSS.n1003 VSS.n829 3.65125
R3085 VSS.n1003 VSS.n828 3.65125
R3086 VSS.n1003 VSS.n827 3.65125
R3087 VSS.n1003 VSS.n826 3.65125
R3088 VSS.n1003 VSS.n825 3.65125
R3089 VSS.n1003 VSS.n824 3.65125
R3090 VSS.n1003 VSS.n821 3.65125
R3091 VSS.n1003 VSS.n819 3.65125
R3092 VSS.n330 VSS.n319 3.65125
R3093 VSS.n338 VSS.n319 3.65125
R3094 VSS.n341 VSS.n319 3.65125
R3095 VSS.n320 VSS.n319 3.65125
R3096 VSS.n1054 VSS.n319 3.65125
R3097 VSS.n1052 VSS.n328 3.65125
R3098 VSS.n1053 VSS.n1052 3.65125
R3099 VSS.n782 VSS.n386 3.65125
R3100 VSS.n782 VSS.n384 3.65125
R3101 VSS.n779 VSS.n405 3.65125
R3102 VSS.n675 VSS.t160 3.51157
R3103 VSS.n695 VSS.t65 3.51157
R3104 VSS.n718 VSS.t162 3.51157
R3105 VSS.n649 VSS.n648 3.50108
R3106 VSS.n703 VSS.n685 3.50108
R3107 VSS.n692 VSS.n464 3.50108
R3108 VSS.n702 VSS.n463 3.50108
R3109 VSS.n694 VSS.n462 3.50108
R3110 VSS.n531 VSS.t83 3.50108
R3111 VSS.n717 VSS.n419 3.50108
R3112 VSS.n721 VSS.n418 3.50108
R3113 VSS.n731 VSS.n417 3.50108
R3114 VSS.n626 VSS.n625 3.4005
R3115 VSS.n775 VSS.n682 3.36638
R3116 VSS.n625 VSS.n624 3.3021
R3117 VSS.n771 VSS.n758 3.10192
R3118 VSS.n779 VSS.n415 3.09158
R3119 VSS.n779 VSS.n416 3.09158
R3120 VSS.n779 VSS.n424 3.09158
R3121 VSS.n779 VSS.n458 3.09158
R3122 VSS.n779 VSS.n465 3.09158
R3123 VSS.n779 VSS.n466 3.09158
R3124 VSS.n775 VSS.n650 3.09158
R3125 VSS.n779 VSS.n487 3.09158
R3126 VSS.n779 VSS.n483 3.09158
R3127 VSS.n779 VSS.n777 3.09158
R3128 VSS.n775 VSS.n684 3.09158
R3129 VSS.n775 VSS.n683 3.09158
R3130 VSS.n775 VSS.n737 3.09158
R3131 VSS.n775 VSS.n735 3.09158
R3132 VSS.n779 VSS.n778 3.09158
R3133 VSS.n772 VSS.t87 2.8387
R3134 VSS.n1052 VSS.n329 2.72867
R3135 VSS.n344 VSS.t142 2.71989
R3136 VSS.n343 VSS.t144 2.71989
R3137 VSS.n336 VSS.t136 2.71989
R3138 VSS.n335 VSS.t151 2.71989
R3139 VSS.n1023 VSS.t138 2.71989
R3140 VSS.n1020 VSS.t147 2.71989
R3141 VSS.n1013 VSS.t154 2.71989
R3142 VSS.n1012 VSS.t140 2.71989
R3143 VSS.n668 VSS.n667 2.62813
R3144 VSS.n705 VSS.n704 2.62813
R3145 VSS.n764 VSS.n763 2.62813
R3146 VSS.n616 VSS.n613 2.62594
R3147 VSS.n681 VSS.n680 2.62352
R3148 VSS.n733 VSS.n732 2.62352
R3149 VSS.n726 VSS.n725 2.55872
R3150 VSS.n709 VSS.n708 2.55475
R3151 VSS.n732 VSS.n731 2.43137
R3152 VSS.n680 VSS.n679 2.43137
R3153 VSS.n708 VSS.n707 2.43135
R3154 VSS.n726 VSS.n724 2.43046
R3155 VSS.n758 VSS.n757 2.43041
R3156 VSS.n764 VSS.n762 2.42998
R3157 VSS.n705 VSS.n703 2.42998
R3158 VSS.n668 VSS.n492 2.42998
R3159 VSS.n396 VSS.n395 2.4005
R3160 VSS.n621 VSS.n618 2.28134
R3161 VSS.n1039 VSS.n803 2.04585
R3162 VSS.n1003 VSS.n311 2.04585
R3163 VSS.n1052 VSS.n331 2.04585
R3164 VSS.n251 VSS 1.90217
R3165 VSS.n624 VSS.n622 1.84842
R3166 VSS.t76 VSS.n454 1.75079
R3167 VSS.t81 VSS.n592 1.75079
R3168 VSS.n581 VSS.t74 1.75079
R3169 VSS.n622 VSS.n603 1.53166
R3170 VSS.n938 VSS.n218 1.36633
R3171 VSS.n962 VSS.n185 1.34679
R3172 VSS.n470 VSS.n441 1.3455
R3173 VSS.n251 VSS.n218 1.34232
R3174 VSS.n471 VSS.n470 1.32368
R3175 VSS.n671 VSS.n471 1.28812
R3176 VSS.n938 VSS.n185 1.26501
R3177 VSS.n749 VSS 1.25083
R3178 VSS.n749 VSS.n441 1.03321
R3179 VSS.n1049 VSS.n1048 1.01307
R3180 VSS.n1027 VSS.n1025 1.00996
R3181 VSS.n1025 VSS.n1024 0.951847
R3182 VSS.n1050 VSS.n1049 0.948729
R3183 VSS.n607 VSS.n547 0.875646
R3184 VSS.n612 VSS.n583 0.875646
R3185 VSS.n608 VSS.n549 0.875646
R3186 VSS.n611 VSS.n581 0.875646
R3187 VSS.n609 VSS.n551 0.875646
R3188 VSS.n610 VSS.n579 0.875646
R3189 VSS.n772 VSS.n771 0.826621
R3190 VSS.n1025 VSS.n792 0.708973
R3191 VSS.n1049 VSS.n319 0.708965
R3192 VSS.n962 VSS 0.708808
R3193 VSS.n940 VSS.n939 0.688
R3194 VSS.n941 VSS.n940 0.688
R3195 VSS.n942 VSS.n941 0.688
R3196 VSS.n221 VSS.t116 0.664805
R3197 VSS.n224 VSS.t126 0.664805
R3198 VSS.n227 VSS.t113 0.664805
R3199 VSS.n230 VSS.t119 0.664805
R3200 VSS.n233 VSS.t127 0.664805
R3201 VSS.n236 VSS.t122 0.664805
R3202 VSS.n239 VSS.t128 0.664805
R3203 VSS.n242 VSS.t117 0.664805
R3204 VSS.n245 VSS.t129 0.664805
R3205 VSS.n248 VSS.t118 0.664805
R3206 VSS.n939 VSS.n938 0.571125
R3207 VSS.n943 VSS.n942 0.571125
R3208 VSS.n397 VSS.n1 0.556467
R3209 VSS VSS.n398 0.541359
R3210 VSS.n1 VSS.n0 0.503811
R3211 VSS.n663 VSS 0.493117
R3212 VSS.n362 VSS.n329 0.46005
R3213 VSS.n335 VSS.n329 0.376899
R3214 VSS.n393 VSS.n387 0.353045
R3215 VSS.n1067 VSS.n1066 0.353045
R3216 VSS.n622 VSS.n621 0.329349
R3217 VSS.n361 VSS.n360 0.323711
R3218 VSS.n1033 VSS.n1031 0.323711
R3219 VSS.n620 VSS.n619 0.318749
R3220 VSS.n1038 VSS.n1037 0.318618
R3221 VSS.n568 VSS.n564 0.292545
R3222 VSS.n1038 VSS.n1023 0.275254
R3223 VSS.n1048 VSS.n353 0.250378
R3224 VSS.n360 VSS.n353 0.250378
R3225 VSS.n362 VSS.n361 0.250378
R3226 VSS.n1029 VSS.n1027 0.250378
R3227 VSS.n1031 VSS.n1029 0.250378
R3228 VSS.n1035 VSS.n1033 0.250378
R3229 VSS.n1037 VSS.n1035 0.250378
R3230 VSS.n387 VSS.n5 0.223034
R3231 VSS.n394 VSS.n393 0.223034
R3232 VSS.n1066 VSS.n1065 0.223034
R3233 VSS.n1068 VSS.n1067 0.223034
R3234 VSS.n624 VSS.n623 0.22041
R3235 VSS.n344 VSS.n321 0.213565
R3236 VSS.n1012 VSS.n801 0.213225
R3237 VSS.n898 VSS 0.209539
R3238 VSS.n727 VSS 0.201452
R3239 VSS.n1024 VSS.n801 0.195092
R3240 VSS.n1050 VSS.n321 0.194752
R3241 VSS.n1060 VSS.n218 0.190861
R3242 VSS.n1060 VSS.n185 0.175532
R3243 VSS.n779 VSS.n471 0.175532
R3244 VSS.n963 VSS.n962 0.173106
R3245 VSS.n963 VSS.n961 0.154772
R3246 VSS.n779 VSS.n441 0.140412
R3247 VSS.n569 VSS.n568 0.132772
R3248 VSS.n756 VSS 0.128407
R3249 VSS.n755 VSS.n754 0.116
R3250 VSS.n750 VSS.n749 0.116
R3251 VSS.n682 VSS 0.10042
R3252 VSS.n763 VSS.n736 0.0976482
R3253 VSS.n736 VSS 0.093811
R3254 VSS.n704 VSS.n682 0.0914701
R3255 VSS.n345 VSS.n343 0.0892566
R3256 VSS.n1021 VSS.n1020 0.0892566
R3257 VSS.n337 VSS.n336 0.0889207
R3258 VSS.n1014 VSS.n1013 0.0889207
R3259 VSS.n1013 VSS.n797 0.077975
R3260 VSS.n343 VSS.n325 0.077638
R3261 VSS.n1069 VSS.n0 0.0702476
R3262 VSS.n754 VSS.n753 0.06705
R3263 VSS.n751 VSS.n748 0.06705
R3264 VSS.n336 VSS.n325 0.0668916
R3265 VSS.n1020 VSS.n797 0.0665552
R3266 VSS.n746 VSS.n743 0.0665
R3267 VSS.n753 VSS.n743 0.06595
R3268 VSS.n748 VSS.n747 0.06595
R3269 VSS.n751 VSS.n750 0.06595
R3270 VSS.n937 VSS.n70 0.0626195
R3271 VSS.n397 VSS.n396 0.0622335
R3272 VSS.n469 VSS 0.0592931
R3273 VSS.n337 VSS.n335 0.0558388
R3274 VSS.n1014 VSS.n1012 0.0558388
R3275 VSS.n396 VSS.n0 0.0555762
R3276 VSS.n345 VSS.n344 0.055503
R3277 VSS.n1023 VSS.n1021 0.055503
R3278 VSS.n856 VSS.n69 0.0505
R3279 VSS.n398 VSS.n397 0.0501911
R3280 VSS.n959 VSS.n841 0.0471667
R3281 VSS.n958 VSS.n7 0.0471667
R3282 VSS.n842 VSS.n10 0.0471667
R3283 VSS.n957 VSS.n11 0.0471667
R3284 VSS.n843 VSS.n14 0.0471667
R3285 VSS.n956 VSS.n15 0.0471667
R3286 VSS.n844 VSS.n18 0.0471667
R3287 VSS.n955 VSS.n19 0.0471667
R3288 VSS.n845 VSS.n22 0.0471667
R3289 VSS.n954 VSS.n23 0.0471667
R3290 VSS.n846 VSS.n26 0.0471667
R3291 VSS.n953 VSS.n27 0.0471667
R3292 VSS.n847 VSS.n30 0.0471667
R3293 VSS.n952 VSS.n31 0.0471667
R3294 VSS.n848 VSS.n34 0.0471667
R3295 VSS.n951 VSS.n35 0.0471667
R3296 VSS.n849 VSS.n38 0.0471667
R3297 VSS.n950 VSS.n39 0.0471667
R3298 VSS.n850 VSS.n42 0.0471667
R3299 VSS.n949 VSS.n43 0.0471667
R3300 VSS.n851 VSS.n46 0.0471667
R3301 VSS.n948 VSS.n47 0.0471667
R3302 VSS.n852 VSS.n50 0.0471667
R3303 VSS.n947 VSS.n51 0.0471667
R3304 VSS.n853 VSS.n54 0.0471667
R3305 VSS.n946 VSS.n55 0.0471667
R3306 VSS.n854 VSS.n58 0.0471667
R3307 VSS.n945 VSS.n59 0.0471667
R3308 VSS.n855 VSS.n62 0.0471667
R3309 VSS.n944 VSS.n63 0.0471667
R3310 VSS.n704 VSS.n686 0.0414302
R3311 VSS.n693 VSS.n687 0.0414302
R3312 VSS.n701 VSS.n688 0.0414302
R3313 VSS.n720 VSS.n713 0.0414302
R3314 VSS.n733 VSS.n714 0.0414302
R3315 VSS.n725 VSS.n495 0.0409846
R3316 VSS.n691 VSS 0.0388721
R3317 VSS.n676 VSS.n675 0.037593
R3318 VSS.n696 VSS.n695 0.037593
R3319 VSS.n569 VSS.n495 0.0362227
R3320 VSS.n856 VSS.n66 0.0359529
R3321 VSS.n937 VSS.n69 0.0359529
R3322 VSS.n398 VSS.n394 0.0357621
R3323 VSS.n1065 VSS.n4 0.0357621
R3324 VSS.n959 VSS.n5 0.0357621
R3325 VSS.n1069 VSS.n1068 0.0357621
R3326 VSS.n936 VSS.n73 0.0338333
R3327 VSS.n857 VSS.n74 0.0338333
R3328 VSS.n935 VSS.n77 0.0338333
R3329 VSS.n858 VSS.n78 0.0338333
R3330 VSS.n934 VSS.n81 0.0338333
R3331 VSS.n859 VSS.n82 0.0338333
R3332 VSS.n933 VSS.n85 0.0338333
R3333 VSS.n860 VSS.n86 0.0338333
R3334 VSS.n932 VSS.n89 0.0338333
R3335 VSS.n861 VSS.n90 0.0338333
R3336 VSS.n931 VSS.n93 0.0338333
R3337 VSS.n862 VSS.n94 0.0338333
R3338 VSS.n930 VSS.n97 0.0338333
R3339 VSS.n863 VSS.n98 0.0338333
R3340 VSS.n929 VSS.n101 0.0338333
R3341 VSS.n864 VSS.n102 0.0338333
R3342 VSS.n928 VSS.n105 0.0338333
R3343 VSS.n865 VSS.n106 0.0338333
R3344 VSS.n927 VSS.n109 0.0338333
R3345 VSS.n866 VSS.n110 0.0338333
R3346 VSS.n926 VSS.n113 0.0338333
R3347 VSS.n867 VSS.n114 0.0338333
R3348 VSS.n925 VSS.n117 0.0338333
R3349 VSS.n868 VSS.n118 0.0338333
R3350 VSS.n924 VSS.n121 0.0338333
R3351 VSS.n869 VSS.n122 0.0338333
R3352 VSS.n923 VSS.n125 0.0338333
R3353 VSS.n870 VSS.n126 0.0338333
R3354 VSS.n922 VSS.n129 0.0338333
R3355 VSS.n699 VSS.n690 0.0324767
R3356 VSS.n716 VSS.n493 0.0324767
R3357 VSS.n722 VSS.n711 0.0324767
R3358 VSS.n756 VSS.n755 0.0313
R3359 VSS.n656 VSS.n653 0.0311977
R3360 VSS.n657 VSS.n654 0.0311977
R3361 VSS.n761 VSS.n739 0.0311977
R3362 VSS.n766 VSS.n740 0.0311977
R3363 VSS.n742 VSS.n741 0.0311977
R3364 VSS.n943 VSS.n66 0.0309529
R3365 VSS VSS.n530 0.0266989
R3366 VSS.n623 VSS.n530 0.0266989
R3367 VSS.n718 VSS.n712 0.0260814
R3368 VSS.n698 VSS.n691 0.0248023
R3369 VSS.n728 VSS.n727 0.0248023
R3370 VSS.n671 VSS 0.0241433
R3371 VSS.n936 VSS.n70 0.0238333
R3372 VSS.n857 VSS.n73 0.0238333
R3373 VSS.n935 VSS.n74 0.0238333
R3374 VSS.n858 VSS.n77 0.0238333
R3375 VSS.n934 VSS.n78 0.0238333
R3376 VSS.n859 VSS.n81 0.0238333
R3377 VSS.n933 VSS.n82 0.0238333
R3378 VSS.n860 VSS.n85 0.0238333
R3379 VSS.n932 VSS.n86 0.0238333
R3380 VSS.n861 VSS.n89 0.0238333
R3381 VSS.n931 VSS.n90 0.0238333
R3382 VSS.n862 VSS.n93 0.0238333
R3383 VSS.n930 VSS.n94 0.0238333
R3384 VSS.n863 VSS.n97 0.0238333
R3385 VSS.n929 VSS.n98 0.0238333
R3386 VSS.n864 VSS.n101 0.0238333
R3387 VSS.n928 VSS.n102 0.0238333
R3388 VSS.n865 VSS.n105 0.0238333
R3389 VSS.n927 VSS.n106 0.0238333
R3390 VSS.n866 VSS.n109 0.0238333
R3391 VSS.n926 VSS.n110 0.0238333
R3392 VSS.n867 VSS.n113 0.0238333
R3393 VSS.n925 VSS.n114 0.0238333
R3394 VSS.n868 VSS.n117 0.0238333
R3395 VSS.n924 VSS.n118 0.0238333
R3396 VSS.n869 VSS.n121 0.0238333
R3397 VSS.n923 VSS.n122 0.0238333
R3398 VSS.n870 VSS.n125 0.0238333
R3399 VSS.n922 VSS.n126 0.0238333
R3400 VSS.n623 VSS.n529 0.0233571
R3401 VSS.n532 VSS.n528 0.0233571
R3402 VSS.n601 VSS.n527 0.0233571
R3403 VSS.n534 VSS.n526 0.0233571
R3404 VSS.n599 VSS.n525 0.0233571
R3405 VSS.n536 VSS.n524 0.0233571
R3406 VSS.n597 VSS.n523 0.0233571
R3407 VSS.n538 VSS.n522 0.0233571
R3408 VSS.n595 VSS.n521 0.0233571
R3409 VSS.n540 VSS.n520 0.0233571
R3410 VSS.n593 VSS.n519 0.0233571
R3411 VSS.n542 VSS.n518 0.0233571
R3412 VSS.n591 VSS.n517 0.0233571
R3413 VSS.n544 VSS.n516 0.0233571
R3414 VSS.n589 VSS.n515 0.0233571
R3415 VSS.n546 VSS.n514 0.0233571
R3416 VSS.n586 VSS.n513 0.0205
R3417 VSS VSS.n681 0.019686
R3418 VSS.n548 VSS.n512 0.0195476
R3419 VSS.n582 VSS.n511 0.0195476
R3420 VSS.n550 VSS.n510 0.0195476
R3421 VSS.n580 VSS.n509 0.0195476
R3422 VSS.n552 VSS.n508 0.0195476
R3423 VSS.n578 VSS.n507 0.0195476
R3424 VSS.n554 VSS.n506 0.0195476
R3425 VSS.n576 VSS.n505 0.0195476
R3426 VSS.n556 VSS.n504 0.0195476
R3427 VSS.n574 VSS.n503 0.0195476
R3428 VSS.n558 VSS.n502 0.0195476
R3429 VSS.n572 VSS.n501 0.0195476
R3430 VSS.n560 VSS.n500 0.0195476
R3431 VSS.n570 VSS.n499 0.0195476
R3432 VSS.n562 VSS.n498 0.0195476
R3433 VSS.n671 VSS.n629 0.018407
R3434 VSS.n251 VSS.n129 0.0171667
R3435 VSS VSS.n734 0.0171279
R3436 VSS.n771 VSS.n770 0.017
R3437 VSS.n770 VSS 0.017
R3438 VSS.n749 VSS 0.017
R3439 VSS.n774 VSS.n773 0.0164884
R3440 VSS.n719 VSS.n718 0.0158488
R3441 VSS.n961 VSS.n960 0.0155
R3442 VSS VSS.n756 0.0148
R3443 VSS.n709 VSS 0.0147857
R3444 VSS.n548 VSS.n513 0.0138333
R3445 VSS.n582 VSS.n512 0.0138333
R3446 VSS.n550 VSS.n511 0.0138333
R3447 VSS.n552 VSS.n509 0.0138333
R3448 VSS.n578 VSS.n508 0.0138333
R3449 VSS.n554 VSS.n507 0.0138333
R3450 VSS.n576 VSS.n506 0.0138333
R3451 VSS.n556 VSS.n505 0.0138333
R3452 VSS.n574 VSS.n504 0.0138333
R3453 VSS.n558 VSS.n503 0.0138333
R3454 VSS.n572 VSS.n502 0.0138333
R3455 VSS.n560 VSS.n501 0.0138333
R3456 VSS.n570 VSS.n500 0.0138333
R3457 VSS.n562 VSS.n499 0.0138333
R3458 VSS.n569 VSS.n498 0.0138333
R3459 VSS.n656 VSS.n652 0.0132907
R3460 VSS.n657 VSS.n653 0.0132907
R3461 VSS.n681 VSS.n654 0.0132907
R3462 VSS.n763 VSS.n739 0.0132907
R3463 VSS.n761 VSS.n740 0.0132907
R3464 VSS.n766 VSS.n741 0.0132907
R3465 VSS.n774 VSS.n742 0.0132907
R3466 VSS.n699 VSS.n689 0.0120116
R3467 VSS.n698 VSS.n690 0.0120116
R3468 VSS.n728 VSS.n493 0.0120116
R3469 VSS.n716 VSS.n711 0.0120116
R3470 VSS.n722 VSS.n712 0.0120116
R3471 VSS.n580 VSS 0.0114524
R3472 VSS.n587 VSS.n586 0.0109762
R3473 VSS.n960 VSS.n959 0.0105
R3474 VSS.n841 VSS.n7 0.0105
R3475 VSS.n958 VSS.n10 0.0105
R3476 VSS.n842 VSS.n11 0.0105
R3477 VSS.n957 VSS.n14 0.0105
R3478 VSS.n843 VSS.n15 0.0105
R3479 VSS.n956 VSS.n18 0.0105
R3480 VSS.n844 VSS.n19 0.0105
R3481 VSS.n955 VSS.n22 0.0105
R3482 VSS.n845 VSS.n23 0.0105
R3483 VSS.n954 VSS.n26 0.0105
R3484 VSS.n846 VSS.n27 0.0105
R3485 VSS.n953 VSS.n30 0.0105
R3486 VSS.n847 VSS.n31 0.0105
R3487 VSS.n952 VSS.n34 0.0105
R3488 VSS.n848 VSS.n35 0.0105
R3489 VSS.n951 VSS.n38 0.0105
R3490 VSS.n849 VSS.n39 0.0105
R3491 VSS.n950 VSS.n42 0.0105
R3492 VSS.n850 VSS.n43 0.0105
R3493 VSS.n949 VSS.n46 0.0105
R3494 VSS.n851 VSS.n47 0.0105
R3495 VSS.n948 VSS.n50 0.0105
R3496 VSS.n852 VSS.n51 0.0105
R3497 VSS.n947 VSS.n54 0.0105
R3498 VSS.n853 VSS.n55 0.0105
R3499 VSS.n946 VSS.n58 0.0105
R3500 VSS.n854 VSS.n59 0.0105
R3501 VSS.n945 VSS.n62 0.0105
R3502 VSS.n855 VSS.n63 0.0105
R3503 VSS.n302 VSS.n299 0.0103854
R3504 VSS.n532 VSS.n529 0.0100238
R3505 VSS.n601 VSS.n528 0.0100238
R3506 VSS.n534 VSS.n527 0.0100238
R3507 VSS.n599 VSS.n526 0.0100238
R3508 VSS.n536 VSS.n525 0.0100238
R3509 VSS.n597 VSS.n524 0.0100238
R3510 VSS.n538 VSS.n523 0.0100238
R3511 VSS.n595 VSS.n522 0.0100238
R3512 VSS.n540 VSS.n521 0.0100238
R3513 VSS.n593 VSS.n520 0.0100238
R3514 VSS.n542 VSS.n519 0.0100238
R3515 VSS.n591 VSS.n518 0.0100238
R3516 VSS.n544 VSS.n517 0.0100238
R3517 VSS.n589 VSS.n516 0.0100238
R3518 VSS.n546 VSS.n515 0.0100238
R3519 VSS.n587 VSS.n514 0.0100238
R3520 VSS.n820 VSS.n138 0.00979325
R3521 VSS.n710 VSS.n709 0.00907143
R3522 VSS.n725 VSS.n494 0.00907143
R3523 VSS.n944 VSS.n943 0.00883333
R3524 VSS.n921 VSS.n295 0.00860878
R3525 VSS.n1002 VSS.n804 0.00792395
R3526 VSS.n646 VSS.n480 0.00773219
R3527 VSS.n780 VSS.n385 0.00773219
R3528 VSS.n896 VSS.n257 0.00677376
R3529 VSS.n895 VSS.n258 0.00677376
R3530 VSS.n894 VSS.n260 0.00677376
R3531 VSS.n893 VSS.n261 0.00677376
R3532 VSS.n892 VSS.n263 0.00677376
R3533 VSS.n891 VSS.n264 0.00677376
R3534 VSS.n890 VSS.n266 0.00677376
R3535 VSS.n889 VSS.n267 0.00677376
R3536 VSS.n888 VSS.n269 0.00677376
R3537 VSS.n887 VSS.n270 0.00677376
R3538 VSS.n885 VSS.n272 0.00677376
R3539 VSS.n884 VSS.n273 0.00677376
R3540 VSS.n913 VSS.n276 0.00677376
R3541 VSS.n902 VSS.n277 0.00677376
R3542 VSS.n912 VSS.n279 0.00677376
R3543 VSS.n903 VSS.n280 0.00677376
R3544 VSS.n911 VSS.n282 0.00677376
R3545 VSS.n904 VSS.n283 0.00677376
R3546 VSS.n910 VSS.n285 0.00677376
R3547 VSS.n905 VSS.n286 0.00677376
R3548 VSS.n909 VSS.n288 0.00677376
R3549 VSS.n906 VSS.n289 0.00677376
R3550 VSS.n908 VSS.n291 0.00677376
R3551 VSS.n907 VSS.n292 0.00677376
R3552 VSS.n916 VSS.n294 0.00677376
R3553 VSS.n965 VSS.n964 0.00677376
R3554 VSS.n900 VSS.n898 0.00656464
R3555 VSS.n660 VSS.n485 0.00645833
R3556 VSS.n659 VSS.n486 0.00645833
R3557 VSS.n661 VSS.n488 0.00645833
R3558 VSS.n710 VSS.n691 0.00621429
R3559 VSS.n727 VSS.n494 0.00621429
R3560 VSS.n744 VSS.n382 0.00619164
R3561 VSS.n745 VSS.n383 0.00619164
R3562 VSS.n752 VSS.n380 0.00619164
R3563 VSS.n996 VSS.n995 0.00614639
R3564 VSS.n967 VSS.n142 0.00614639
R3565 VSS.n994 VSS.n144 0.00614639
R3566 VSS.n968 VSS.n145 0.00614639
R3567 VSS.n993 VSS.n147 0.00614639
R3568 VSS.n969 VSS.n148 0.00614639
R3569 VSS.n992 VSS.n150 0.00614639
R3570 VSS.n970 VSS.n151 0.00614639
R3571 VSS.n991 VSS.n153 0.00614639
R3572 VSS.n971 VSS.n154 0.00614639
R3573 VSS.n990 VSS.n156 0.00614639
R3574 VSS.n972 VSS.n157 0.00614639
R3575 VSS.n989 VSS.n159 0.00614639
R3576 VSS.n987 VSS.n160 0.00614639
R3577 VSS.n985 VSS.n162 0.00614639
R3578 VSS.n973 VSS.n163 0.00614639
R3579 VSS.n984 VSS.n165 0.00614639
R3580 VSS.n974 VSS.n166 0.00614639
R3581 VSS.n983 VSS.n168 0.00614639
R3582 VSS.n975 VSS.n169 0.00614639
R3583 VSS.n982 VSS.n171 0.00614639
R3584 VSS.n976 VSS.n172 0.00614639
R3585 VSS.n981 VSS.n174 0.00614639
R3586 VSS.n977 VSS.n175 0.00614639
R3587 VSS.n980 VSS.n177 0.00614639
R3588 VSS.n978 VSS.n178 0.00614639
R3589 VSS.n979 VSS.n180 0.00614639
R3590 VSS.n670 VSS.n476 0.00569817
R3591 VSS.n667 VSS.n666 0.00544665
R3592 VSS.n919 VSS.n297 0.00510076
R3593 VSS.n823 VSS.n822 0.00510076
R3594 VSS.n1051 VSS 0.00489163
R3595 VSS.n618 VSS.n603 0.00474047
R3596 VSS.n917 VSS.n295 0.00455439
R3597 VSS.n920 VSS.n299 0.00455439
R3598 VSS.n823 VSS.n140 0.00455439
R3599 VSS.n838 VSS.n181 0.00455439
R3600 VSS.n965 VSS.n181 0.00455439
R3601 VSS.n996 VSS.n140 0.00455439
R3602 VSS.n921 VSS.n297 0.00455439
R3603 VSS.n820 VSS.n139 0.00455439
R3604 VSS.n485 VSS.n484 0.00453333
R3605 VSS.n663 VSS.n489 0.00453333
R3606 VSS.n746 VSS.n376 0.00453333
R3607 VSS.n406 VSS.n383 0.00453333
R3608 VSS.n255 VSS.n4 0.00441459
R3609 VSS.n676 VSS.n629 0.00433721
R3610 VSS.n695 VSS.n689 0.00433721
R3611 VSS.n630 VSS.n480 0.0041161
R3612 VSS.n646 VSS.n482 0.0041161
R3613 VSS.n407 VSS.n385 0.0041161
R3614 VSS.n781 VSS.n780 0.0041161
R3615 VSS.n1059 VSS 0.00363688
R3616 VSS.n1051 VSS.n1050 0.00363688
R3617 VSS.n1024 VSS.n804 0.00363688
R3618 VSS.n252 VSS.n130 0.00363167
R3619 VSS.n708 VSS.n706 0.00348323
R3620 VSS.n732 VSS.n730 0.00346951
R3621 VSS.n680 VSS.n678 0.00346951
R3622 VSS.n769 VSS.n758 0.00342046
R3623 VSS.n1002 VSS.n138 0.00336943
R3624 VSS.n781 VSS 0.00325
R3625 VSS.n255 VSS.n130 0.00324021
R3626 VSS.n675 VSS.n652 0.00305814
R3627 VSS.n693 VSS.n686 0.00305814
R3628 VSS.n701 VSS.n687 0.00305814
R3629 VSS.n696 VSS.n688 0.00305814
R3630 VSS.n719 VSS.n713 0.00305814
R3631 VSS.n720 VSS.n714 0.00305814
R3632 VSS.n734 VSS.n733 0.00305814
R3633 VSS.n744 VSS.n380 0.00304166
R3634 VSS.n745 VSS.n382 0.00304166
R3635 VSS.n752 VSS.n376 0.00304166
R3636 VSS.n920 VSS.n919 0.00300951
R3637 VSS.n822 VSS.n139 0.00300951
R3638 VSS VSS.n510 0.00288095
R3639 VSS.n1059 VSS.n302 0.00277701
R3640 VSS.n730 VSS.n726 0.00270234
R3641 VSS.n484 VSS.n482 0.0027
R3642 VSS.n407 VSS.n406 0.0027
R3643 VSS.n897 VSS.n4 0.0024573
R3644 VSS.n678 VSS.n668 0.0024282
R3645 VSS.n706 VSS.n705 0.0024282
R3646 VSS.n769 VSS.n764 0.0024282
R3647 VSS.n773 VSS.n756 0.0024186
R3648 VSS.n664 VSS.n663 0.00226067
R3649 VSS.n673 VSS.n672 0.00200915
R3650 VSS.n995 VSS.n142 0.00196388
R3651 VSS.n967 VSS.n144 0.00196388
R3652 VSS.n994 VSS.n145 0.00196388
R3653 VSS.n968 VSS.n147 0.00196388
R3654 VSS.n993 VSS.n148 0.00196388
R3655 VSS.n969 VSS.n150 0.00196388
R3656 VSS.n992 VSS.n151 0.00196388
R3657 VSS.n970 VSS.n153 0.00196388
R3658 VSS.n991 VSS.n154 0.00196388
R3659 VSS.n971 VSS.n156 0.00196388
R3660 VSS.n990 VSS.n157 0.00196388
R3661 VSS.n972 VSS.n159 0.00196388
R3662 VSS.n989 VSS.n160 0.00196388
R3663 VSS.n987 VSS.n162 0.00196388
R3664 VSS.n985 VSS.n163 0.00196388
R3665 VSS.n973 VSS.n165 0.00196388
R3666 VSS.n984 VSS.n166 0.00196388
R3667 VSS.n974 VSS.n168 0.00196388
R3668 VSS.n983 VSS.n169 0.00196388
R3669 VSS.n975 VSS.n171 0.00196388
R3670 VSS.n982 VSS.n172 0.00196388
R3671 VSS.n976 VSS.n174 0.00196388
R3672 VSS.n981 VSS.n175 0.00196388
R3673 VSS.n977 VSS.n177 0.00196388
R3674 VSS.n980 VSS.n178 0.00196388
R3675 VSS.n978 VSS.n180 0.00196388
R3676 VSS.n979 VSS.n838 0.00196388
R3677 VSS.n672 VSS.n671 0.00184146
R3678 VSS VSS.n1069 0.00171681
R3679 VSS.n392 VSS.n391 0.00166667
R3680 VSS.n134 VSS.n2 0.00166667
R3681 VSS.n900 VSS.n257 0.0013365
R3682 VSS.n896 VSS.n258 0.0013365
R3683 VSS.n895 VSS.n260 0.0013365
R3684 VSS.n894 VSS.n261 0.0013365
R3685 VSS.n893 VSS.n263 0.0013365
R3686 VSS.n892 VSS.n264 0.0013365
R3687 VSS.n891 VSS.n266 0.0013365
R3688 VSS.n890 VSS.n267 0.0013365
R3689 VSS.n889 VSS.n269 0.0013365
R3690 VSS.n888 VSS.n270 0.0013365
R3691 VSS.n887 VSS.n272 0.0013365
R3692 VSS.n885 VSS.n273 0.0013365
R3693 VSS.n884 VSS.n276 0.0013365
R3694 VSS.n913 VSS.n277 0.0013365
R3695 VSS.n902 VSS.n279 0.0013365
R3696 VSS.n912 VSS.n280 0.0013365
R3697 VSS.n903 VSS.n282 0.0013365
R3698 VSS.n911 VSS.n283 0.0013365
R3699 VSS.n904 VSS.n285 0.0013365
R3700 VSS.n910 VSS.n286 0.0013365
R3701 VSS.n905 VSS.n288 0.0013365
R3702 VSS.n909 VSS.n289 0.0013365
R3703 VSS.n906 VSS.n291 0.0013365
R3704 VSS.n908 VSS.n292 0.0013365
R3705 VSS.n907 VSS.n294 0.0013365
R3706 VSS.n917 VSS.n916 0.0013365
R3707 VSS.n964 VSS.n183 0.0013365
R3708 VSS.n962 VSS.n183 0.0013365
R3709 VSS.n391 VSS.n1 0.00133332
R3710 VSS.n134 VSS.n1 0.00133332
R3711 VSS.n395 VSS.t170 0.00129121
R3712 VSS.n253 VSS.n251 0.00128292
R3713 VSS.n253 VSS.n252 0.00128292
R3714 VSS.n897 VSS.n256 0.00128292
R3715 VSS.t16 VSS.n901 0.00124999
R3716 VSS.n395 VSS.t169 0.00117081
R3717 VSS.n747 VSS.n746 0.00105
R3718 VSS.n667 VSS.n490 0.00100305
R3719 VSS.n670 VSS.n477 0.00100305
R3720 VSS.n673 VSS.n476 0.00100305
R3721 VSS.n783 VSS.n374 0.001
R3722 VSS.n374 VSS.n367 0.001
R3723 VSS.n404 VSS.n368 0.001
R3724 VSS.n403 VSS.n369 0.001
R3725 VSS.n402 VSS.n370 0.001
R3726 VSS.n401 VSS.n371 0.001
R3727 VSS.n400 VSS.n372 0.001
R3728 VSS.n399 VSS.n373 0.001
R3729 VSS.n645 VSS.n631 0.001
R3730 VSS.n632 VSS.n631 0.001
R3731 VSS.n634 VSS.n633 0.001
R3732 VSS.n636 VSS.n635 0.001
R3733 VSS.n638 VSS.n637 0.001
R3734 VSS.n640 VSS.n639 0.001
R3735 VSS.n643 VSS.n641 0.001
R3736 VSS.n642 VSS.n479 0.001
R3737 VSS.n567 VSS.n566 0.001
R3738 VSS.n567 VSS.n563 0.001
R3739 VSS.n319 VSS.n312 0.001
R3740 VSS.n352 VSS.n313 0.001
R3741 VSS.n351 VSS.n314 0.001
R3742 VSS.n350 VSS.n315 0.001
R3743 VSS.n349 VSS.n316 0.001
R3744 VSS.n348 VSS.n317 0.001
R3745 VSS.n347 VSS.n318 0.001
R3746 VSS.n1047 VSS.n1046 0.001
R3747 VSS.n1047 VSS.n354 0.001
R3748 VSS.n356 VSS.n355 0.001
R3749 VSS.n359 VSS.n357 0.001
R3750 VSS.n364 VSS.n358 0.001
R3751 VSS.n363 VSS.n332 0.001
R3752 VSS.n1060 VSS.n136 0.001
R3753 VSS.n1001 VSS.n813 0.001
R3754 VSS.n1000 VSS.n814 0.001
R3755 VSS.n999 VSS.n815 0.001
R3756 VSS.n998 VSS.n816 0.001
R3757 VSS.n997 VSS.n817 0.001
R3758 VSS.n1004 VSS.n818 0.001
R3759 VSS.n1058 VSS.n301 0.001
R3760 VSS.n1058 VSS.n1057 0.001
R3761 VSS.n307 VSS.n306 0.001
R3762 VSS.n308 VSS.n305 0.001
R3763 VSS.n309 VSS.n304 0.001
R3764 VSS.n310 VSS.n303 0.001
R3765 VSS.n792 VSS.n785 0.001
R3766 VSS.n1026 VSS.n786 0.001
R3767 VSS.n1028 VSS.n787 0.001
R3768 VSS.n1030 VSS.n788 0.001
R3769 VSS.n1032 VSS.n789 0.001
R3770 VSS.n1034 VSS.n790 0.001
R3771 VSS.n1036 VSS.n791 0.001
R3772 VSS.n1007 VSS.n1006 0.001
R3773 VSS.n1006 VSS.n806 0.001
R3774 VSS.n808 VSS.n807 0.001
R3775 VSS.n810 VSS.n809 0.001
R3776 VSS.n812 VSS.n811 0.001
R3777 VSS.n1009 VSS.n805 0.001
R3778 VSS.n388 VSS.n8 0.001
R3779 VSS.n389 VSS.n388 0.001
R3780 VSS.n1063 VSS.n3 0.001
R3781 VSS.n133 VSS.n3 0.001
R3782 VSS.t16 VSS.n886 0.001
R3783 VSS.n914 VSS.t16 0.001
R3784 VSS.n915 VSS.n914 0.001
R3785 VSS.n899 VSS.n886 0.001
R3786 VSS.t4 VSS.n988 0.001
R3787 VSS.n988 VSS.n986 0.001
R3788 VSS.n1064 VSS.n1063 0.001
R3789 VSS.n1064 VSS.n8 0.001
R3790 VSS.n392 VSS.n389 0.001
R3791 VSS.n133 VSS.n2 0.001
R3792 VSS.n1007 VSS.n792 0.001
R3793 VSS.n1026 VSS.n785 0.001
R3794 VSS.n1028 VSS.n786 0.001
R3795 VSS.n1030 VSS.n787 0.001
R3796 VSS.n1032 VSS.n788 0.001
R3797 VSS.n1034 VSS.n789 0.001
R3798 VSS.n1036 VSS.n790 0.001
R3799 VSS.n1039 VSS.n1009 0.001
R3800 VSS.n812 VSS.n805 0.001
R3801 VSS.n811 VSS.n810 0.001
R3802 VSS.n809 VSS.n808 0.001
R3803 VSS.n807 VSS.n806 0.001
R3804 VSS.n1039 VSS.n791 0.001
R3805 VSS.n1060 VSS.n301 0.001
R3806 VSS.n1001 VSS.n136 0.001
R3807 VSS.n1000 VSS.n813 0.001
R3808 VSS.n999 VSS.n814 0.001
R3809 VSS.n998 VSS.n815 0.001
R3810 VSS.n997 VSS.n816 0.001
R3811 VSS.n818 VSS.n817 0.001
R3812 VSS.n1003 VSS.n310 0.001
R3813 VSS.n309 VSS.n303 0.001
R3814 VSS.n308 VSS.n304 0.001
R3815 VSS.n307 VSS.n305 0.001
R3816 VSS.n1057 VSS.n306 0.001
R3817 VSS.n1004 VSS.n1003 0.001
R3818 VSS.n1046 VSS.n319 0.001
R3819 VSS.n352 VSS.n312 0.001
R3820 VSS.n351 VSS.n313 0.001
R3821 VSS.n350 VSS.n314 0.001
R3822 VSS.n349 VSS.n315 0.001
R3823 VSS.n348 VSS.n316 0.001
R3824 VSS.n347 VSS.n317 0.001
R3825 VSS.n1052 VSS.n332 0.001
R3826 VSS.n364 VSS.n363 0.001
R3827 VSS.n358 VSS.n357 0.001
R3828 VSS.n359 VSS.n356 0.001
R3829 VSS.n355 VSS.n354 0.001
R3830 VSS.n1052 VSS.n318 0.001
R3831 VSS.n782 VSS.n378 0.001
R3832 VSS.n662 VSS.t12 0.001
R3833 VSS.n665 VSS.n662 0.001
R3834 VSS.n775 VSS.n645 0.001
R3835 VSS.n633 VSS.n632 0.001
R3836 VSS.n635 VSS.n634 0.001
R3837 VSS.n637 VSS.n636 0.001
R3838 VSS.n639 VSS.n638 0.001
R3839 VSS.n641 VSS.n640 0.001
R3840 VSS.n643 VSS.n642 0.001
R3841 VSS.n779 VSS.n479 0.001
R3842 VSS.n625 VSS.n563 0.001
R3843 VSS.n775 VSS.n378 0.001
R3844 VSS.n783 VSS.n782 0.001
R3845 VSS.n399 VSS.n372 0.001
R3846 VSS.n400 VSS.n371 0.001
R3847 VSS.n401 VSS.n370 0.001
R3848 VSS.n402 VSS.n369 0.001
R3849 VSS.n403 VSS.n368 0.001
R3850 VSS.n404 VSS.n367 0.001
R3851 VSS.n779 VSS.n373 0.001
R3852 VSS.n660 VSS.n486 0.000775
R3853 VSS.n659 VSS.n488 0.000775
R3854 VSS.n661 VSS.n489 0.000775
R3855 VSS.n664 VSS.n490 0.000751524
R3856 VSS.n666 VSS.n477 0.000751524
R3857 VSS.n898 VSS.n256 0.00069573
R3858 VRAMP.n43 VRAMP.t2 25.633
R3859 VRAMP.n43 VRAMP.t3 25.4884
R3860 VRAMP.n14 VRAMP.t15 7.2053
R3861 VRAMP VRAMP.n14 5.66874
R3862 VRAMP.n13 VRAMP.t14 4.87123
R3863 VRAMP.t1 VRAMP.n42 3.61137
R3864 VRAMP.n49 VRAMP.n48 3.6005
R3865 VRAMP.n13 VRAMP 3.50243
R3866 VRAMP.n47 VRAMP.t6 3.30788
R3867 VRAMP.n41 VRAMP.t12 3.3031
R3868 VRAMP.n40 VRAMP.t7 3.3031
R3869 VRAMP.n45 VRAMP.t5 3.2573
R3870 VRAMP.n42 VRAMP.t4 2.71416
R3871 VRAMP.n41 VRAMP.t8 2.71416
R3872 VRAMP.n40 VRAMP.t11 2.71416
R3873 VRAMP.n47 VRAMP.t10 2.71416
R3874 VRAMP.n46 VRAMP.t9 2.71416
R3875 VRAMP.n45 VRAMP.t13 2.71416
R3876 VRAMP.n14 VRAMP.n13 1.79808
R3877 VRAMP.n55 VRAMP 0.896408
R3878 VRAMP.n44 VRAMP.n43 0.5405
R3879 VRAMP.n42 VRAMP.n40 0.534786
R3880 VRAMP.n42 VRAMP.n41 0.534786
R3881 VRAMP.n46 VRAMP.n45 0.534786
R3882 VRAMP.n15 VRAMP 0.51488
R3883 VRAMP.n48 VRAMP.n47 0.4955
R3884 VRAMP.n53 VRAMP.n52 0.30396
R3885 VRAMP.n17 VRAMP.n16 0.302727
R3886 VRAMP.n12 VRAMP.n11 0.3005
R3887 VRAMP.n27 VRAMP.n26 0.3005
R3888 VRAMP.n28 VRAMP.n10 0.3005
R3889 VRAMP.n30 VRAMP.n29 0.3005
R3890 VRAMP.n8 VRAMP.n7 0.3005
R3891 VRAMP.n38 VRAMP.n37 0.3005
R3892 VRAMP.n39 VRAMP.n6 0.3005
R3893 VRAMP.n51 VRAMP.n50 0.3005
R3894 VRAMP.n19 VRAMP.n18 0.3005
R3895 VRAMP.n22 VRAMP.n12 0.3005
R3896 VRAMP.n26 VRAMP.n25 0.3005
R3897 VRAMP.n10 VRAMP.n9 0.3005
R3898 VRAMP.n31 VRAMP.n30 0.3005
R3899 VRAMP.n34 VRAMP.n8 0.3005
R3900 VRAMP.n37 VRAMP.n36 0.3005
R3901 VRAMP.n6 VRAMP.n5 0.3005
R3902 VRAMP.n52 VRAMP.n51 0.3005
R3903 VRAMP.n20 VRAMP.n19 0.3005
R3904 VRAMP.n22 VRAMP.n21 0.3005
R3905 VRAMP.n25 VRAMP.n24 0.3005
R3906 VRAMP.n23 VRAMP.n9 0.3005
R3907 VRAMP.n32 VRAMP.n31 0.3005
R3908 VRAMP.n34 VRAMP.n33 0.3005
R3909 VRAMP.n36 VRAMP.n35 0.3005
R3910 VRAMP.n5 VRAMP.n4 0.3005
R3911 VRAMP.n16 VRAMP.n15 0.3005
R3912 VRAMP.n17 VRAMP.n11 0.151419
R3913 VRAMP.n54 VRAMP.n53 0.14952
R3914 VRAMP.n54 VRAMP.n3 0.14952
R3915 VRAMP.n54 VRAMP.n2 0.14952
R3916 VRAMP.n54 VRAMP.n1 0.14952
R3917 VRAMP.n54 VRAMP.n0 0.14952
R3918 VRAMP VRAMP.n54 0.148381
R3919 VRAMP VRAMP.n55 0.11252
R3920 VRAMP.t0 VRAMP.n44 0.0449165
R3921 VRAMP.n44 VRAMP.t1 0.0440835
R3922 VRAMP.n48 VRAMP.n46 0.0397857
R3923 VRAMP.n55 VRAMP 0.0350651
R3924 VRAMP.n50 VRAMP.n49 0.0243262
R3925 VRAMP.n49 VRAMP.t0 0.011201
R3926 VRAMP.n21 VRAMP.n20 0.00647877
R3927 VRAMP.n24 VRAMP.n23 0.00647877
R3928 VRAMP.n33 VRAMP.n32 0.00647877
R3929 VRAMP.n35 VRAMP.n4 0.00647877
R3930 VRAMP.n18 VRAMP.n12 0.00396798
R3931 VRAMP.n26 VRAMP.n12 0.00396798
R3932 VRAMP.n26 VRAMP.n10 0.00396798
R3933 VRAMP.n30 VRAMP.n10 0.00396798
R3934 VRAMP.n30 VRAMP.n8 0.00396798
R3935 VRAMP.n37 VRAMP.n8 0.00396798
R3936 VRAMP.n37 VRAMP.n6 0.00396798
R3937 VRAMP.n51 VRAMP.n6 0.00396798
R3938 VRAMP.n19 VRAMP.n16 0.00396798
R3939 VRAMP.n22 VRAMP.n19 0.00396798
R3940 VRAMP.n25 VRAMP.n22 0.00396798
R3941 VRAMP.n25 VRAMP.n9 0.00396798
R3942 VRAMP.n31 VRAMP.n9 0.00396798
R3943 VRAMP.n34 VRAMP.n31 0.00396798
R3944 VRAMP.n36 VRAMP.n34 0.00396798
R3945 VRAMP.n36 VRAMP.n5 0.00396798
R3946 VRAMP.n52 VRAMP.n5 0.00396798
R3947 VRAMP.n20 VRAMP.n0 0.00395989
R3948 VRAMP.n24 VRAMP.n1 0.00395989
R3949 VRAMP.n32 VRAMP.n2 0.00395989
R3950 VRAMP.n35 VRAMP.n3 0.00395989
R3951 VRAMP.n53 VRAMP.n4 0.00395989
R3952 VRAMP.n33 VRAMP.n3 0.00395989
R3953 VRAMP.n23 VRAMP.n2 0.00395989
R3954 VRAMP.n21 VRAMP.n1 0.00395989
R3955 VRAMP.n15 VRAMP.n0 0.00395989
R3956 VRAMP.n18 VRAMP.n17 0.0027211
R3957 VRAMP.n27 VRAMP.n11 0.00152524
R3958 VRAMP.n28 VRAMP.n27 0.00152524
R3959 VRAMP.n29 VRAMP.n28 0.00152524
R3960 VRAMP.n29 VRAMP.n7 0.00152524
R3961 VRAMP.n38 VRAMP.n7 0.00152524
R3962 VRAMP.n39 VRAMP.n38 0.00152524
R3963 VRAMP.n50 VRAMP.n39 0.00152524
R3964 VMEAS.n0 VMEAS.t0 12.0571
R3965 VMEAS VMEAS.n0 9.9137
R3966 VMEAS.n0 VMEAS 0.779533
R3967 SEL_MEAS.n4 SEL_MEAS.t0 6.45081
R3968 SEL_MEAS.n0 SEL_MEAS.t2 6.45038
R3969 SEL_MEAS.n0 SEL_MEAS.t9 6.02698
R3970 SEL_MEAS.n1 SEL_MEAS.t4 6.02698
R3971 SEL_MEAS.n2 SEL_MEAS.t3 6.02698
R3972 SEL_MEAS.n3 SEL_MEAS.t6 6.02698
R3973 SEL_MEAS.n7 SEL_MEAS.t5 6.02698
R3974 SEL_MEAS.n6 SEL_MEAS.t7 6.02698
R3975 SEL_MEAS.n5 SEL_MEAS.t8 6.02698
R3976 SEL_MEAS.n4 SEL_MEAS.t1 6.02698
R3977 SEL_MEAS SEL_MEAS.n9 2.95658
R3978 SEL_MEAS.n9 SEL_MEAS.n8 0.932623
R3979 SEL_MEAS.n9 SEL_MEAS 0.74522
R3980 SEL_MEAS.n1 SEL_MEAS.n0 0.423896
R3981 SEL_MEAS.n2 SEL_MEAS.n1 0.423896
R3982 SEL_MEAS.n3 SEL_MEAS.n2 0.423896
R3983 SEL_MEAS.n7 SEL_MEAS.n6 0.423896
R3984 SEL_MEAS.n6 SEL_MEAS.n5 0.423896
R3985 SEL_MEAS.n5 SEL_MEAS.n4 0.423896
R3986 SEL_MEAS.n8 SEL_MEAS.n3 0.411443
R3987 SEL_MEAS.n8 SEL_MEAS.n7 0.0129528
R3988 ramp_generator_0.ramp_generator_input_select_0.v_cmp.n0 ramp_generator_0.ramp_generator_input_select_0.v_cmp.t22 6.66783
R3989 ramp_generator_0.ramp_generator_input_select_0.v_cmp.n10 ramp_generator_0.ramp_generator_input_select_0.v_cmp.t16 6.45081
R3990 ramp_generator_0.ramp_generator_input_select_0.v_cmp.n1 ramp_generator_0.ramp_generator_input_select_0.v_cmp.t7 6.45081
R3991 ramp_generator_0.ramp_generator_input_select_0.v_cmp.n10 ramp_generator_0.ramp_generator_input_select_0.v_cmp.t15 6.02741
R3992 ramp_generator_0.ramp_generator_input_select_0.v_cmp.n11 ramp_generator_0.ramp_generator_input_select_0.v_cmp.t18 6.02741
R3993 ramp_generator_0.ramp_generator_input_select_0.v_cmp.n12 ramp_generator_0.ramp_generator_input_select_0.v_cmp.t19 6.02741
R3994 ramp_generator_0.ramp_generator_input_select_0.v_cmp.n13 ramp_generator_0.ramp_generator_input_select_0.v_cmp.t13 6.02741
R3995 ramp_generator_0.ramp_generator_input_select_0.v_cmp.n14 ramp_generator_0.ramp_generator_input_select_0.v_cmp.t14 6.02741
R3996 ramp_generator_0.ramp_generator_input_select_0.v_cmp.n15 ramp_generator_0.ramp_generator_input_select_0.v_cmp.t17 6.02741
R3997 ramp_generator_0.ramp_generator_input_select_0.v_cmp.n16 ramp_generator_0.ramp_generator_input_select_0.v_cmp.t12 6.02741
R3998 ramp_generator_0.ramp_generator_input_select_0.v_cmp.n17 ramp_generator_0.ramp_generator_input_select_0.v_cmp.t11 6.02741
R3999 ramp_generator_0.ramp_generator_input_select_0.v_cmp.n18 ramp_generator_0.ramp_generator_input_select_0.v_cmp.t20 6.02741
R4000 ramp_generator_0.ramp_generator_input_select_0.v_cmp.n19 ramp_generator_0.ramp_generator_input_select_0.v_cmp.t3 6.02741
R4001 ramp_generator_0.ramp_generator_input_select_0.v_cmp.n9 ramp_generator_0.ramp_generator_input_select_0.v_cmp.t6 6.02741
R4002 ramp_generator_0.ramp_generator_input_select_0.v_cmp.n8 ramp_generator_0.ramp_generator_input_select_0.v_cmp.t2 6.02741
R4003 ramp_generator_0.ramp_generator_input_select_0.v_cmp.n7 ramp_generator_0.ramp_generator_input_select_0.v_cmp.t5 6.02741
R4004 ramp_generator_0.ramp_generator_input_select_0.v_cmp.n6 ramp_generator_0.ramp_generator_input_select_0.v_cmp.t1 6.02741
R4005 ramp_generator_0.ramp_generator_input_select_0.v_cmp.n5 ramp_generator_0.ramp_generator_input_select_0.v_cmp.t10 6.02741
R4006 ramp_generator_0.ramp_generator_input_select_0.v_cmp.n4 ramp_generator_0.ramp_generator_input_select_0.v_cmp.t0 6.02741
R4007 ramp_generator_0.ramp_generator_input_select_0.v_cmp.n3 ramp_generator_0.ramp_generator_input_select_0.v_cmp.t9 6.02741
R4008 ramp_generator_0.ramp_generator_input_select_0.v_cmp.n1 ramp_generator_0.ramp_generator_input_select_0.v_cmp.t8 6.02741
R4009 ramp_generator_0.ramp_generator_input_select_0.v_cmp.n2 ramp_generator_0.ramp_generator_input_select_0.v_cmp.t4 6.02676
R4010 ramp_generator_0.ramp_generator_input_select_0.v_cmp.n0 ramp_generator_0.ramp_generator_input_select_0.v_cmp.t21 4.87123
R4011 ramp_generator_0.ramp_generator_input_select_0.v_cmp ramp_generator_0.ramp_generator_input_select_0.v_cmp.n0 3.9033
R4012 ramp_generator_0.ramp_generator_input_select_0.v_cmp ramp_generator_0.ramp_generator_input_select_0.v_cmp.n20 3.6135
R4013 ramp_generator_0.ramp_generator_input_select_0.v_cmp.n2 ramp_generator_0.ramp_generator_input_select_0.v_cmp.n1 0.423896
R4014 ramp_generator_0.ramp_generator_input_select_0.v_cmp.n3 ramp_generator_0.ramp_generator_input_select_0.v_cmp.n2 0.423896
R4015 ramp_generator_0.ramp_generator_input_select_0.v_cmp.n4 ramp_generator_0.ramp_generator_input_select_0.v_cmp.n3 0.423896
R4016 ramp_generator_0.ramp_generator_input_select_0.v_cmp.n5 ramp_generator_0.ramp_generator_input_select_0.v_cmp.n4 0.423896
R4017 ramp_generator_0.ramp_generator_input_select_0.v_cmp.n6 ramp_generator_0.ramp_generator_input_select_0.v_cmp.n5 0.423896
R4018 ramp_generator_0.ramp_generator_input_select_0.v_cmp.n7 ramp_generator_0.ramp_generator_input_select_0.v_cmp.n6 0.423896
R4019 ramp_generator_0.ramp_generator_input_select_0.v_cmp.n8 ramp_generator_0.ramp_generator_input_select_0.v_cmp.n7 0.423896
R4020 ramp_generator_0.ramp_generator_input_select_0.v_cmp.n9 ramp_generator_0.ramp_generator_input_select_0.v_cmp.n8 0.423896
R4021 ramp_generator_0.ramp_generator_input_select_0.v_cmp.n19 ramp_generator_0.ramp_generator_input_select_0.v_cmp.n18 0.423896
R4022 ramp_generator_0.ramp_generator_input_select_0.v_cmp.n18 ramp_generator_0.ramp_generator_input_select_0.v_cmp.n17 0.423896
R4023 ramp_generator_0.ramp_generator_input_select_0.v_cmp.n17 ramp_generator_0.ramp_generator_input_select_0.v_cmp.n16 0.423896
R4024 ramp_generator_0.ramp_generator_input_select_0.v_cmp.n16 ramp_generator_0.ramp_generator_input_select_0.v_cmp.n15 0.423896
R4025 ramp_generator_0.ramp_generator_input_select_0.v_cmp.n15 ramp_generator_0.ramp_generator_input_select_0.v_cmp.n14 0.423896
R4026 ramp_generator_0.ramp_generator_input_select_0.v_cmp.n14 ramp_generator_0.ramp_generator_input_select_0.v_cmp.n13 0.423896
R4027 ramp_generator_0.ramp_generator_input_select_0.v_cmp.n13 ramp_generator_0.ramp_generator_input_select_0.v_cmp.n12 0.423896
R4028 ramp_generator_0.ramp_generator_input_select_0.v_cmp.n12 ramp_generator_0.ramp_generator_input_select_0.v_cmp.n11 0.423896
R4029 ramp_generator_0.ramp_generator_input_select_0.v_cmp.n11 ramp_generator_0.ramp_generator_input_select_0.v_cmp.n10 0.423896
R4030 ramp_generator_0.ramp_generator_input_select_0.v_cmp.n20 ramp_generator_0.ramp_generator_input_select_0.v_cmp.n9 0.411443
R4031 ramp_generator_0.ramp_generator_input_select_0.v_cmp.n20 ramp_generator_0.ramp_generator_input_select_0.v_cmp.n19 0.0129528
R4032 SEL_CAL SEL_CAL.t0 13.035
R4033 VCAL.n5 VCAL.t4 6.45081
R4034 VCAL.n0 VCAL.t3 6.45038
R4035 VCAL.n0 VCAL.t6 6.02698
R4036 VCAL.n1 VCAL.t0 6.02698
R4037 VCAL.n2 VCAL.t5 6.02698
R4038 VCAL.n3 VCAL.t7 6.02698
R4039 VCAL.n4 VCAL.t1 6.02698
R4040 VCAL.n7 VCAL.t8 6.02698
R4041 VCAL.n6 VCAL.t2 6.02698
R4042 VCAL.n5 VCAL.t9 6.02698
R4043 VCAL VCAL.n9 1.04752
R4044 VCAL.n9 VCAL.n8 0.992184
R4045 VCAL.n9 VCAL 0.477747
R4046 VCAL.n1 VCAL.n0 0.423896
R4047 VCAL.n2 VCAL.n1 0.423896
R4048 VCAL.n3 VCAL.n2 0.423896
R4049 VCAL.n4 VCAL.n3 0.423896
R4050 VCAL.n7 VCAL.n6 0.423896
R4051 VCAL.n6 VCAL.n5 0.423896
R4052 VCAL.n8 VCAL.n7 0.421821
R4053 VCAL.n8 VCAL.n4 0.00257547
R4054 ota_lv_gmid_comparator_0.ota_slow_gmid_ctrl_buff_1.ota_slow_gmid_ctrl_inv_0.x ota_lv_gmid_comparator_0.ota_slow_gmid_ctrl_buff_1.ota_slow_gmid_ctrl_inv_0.x.t2 15.2608
R4055 ota_lv_gmid_comparator_0.ota_slow_gmid_ctrl_buff_1.ota_slow_gmid_ctrl_inv_0.x.n0 ota_lv_gmid_comparator_0.ota_slow_gmid_ctrl_buff_1.ota_slow_gmid_ctrl_inv_0.x.t1 3.55057
R4056 ota_lv_gmid_comparator_0.ota_slow_gmid_ctrl_buff_1.ota_slow_gmid_ctrl_inv_0.x.n0 ota_lv_gmid_comparator_0.ota_slow_gmid_ctrl_buff_1.ota_slow_gmid_ctrl_inv_0.x.t0 3.47311
R4057 ota_lv_gmid_comparator_0.ota_slow_gmid_ctrl_buff_1.ota_slow_gmid_ctrl_inv_0.x ota_lv_gmid_comparator_0.ota_slow_gmid_ctrl_buff_1.ota_slow_gmid_ctrl_inv_0.x.n0 0.204
R4058 ota_lv_gmid_comparator_0.ota_slow_gmid_ctrl_buff_1.y ota_lv_gmid_comparator_0.ota_slow_gmid_ctrl_buff_1.y.t2 7.76611
R4059 ota_lv_gmid_comparator_0.ota_slow_gmid_ctrl_buff_1.y.n0 ota_lv_gmid_comparator_0.ota_slow_gmid_ctrl_buff_1.y.t3 7.76611
R4060 ota_lv_gmid_comparator_0.ota_slow_gmid_ctrl_buff_1.y ota_lv_gmid_comparator_0.ota_slow_gmid_ctrl_buff_1.y.n1 7.6161
R4061 ota_lv_gmid_comparator_0.ota_slow_gmid_ctrl_buff_1.y.n1 ota_lv_gmid_comparator_0.ota_slow_gmid_ctrl_buff_1.y.n0 6.87119
R4062 ota_lv_gmid_comparator_0.ota_slow_gmid_ctrl_buff_1.y.n2 ota_lv_gmid_comparator_0.ota_slow_gmid_ctrl_buff_1.y.t1 3.54938
R4063 ota_lv_gmid_comparator_0.ota_slow_gmid_ctrl_buff_1.y.n2 ota_lv_gmid_comparator_0.ota_slow_gmid_ctrl_buff_1.y.t0 3.47311
R4064 ota_lv_gmid_comparator_0.ota_slow_gmid_ctrl_buff_1.y.n1 ota_lv_gmid_comparator_0.ota_slow_gmid_ctrl_buff_1.y 0.5901
R4065 ota_lv_gmid_comparator_0.ota_slow_gmid_ctrl_buff_1.y ota_lv_gmid_comparator_0.ota_slow_gmid_ctrl_buff_1.y.n2 0.204
R4066 ota_lv_gmid_comparator_0.ota_slow_gmid_ctrl_buff_1.y.n0 ota_lv_gmid_comparator_0.ota_slow_gmid_ctrl_buff_1.y 0.0387609
R4067 RAMP_EN.n1 RAMP_EN 32.6293
R4068 RAMP_EN.n0 RAMP_EN.t1 15.2113
R4069 RAMP_EN.n1 RAMP_EN.t0 13.761
R4070 RAMP_EN.n1 RAMP_EN 11.8343
R4071 RAMP_EN.n2 RAMP_EN 10.7695
R4072 RAMP_EN RAMP_EN.n0 5.6863
R4073 RAMP_EN RAMP_EN.n2 0.454409
R4074 RAMP_EN.n0 RAMP_EN 0.05
R4075 RAMP_EN.n2 RAMP_EN.n1 0.0453809
R4076 ramp_generator_0.ramp_generator_nmos_mirror_0.pmos_ref.n0 ramp_generator_0.ramp_generator_nmos_mirror_0.pmos_ref.t20 27.8189
R4077 ramp_generator_0.ramp_generator_nmos_mirror_0.pmos_ref.n0 ramp_generator_0.ramp_generator_nmos_mirror_0.pmos_ref.t21 18.2334
R4078 ramp_generator_0.ramp_generator_nmos_mirror_0.pmos_ref.n10 ramp_generator_0.ramp_generator_nmos_mirror_0.pmos_ref.t32 17.0005
R4079 ramp_generator_0.ramp_generator_nmos_mirror_0.pmos_ref.n51 ramp_generator_0.ramp_generator_nmos_mirror_0.pmos_ref.t30 17.0005
R4080 ramp_generator_0.ramp_generator_nmos_mirror_0.pmos_ref.n51 ramp_generator_0.ramp_generator_nmos_mirror_0.pmos_ref.t34 17.0005
R4081 ramp_generator_0.ramp_generator_nmos_mirror_0.pmos_ref.n49 ramp_generator_0.ramp_generator_nmos_mirror_0.pmos_ref.t41 17.0005
R4082 ramp_generator_0.ramp_generator_nmos_mirror_0.pmos_ref.n49 ramp_generator_0.ramp_generator_nmos_mirror_0.pmos_ref.t43 17.0005
R4083 ramp_generator_0.ramp_generator_nmos_mirror_0.pmos_ref.n47 ramp_generator_0.ramp_generator_nmos_mirror_0.pmos_ref.t52 17.0005
R4084 ramp_generator_0.ramp_generator_nmos_mirror_0.pmos_ref.n47 ramp_generator_0.ramp_generator_nmos_mirror_0.pmos_ref.t25 17.0005
R4085 ramp_generator_0.ramp_generator_nmos_mirror_0.pmos_ref.n45 ramp_generator_0.ramp_generator_nmos_mirror_0.pmos_ref.t29 17.0005
R4086 ramp_generator_0.ramp_generator_nmos_mirror_0.pmos_ref.n45 ramp_generator_0.ramp_generator_nmos_mirror_0.pmos_ref.t50 17.0005
R4087 ramp_generator_0.ramp_generator_nmos_mirror_0.pmos_ref.n52 ramp_generator_0.ramp_generator_nmos_mirror_0.pmos_ref.t23 17.0005
R4088 ramp_generator_0.ramp_generator_nmos_mirror_0.pmos_ref.n52 ramp_generator_0.ramp_generator_nmos_mirror_0.pmos_ref.t26 17.0005
R4089 ramp_generator_0.ramp_generator_nmos_mirror_0.pmos_ref.n1 ramp_generator_0.ramp_generator_nmos_mirror_0.pmos_ref.t38 17.0005
R4090 ramp_generator_0.ramp_generator_nmos_mirror_0.pmos_ref.n1 ramp_generator_0.ramp_generator_nmos_mirror_0.pmos_ref.t39 17.0005
R4091 ramp_generator_0.ramp_generator_nmos_mirror_0.pmos_ref.n12 ramp_generator_0.ramp_generator_nmos_mirror_0.pmos_ref.t45 17.0005
R4092 ramp_generator_0.ramp_generator_nmos_mirror_0.pmos_ref.n12 ramp_generator_0.ramp_generator_nmos_mirror_0.pmos_ref.t47 17.0005
R4093 ramp_generator_0.ramp_generator_nmos_mirror_0.pmos_ref.n14 ramp_generator_0.ramp_generator_nmos_mirror_0.pmos_ref.t37 17.0005
R4094 ramp_generator_0.ramp_generator_nmos_mirror_0.pmos_ref.n8 ramp_generator_0.ramp_generator_nmos_mirror_0.pmos_ref.t28 17.0005
R4095 ramp_generator_0.ramp_generator_nmos_mirror_0.pmos_ref.n8 ramp_generator_0.ramp_generator_nmos_mirror_0.pmos_ref.t49 17.0005
R4096 ramp_generator_0.ramp_generator_nmos_mirror_0.pmos_ref.n6 ramp_generator_0.ramp_generator_nmos_mirror_0.pmos_ref.t46 17.0005
R4097 ramp_generator_0.ramp_generator_nmos_mirror_0.pmos_ref.n6 ramp_generator_0.ramp_generator_nmos_mirror_0.pmos_ref.t40 17.0005
R4098 ramp_generator_0.ramp_generator_nmos_mirror_0.pmos_ref.n4 ramp_generator_0.ramp_generator_nmos_mirror_0.pmos_ref.t27 17.0005
R4099 ramp_generator_0.ramp_generator_nmos_mirror_0.pmos_ref.n4 ramp_generator_0.ramp_generator_nmos_mirror_0.pmos_ref.t48 17.0005
R4100 ramp_generator_0.ramp_generator_nmos_mirror_0.pmos_ref.n41 ramp_generator_0.ramp_generator_nmos_mirror_0.pmos_ref.t44 17.0005
R4101 ramp_generator_0.ramp_generator_nmos_mirror_0.pmos_ref.n41 ramp_generator_0.ramp_generator_nmos_mirror_0.pmos_ref.t42 17.0005
R4102 ramp_generator_0.ramp_generator_nmos_mirror_0.pmos_ref.n39 ramp_generator_0.ramp_generator_nmos_mirror_0.pmos_ref.t36 17.0005
R4103 ramp_generator_0.ramp_generator_nmos_mirror_0.pmos_ref.n39 ramp_generator_0.ramp_generator_nmos_mirror_0.pmos_ref.t33 17.0005
R4104 ramp_generator_0.ramp_generator_nmos_mirror_0.pmos_ref.n17 ramp_generator_0.ramp_generator_nmos_mirror_0.pmos_ref.t24 17.0005
R4105 ramp_generator_0.ramp_generator_nmos_mirror_0.pmos_ref.n17 ramp_generator_0.ramp_generator_nmos_mirror_0.pmos_ref.t51 17.0005
R4106 ramp_generator_0.ramp_generator_nmos_mirror_0.pmos_ref.n15 ramp_generator_0.ramp_generator_nmos_mirror_0.pmos_ref.t35 17.0005
R4107 ramp_generator_0.ramp_generator_nmos_mirror_0.pmos_ref.n15 ramp_generator_0.ramp_generator_nmos_mirror_0.pmos_ref.t31 17.0005
R4108 ramp_generator_0.ramp_generator_nmos_mirror_0.pmos_ref.n52 ramp_generator_0.ramp_generator_nmos_mirror_0.pmos_ref.n51 9.57126
R4109 ramp_generator_0.ramp_generator_nmos_mirror_0.pmos_ref.n27 ramp_generator_0.ramp_generator_nmos_mirror_0.pmos_ref.t2 6.46275
R4110 ramp_generator_0.ramp_generator_nmos_mirror_0.pmos_ref.n18 ramp_generator_0.ramp_generator_nmos_mirror_0.pmos_ref.t11 6.46232
R4111 ramp_generator_0.ramp_generator_nmos_mirror_0.pmos_ref.n18 ramp_generator_0.ramp_generator_nmos_mirror_0.pmos_ref.t0 6.08198
R4112 ramp_generator_0.ramp_generator_nmos_mirror_0.pmos_ref.n19 ramp_generator_0.ramp_generator_nmos_mirror_0.pmos_ref.t8 6.08198
R4113 ramp_generator_0.ramp_generator_nmos_mirror_0.pmos_ref.n20 ramp_generator_0.ramp_generator_nmos_mirror_0.pmos_ref.t16 6.08198
R4114 ramp_generator_0.ramp_generator_nmos_mirror_0.pmos_ref.n22 ramp_generator_0.ramp_generator_nmos_mirror_0.pmos_ref.t10 6.08198
R4115 ramp_generator_0.ramp_generator_nmos_mirror_0.pmos_ref.n23 ramp_generator_0.ramp_generator_nmos_mirror_0.pmos_ref.t14 6.08198
R4116 ramp_generator_0.ramp_generator_nmos_mirror_0.pmos_ref.n24 ramp_generator_0.ramp_generator_nmos_mirror_0.pmos_ref.t6 6.08198
R4117 ramp_generator_0.ramp_generator_nmos_mirror_0.pmos_ref.n25 ramp_generator_0.ramp_generator_nmos_mirror_0.pmos_ref.t7 6.08198
R4118 ramp_generator_0.ramp_generator_nmos_mirror_0.pmos_ref.n26 ramp_generator_0.ramp_generator_nmos_mirror_0.pmos_ref.t19 6.08198
R4119 ramp_generator_0.ramp_generator_nmos_mirror_0.pmos_ref.n35 ramp_generator_0.ramp_generator_nmos_mirror_0.pmos_ref.t15 6.08198
R4120 ramp_generator_0.ramp_generator_nmos_mirror_0.pmos_ref.n34 ramp_generator_0.ramp_generator_nmos_mirror_0.pmos_ref.t3 6.08198
R4121 ramp_generator_0.ramp_generator_nmos_mirror_0.pmos_ref.n33 ramp_generator_0.ramp_generator_nmos_mirror_0.pmos_ref.t18 6.08198
R4122 ramp_generator_0.ramp_generator_nmos_mirror_0.pmos_ref.n32 ramp_generator_0.ramp_generator_nmos_mirror_0.pmos_ref.t4 6.08198
R4123 ramp_generator_0.ramp_generator_nmos_mirror_0.pmos_ref.n31 ramp_generator_0.ramp_generator_nmos_mirror_0.pmos_ref.t13 6.08198
R4124 ramp_generator_0.ramp_generator_nmos_mirror_0.pmos_ref.n30 ramp_generator_0.ramp_generator_nmos_mirror_0.pmos_ref.t5 6.08198
R4125 ramp_generator_0.ramp_generator_nmos_mirror_0.pmos_ref.n29 ramp_generator_0.ramp_generator_nmos_mirror_0.pmos_ref.t1 6.08198
R4126 ramp_generator_0.ramp_generator_nmos_mirror_0.pmos_ref.n28 ramp_generator_0.ramp_generator_nmos_mirror_0.pmos_ref.t12 6.08198
R4127 ramp_generator_0.ramp_generator_nmos_mirror_0.pmos_ref.n27 ramp_generator_0.ramp_generator_nmos_mirror_0.pmos_ref.t17 6.08198
R4128 ramp_generator_0.ramp_generator_nmos_mirror_0.pmos_ref.n21 ramp_generator_0.ramp_generator_nmos_mirror_0.pmos_ref.t9 6.08098
R4129 ramp_generator_0.ramp_generator_nmos_mirror_0.pmos_ref.n37 ramp_generator_0.ramp_generator_nmos_mirror_0.pmos_ref.n36 3.67358
R4130 ramp_generator_0.ramp_generator_nmos_mirror_0.pmos_ref.n55 ramp_generator_0.ramp_generator_nmos_mirror_0.pmos_ref.n54 1.28773
R4131 ramp_generator_0.ramp_generator_nmos_mirror_0.pmos_ref.n44 ramp_generator_0.ramp_generator_nmos_mirror_0.pmos_ref.n43 1.2146
R4132 ramp_generator_0.ramp_generator_nmos_mirror_0.pmos_ref.n9 ramp_generator_0.ramp_generator_nmos_mirror_0.pmos_ref.t22 1.19911
R4133 ramp_generator_0.ramp_generator_nmos_mirror_0.pmos_ref.n13 ramp_generator_0.ramp_generator_nmos_mirror_0.pmos_ref.n3 1.19316
R4134 ramp_generator_0.ramp_generator_nmos_mirror_0.pmos_ref.n43 ramp_generator_0.ramp_generator_nmos_mirror_0.pmos_ref.n42 1.18317
R4135 ramp_generator_0.ramp_generator_nmos_mirror_0.pmos_ref.n7 ramp_generator_0.ramp_generator_nmos_mirror_0.pmos_ref.t22 1.08411
R4136 ramp_generator_0.ramp_generator_nmos_mirror_0.pmos_ref.n5 ramp_generator_0.ramp_generator_nmos_mirror_0.pmos_ref.t22 1.07312
R4137 ramp_generator_0.ramp_generator_nmos_mirror_0.pmos_ref.n50 ramp_generator_0.ramp_generator_nmos_mirror_0.pmos_ref.t22 1.07182
R4138 ramp_generator_0.ramp_generator_nmos_mirror_0.pmos_ref.n48 ramp_generator_0.ramp_generator_nmos_mirror_0.pmos_ref.n2 1.07152
R4139 ramp_generator_0.ramp_generator_nmos_mirror_0.pmos_ref.n46 ramp_generator_0.ramp_generator_nmos_mirror_0.pmos_ref.n3 1.06915
R4140 ramp_generator_0.ramp_generator_nmos_mirror_0.pmos_ref.n11 ramp_generator_0.ramp_generator_nmos_mirror_0.pmos_ref.n2 1.05896
R4141 ramp_generator_0.ramp_generator_nmos_mirror_0.pmos_ref.n40 ramp_generator_0.ramp_generator_nmos_mirror_0.pmos_ref.t22 1.05886
R4142 ramp_generator_0.ramp_generator_nmos_mirror_0.pmos_ref.n16 ramp_generator_0.ramp_generator_nmos_mirror_0.pmos_ref.t22 1.05886
R4143 ramp_generator_0.ramp_generator_nmos_mirror_0.pmos_ref.n38 ramp_generator_0.ramp_generator_nmos_mirror_0.pmos_ref.t22 1.05607
R4144 ramp_generator_0.ramp_generator_nmos_mirror_0.pmos_ref.n53 ramp_generator_0.ramp_generator_nmos_mirror_0.pmos_ref.t22 1.04639
R4145 ramp_generator_0.ramp_generator_nmos_mirror_0.pmos_ref ramp_generator_0.ramp_generator_nmos_mirror_0.pmos_ref.n0 0.7111
R4146 ramp_generator_0.ramp_generator_nmos_mirror_0.pmos_ref.n19 ramp_generator_0.ramp_generator_nmos_mirror_0.pmos_ref.n18 0.380839
R4147 ramp_generator_0.ramp_generator_nmos_mirror_0.pmos_ref.n20 ramp_generator_0.ramp_generator_nmos_mirror_0.pmos_ref.n19 0.380839
R4148 ramp_generator_0.ramp_generator_nmos_mirror_0.pmos_ref.n21 ramp_generator_0.ramp_generator_nmos_mirror_0.pmos_ref.n20 0.380839
R4149 ramp_generator_0.ramp_generator_nmos_mirror_0.pmos_ref.n22 ramp_generator_0.ramp_generator_nmos_mirror_0.pmos_ref.n21 0.380839
R4150 ramp_generator_0.ramp_generator_nmos_mirror_0.pmos_ref.n23 ramp_generator_0.ramp_generator_nmos_mirror_0.pmos_ref.n22 0.380839
R4151 ramp_generator_0.ramp_generator_nmos_mirror_0.pmos_ref.n24 ramp_generator_0.ramp_generator_nmos_mirror_0.pmos_ref.n23 0.380839
R4152 ramp_generator_0.ramp_generator_nmos_mirror_0.pmos_ref.n25 ramp_generator_0.ramp_generator_nmos_mirror_0.pmos_ref.n24 0.380839
R4153 ramp_generator_0.ramp_generator_nmos_mirror_0.pmos_ref.n26 ramp_generator_0.ramp_generator_nmos_mirror_0.pmos_ref.n25 0.380839
R4154 ramp_generator_0.ramp_generator_nmos_mirror_0.pmos_ref.n35 ramp_generator_0.ramp_generator_nmos_mirror_0.pmos_ref.n34 0.380839
R4155 ramp_generator_0.ramp_generator_nmos_mirror_0.pmos_ref.n34 ramp_generator_0.ramp_generator_nmos_mirror_0.pmos_ref.n33 0.380839
R4156 ramp_generator_0.ramp_generator_nmos_mirror_0.pmos_ref.n33 ramp_generator_0.ramp_generator_nmos_mirror_0.pmos_ref.n32 0.380839
R4157 ramp_generator_0.ramp_generator_nmos_mirror_0.pmos_ref.n32 ramp_generator_0.ramp_generator_nmos_mirror_0.pmos_ref.n31 0.380839
R4158 ramp_generator_0.ramp_generator_nmos_mirror_0.pmos_ref.n31 ramp_generator_0.ramp_generator_nmos_mirror_0.pmos_ref.n30 0.380839
R4159 ramp_generator_0.ramp_generator_nmos_mirror_0.pmos_ref.n30 ramp_generator_0.ramp_generator_nmos_mirror_0.pmos_ref.n29 0.380839
R4160 ramp_generator_0.ramp_generator_nmos_mirror_0.pmos_ref.n29 ramp_generator_0.ramp_generator_nmos_mirror_0.pmos_ref.n28 0.380839
R4161 ramp_generator_0.ramp_generator_nmos_mirror_0.pmos_ref.n28 ramp_generator_0.ramp_generator_nmos_mirror_0.pmos_ref.n27 0.380839
R4162 ramp_generator_0.ramp_generator_nmos_mirror_0.pmos_ref.n55 ramp_generator_0.ramp_generator_nmos_mirror_0.pmos_ref 0.3547
R4163 ramp_generator_0.ramp_generator_nmos_mirror_0.pmos_ref.n44 ramp_generator_0.ramp_generator_nmos_mirror_0.pmos_ref.n10 0.26175
R4164 ramp_generator_0.ramp_generator_nmos_mirror_0.pmos_ref.n42 ramp_generator_0.ramp_generator_nmos_mirror_0.pmos_ref.n14 0.26175
R4165 ramp_generator_0.ramp_generator_nmos_mirror_0.pmos_ref.n10 ramp_generator_0.ramp_generator_nmos_mirror_0.pmos_ref.n9 0.258312
R4166 ramp_generator_0.ramp_generator_nmos_mirror_0.pmos_ref.n14 ramp_generator_0.ramp_generator_nmos_mirror_0.pmos_ref.n13 0.248
R4167 ramp_generator_0.ramp_generator_nmos_mirror_0.pmos_ref.n13 ramp_generator_0.ramp_generator_nmos_mirror_0.pmos_ref.n12 0.201668
R4168 ramp_generator_0.ramp_generator_nmos_mirror_0.pmos_ref.n36 ramp_generator_0.ramp_generator_nmos_mirror_0.pmos_ref.n26 0.190669
R4169 ramp_generator_0.ramp_generator_nmos_mirror_0.pmos_ref.n36 ramp_generator_0.ramp_generator_nmos_mirror_0.pmos_ref.n35 0.190669
R4170 ramp_generator_0.ramp_generator_nmos_mirror_0.pmos_ref.n45 ramp_generator_0.ramp_generator_nmos_mirror_0.pmos_ref.n44 0.187918
R4171 ramp_generator_0.ramp_generator_nmos_mirror_0.pmos_ref.n9 ramp_generator_0.ramp_generator_nmos_mirror_0.pmos_ref.n8 0.187918
R4172 ramp_generator_0.ramp_generator_nmos_mirror_0.pmos_ref.n42 ramp_generator_0.ramp_generator_nmos_mirror_0.pmos_ref.n41 0.184481
R4173 ramp_generator_0.ramp_generator_nmos_mirror_0.pmos_ref ramp_generator_0.ramp_generator_nmos_mirror_0.pmos_ref.n55 0.0949533
R4174 ramp_generator_0.ramp_generator_nmos_mirror_0.pmos_ref.n47 ramp_generator_0.ramp_generator_nmos_mirror_0.pmos_ref.n46 0.0578913
R4175 ramp_generator_0.ramp_generator_nmos_mirror_0.pmos_ref.n8 ramp_generator_0.ramp_generator_nmos_mirror_0.pmos_ref.n7 0.0572935
R4176 ramp_generator_0.ramp_generator_nmos_mirror_0.pmos_ref.n39 ramp_generator_0.ramp_generator_nmos_mirror_0.pmos_ref.n38 0.0572935
R4177 ramp_generator_0.ramp_generator_nmos_mirror_0.pmos_ref.n49 ramp_generator_0.ramp_generator_nmos_mirror_0.pmos_ref.n48 0.0566957
R4178 ramp_generator_0.ramp_generator_nmos_mirror_0.pmos_ref.n11 ramp_generator_0.ramp_generator_nmos_mirror_0.pmos_ref.n1 0.0566957
R4179 ramp_generator_0.ramp_generator_nmos_mirror_0.pmos_ref.n6 ramp_generator_0.ramp_generator_nmos_mirror_0.pmos_ref.n5 0.0566957
R4180 ramp_generator_0.ramp_generator_nmos_mirror_0.pmos_ref.n17 ramp_generator_0.ramp_generator_nmos_mirror_0.pmos_ref.n16 0.0566957
R4181 ramp_generator_0.ramp_generator_nmos_mirror_0.pmos_ref.n51 ramp_generator_0.ramp_generator_nmos_mirror_0.pmos_ref.n50 0.0560978
R4182 ramp_generator_0.ramp_generator_nmos_mirror_0.pmos_ref.n53 ramp_generator_0.ramp_generator_nmos_mirror_0.pmos_ref.n52 0.0555
R4183 ramp_generator_0.ramp_generator_nmos_mirror_0.pmos_ref.n40 ramp_generator_0.ramp_generator_nmos_mirror_0.pmos_ref.n39 0.0555
R4184 ramp_generator_0.ramp_generator_nmos_mirror_0.pmos_ref.n41 ramp_generator_0.ramp_generator_nmos_mirror_0.pmos_ref.n40 0.0555
R4185 ramp_generator_0.ramp_generator_nmos_mirror_0.pmos_ref.n50 ramp_generator_0.ramp_generator_nmos_mirror_0.pmos_ref.n49 0.0549022
R4186 ramp_generator_0.ramp_generator_nmos_mirror_0.pmos_ref.n48 ramp_generator_0.ramp_generator_nmos_mirror_0.pmos_ref.n47 0.0543043
R4187 ramp_generator_0.ramp_generator_nmos_mirror_0.pmos_ref.n12 ramp_generator_0.ramp_generator_nmos_mirror_0.pmos_ref.n11 0.0543043
R4188 ramp_generator_0.ramp_generator_nmos_mirror_0.pmos_ref.n5 ramp_generator_0.ramp_generator_nmos_mirror_0.pmos_ref.n4 0.0543043
R4189 ramp_generator_0.ramp_generator_nmos_mirror_0.pmos_ref.n16 ramp_generator_0.ramp_generator_nmos_mirror_0.pmos_ref.n15 0.0543043
R4190 ramp_generator_0.ramp_generator_nmos_mirror_0.pmos_ref.n7 ramp_generator_0.ramp_generator_nmos_mirror_0.pmos_ref.n6 0.0537065
R4191 ramp_generator_0.ramp_generator_nmos_mirror_0.pmos_ref.n46 ramp_generator_0.ramp_generator_nmos_mirror_0.pmos_ref.n45 0.0531087
R4192 ramp_generator_0.ramp_generator_nmos_mirror_0.pmos_ref.n38 ramp_generator_0.ramp_generator_nmos_mirror_0.pmos_ref.n37 0.0471304
R4193 ramp_generator_0.ramp_generator_nmos_mirror_0.pmos_ref.n54 ramp_generator_0.ramp_generator_nmos_mirror_0.pmos_ref.n1 0.038163
R4194 ramp_generator_0.ramp_generator_nmos_mirror_0.pmos_ref.n54 ramp_generator_0.ramp_generator_nmos_mirror_0.pmos_ref.n53 0.017837
R4195 ramp_generator_0.ramp_generator_nmos_mirror_0.pmos_ref.n37 ramp_generator_0.ramp_generator_nmos_mirror_0.pmos_ref.n17 0.00707609
R4196 ramp_generator_0.ramp_generator_nmos_mirror_0.pmos_ref.n3 ramp_generator_0.ramp_generator_nmos_mirror_0.pmos_ref.t22 0.00137126
R4197 ramp_generator_0.ramp_generator_nmos_mirror_0.pmos_ref.n2 ramp_generator_0.ramp_generator_nmos_mirror_0.pmos_ref.t22 0.00135368
R4198 ramp_generator_0.ramp_generator_nmos_mirror_0.pmos_ref.n43 ramp_generator_0.ramp_generator_nmos_mirror_0.pmos_ref.t22 0.00132932
R4199 a_n2237_2812.t0 a_n2237_2812.t1 30.5928
R4200 ota_lv_gmid_comparator_0.ota_slow_gmid_mirror_0.vref.n2 ota_lv_gmid_comparator_0.ota_slow_gmid_mirror_0.vref 20.7344
R4201 ota_lv_gmid_comparator_0.ota_slow_gmid_mirror_0.vref.n0 ota_lv_gmid_comparator_0.ota_slow_gmid_mirror_0.vref.t4 19.5609
R4202 ota_lv_gmid_comparator_0.ota_slow_gmid_mirror_0.vref.n1 ota_lv_gmid_comparator_0.ota_slow_gmid_mirror_0.vref.t3 17.0658
R4203 ota_lv_gmid_comparator_0.ota_slow_gmid_mirror_0.vref.n2 ota_lv_gmid_comparator_0.ota_slow_gmid_mirror_0.vref.t1 13.9935
R4204 ota_lv_gmid_comparator_0.ota_slow_gmid_mirror_0.vref ota_lv_gmid_comparator_0.ota_slow_gmid_mirror_0.vref.n1 5.4971
R4205 ota_lv_gmid_comparator_0.ota_slow_gmid_mirror_0.vref.n3 ota_lv_gmid_comparator_0.ota_slow_gmid_mirror_0.vref.t0 5.39538
R4206 ota_lv_gmid_comparator_0.ota_slow_gmid_mirror_0.vref.n3 ota_lv_gmid_comparator_0.ota_slow_gmid_mirror_0.vref.n2 4.9175
R4207 ota_lv_gmid_comparator_0.ota_slow_gmid_mirror_0.vref.n1 ota_lv_gmid_comparator_0.ota_slow_gmid_mirror_0.vref.n0 2.51451
R4208 ota_lv_gmid_comparator_0.ota_slow_gmid_mirror_0.vref.n3 ota_lv_gmid_comparator_0.ota_slow_gmid_mirror_0.vref 0.0885
R4209 ota_lv_gmid_comparator_0.ota_slow_gmid_mirror_0.vref.n0 ota_lv_gmid_comparator_0.ota_slow_gmid_mirror_0.vref.t2 0.0523162
R4210 ota_lv_gmid_comparator_0.ota_slow_gmid_mirror_0.vref ota_lv_gmid_comparator_0.ota_slow_gmid_mirror_0.vref.n3 0.0445
R4211 ota_lv_gmid_comparator_0.ota_slow_gmid_mirror_0.vout1.n3 ota_lv_gmid_comparator_0.ota_slow_gmid_mirror_0.vout1.t13 31.5136
R4212 ota_lv_gmid_comparator_0.ota_slow_gmid_mirror_0.vout1.n1 ota_lv_gmid_comparator_0.ota_slow_gmid_mirror_0.vout1.t15 25.518
R4213 ota_lv_gmid_comparator_0.ota_slow_gmid_mirror_0.vout1.n2 ota_lv_gmid_comparator_0.ota_slow_gmid_mirror_0.vout1.t16 24.0005
R4214 ota_lv_gmid_comparator_0.ota_slow_gmid_mirror_0.vout1.n3 ota_lv_gmid_comparator_0.ota_slow_gmid_mirror_0.vout1.t12 17.0903
R4215 ota_lv_gmid_comparator_0.ota_slow_gmid_mirror_0.vout1.n4 ota_lv_gmid_comparator_0.ota_slow_gmid_mirror_0.vout1.t10 17.0903
R4216 ota_lv_gmid_comparator_0.ota_slow_gmid_mirror_0.vout1.n5 ota_lv_gmid_comparator_0.ota_slow_gmid_mirror_0.vout1.t11 17.01
R4217 ota_lv_gmid_comparator_0.ota_slow_gmid_mirror_0.vout1.n7 ota_lv_gmid_comparator_0.ota_slow_gmid_mirror_0.vout1 16.6531
R4218 ota_lv_gmid_comparator_0.ota_slow_gmid_mirror_0.vout1.n7 ota_lv_gmid_comparator_0.ota_slow_gmid_mirror_0.vout1.n6 14.4679
R4219 ota_lv_gmid_comparator_0.ota_slow_gmid_mirror_0.vout1.n5 ota_lv_gmid_comparator_0.ota_slow_gmid_mirror_0.vout1.n4 14.4641
R4220 ota_lv_gmid_comparator_0.ota_slow_gmid_mirror_0.vout1 ota_lv_gmid_comparator_0.ota_slow_gmid_mirror_0.vout1.n5 9.40045
R4221 ota_lv_gmid_comparator_0.ota_slow_gmid_mirror_0.vout1.n11 ota_lv_gmid_comparator_0.ota_slow_gmid_mirror_0.vout1.t3 9.25218
R4222 ota_lv_gmid_comparator_0.ota_slow_gmid_mirror_0.vout1.n12 ota_lv_gmid_comparator_0.ota_slow_gmid_mirror_0.vout1.t2 9.25218
R4223 ota_lv_gmid_comparator_0.ota_slow_gmid_mirror_0.vout1.n10 ota_lv_gmid_comparator_0.ota_slow_gmid_mirror_0.vout1.t0 9.25218
R4224 ota_lv_gmid_comparator_0.ota_slow_gmid_mirror_0.vout1.n9 ota_lv_gmid_comparator_0.ota_slow_gmid_mirror_0.vout1.t1 9.25218
R4225 ota_lv_gmid_comparator_0.ota_slow_gmid_mirror_0.vout1.n11 ota_lv_gmid_comparator_0.ota_slow_gmid_mirror_0.vout1.t7 9.14668
R4226 ota_lv_gmid_comparator_0.ota_slow_gmid_mirror_0.vout1.n12 ota_lv_gmid_comparator_0.ota_slow_gmid_mirror_0.vout1.t6 9.14586
R4227 ota_lv_gmid_comparator_0.ota_slow_gmid_mirror_0.vout1.n10 ota_lv_gmid_comparator_0.ota_slow_gmid_mirror_0.vout1.t4 9.14586
R4228 ota_lv_gmid_comparator_0.ota_slow_gmid_mirror_0.vout1.n9 ota_lv_gmid_comparator_0.ota_slow_gmid_mirror_0.vout1.t5 9.14586
R4229 ota_lv_gmid_comparator_0.ota_slow_gmid_mirror_0.vout1.n0 ota_lv_gmid_comparator_0.ota_slow_gmid_mirror_0.vout1.t8 7.70967
R4230 ota_lv_gmid_comparator_0.ota_slow_gmid_mirror_0.vout1.n1 ota_lv_gmid_comparator_0.ota_slow_gmid_mirror_0.vout1.t14 6.61988
R4231 ota_lv_gmid_comparator_0.ota_slow_gmid_mirror_0.vout1 ota_lv_gmid_comparator_0.ota_slow_gmid_mirror_0.vout1.n0 5.9369
R4232 ota_lv_gmid_comparator_0.ota_slow_gmid_mirror_0.vout1.n0 ota_lv_gmid_comparator_0.ota_slow_gmid_mirror_0.vout1.t9 5.64781
R4233 ota_lv_gmid_comparator_0.ota_slow_gmid_mirror_0.vout1.n8 ota_lv_gmid_comparator_0.ota_slow_gmid_mirror_0.vout1.n7 4.7645
R4234 ota_lv_gmid_comparator_0.ota_slow_gmid_mirror_0.vout1.n6 ota_lv_gmid_comparator_0.ota_slow_gmid_mirror_0.vout1.n2 2.33849
R4235 ota_lv_gmid_comparator_0.ota_slow_gmid_mirror_0.vout1.n6 ota_lv_gmid_comparator_0.ota_slow_gmid_mirror_0.vout1 2.27825
R4236 ota_lv_gmid_comparator_0.ota_slow_gmid_mirror_0.vout1.n4 ota_lv_gmid_comparator_0.ota_slow_gmid_mirror_0.vout1.n3 1.69241
R4237 ota_lv_gmid_comparator_0.ota_slow_gmid_mirror_0.vout1.n2 ota_lv_gmid_comparator_0.ota_slow_gmid_mirror_0.vout1 1.13084
R4238 ota_lv_gmid_comparator_0.ota_slow_gmid_mirror_0.vout1 ota_lv_gmid_comparator_0.ota_slow_gmid_mirror_0.vout1.n12 0.431138
R4239 ota_lv_gmid_comparator_0.ota_slow_gmid_mirror_0.vout1 ota_lv_gmid_comparator_0.ota_slow_gmid_mirror_0.vout1.n1 0.389879
R4240 ota_lv_gmid_comparator_0.ota_slow_gmid_mirror_0.vout1.n11 ota_lv_gmid_comparator_0.ota_slow_gmid_mirror_0.vout1.n10 0.382457
R4241 ota_lv_gmid_comparator_0.ota_slow_gmid_mirror_0.vout1.n12 ota_lv_gmid_comparator_0.ota_slow_gmid_mirror_0.vout1.n11 0.380585
R4242 ota_lv_gmid_comparator_0.ota_slow_gmid_mirror_0.vout1.n10 ota_lv_gmid_comparator_0.ota_slow_gmid_mirror_0.vout1.n9 0.380585
R4243 ota_lv_gmid_comparator_0.ota_slow_gmid_mirror_0.vout1 ota_lv_gmid_comparator_0.ota_slow_gmid_mirror_0.vout1.n8 0.0267128
R4244 ota_lv_gmid_comparator_0.ota_slow_gmid_mirror_0.vout1.n8 ota_lv_gmid_comparator_0.ota_slow_gmid_mirror_0.vout1 0.0261667
R4245 ota_lv_gmid_comparator_0.ota_slow_gmid_ctrl_buff_0.x.n5 ota_lv_gmid_comparator_0.ota_slow_gmid_ctrl_buff_0.x.t8 25.1081
R4246 ota_lv_gmid_comparator_0.ota_slow_gmid_ctrl_buff_0.x.n7 ota_lv_gmid_comparator_0.ota_slow_gmid_ctrl_buff_0.x.t6 24.4839
R4247 ota_lv_gmid_comparator_0.ota_slow_gmid_ctrl_buff_0.x.n6 ota_lv_gmid_comparator_0.ota_slow_gmid_ctrl_buff_0.x.t7 15.2168
R4248 ota_lv_gmid_comparator_0.ota_slow_gmid_ctrl_buff_0.x.n5 ota_lv_gmid_comparator_0.ota_slow_gmid_ctrl_buff_0.x.n4 9.87282
R4249 ota_lv_gmid_comparator_0.ota_slow_gmid_ctrl_buff_0.x.n7 ota_lv_gmid_comparator_0.ota_slow_gmid_ctrl_buff_0.x.n6 9.47717
R4250 ota_lv_gmid_comparator_0.ota_slow_gmid_ctrl_buff_0.x.n0 ota_lv_gmid_comparator_0.ota_slow_gmid_ctrl_buff_0.x.t3 6.77452
R4251 ota_lv_gmid_comparator_0.ota_slow_gmid_ctrl_buff_0.x.n1 ota_lv_gmid_comparator_0.ota_slow_gmid_ctrl_buff_0.x.t5 6.07327
R4252 ota_lv_gmid_comparator_0.ota_slow_gmid_ctrl_buff_0.x.n0 ota_lv_gmid_comparator_0.ota_slow_gmid_ctrl_buff_0.x.t4 6.07327
R4253 ota_lv_gmid_comparator_0.ota_slow_gmid_ctrl_buff_0.x.n2 ota_lv_gmid_comparator_0.ota_slow_gmid_ctrl_buff_0.x.t2 4.10783
R4254 ota_lv_gmid_comparator_0.ota_slow_gmid_ctrl_buff_0.x.n2 ota_lv_gmid_comparator_0.ota_slow_gmid_ctrl_buff_0.x.t1 3.4078
R4255 ota_lv_gmid_comparator_0.ota_slow_gmid_ctrl_buff_0.x.n3 ota_lv_gmid_comparator_0.ota_slow_gmid_ctrl_buff_0.x.t0 3.40592
R4256 ota_lv_gmid_comparator_0.ota_slow_gmid_ctrl_buff_0.x ota_lv_gmid_comparator_0.ota_slow_gmid_ctrl_buff_0.x.n7 0.954845
R4257 ota_lv_gmid_comparator_0.ota_slow_gmid_ctrl_buff_0.x.n1 ota_lv_gmid_comparator_0.ota_slow_gmid_ctrl_buff_0.x.n0 0.70175
R4258 ota_lv_gmid_comparator_0.ota_slow_gmid_ctrl_buff_0.x.n3 ota_lv_gmid_comparator_0.ota_slow_gmid_ctrl_buff_0.x.n2 0.70175
R4259 ota_lv_gmid_comparator_0.ota_slow_gmid_ctrl_buff_0.x.n4 ota_lv_gmid_comparator_0.ota_slow_gmid_ctrl_buff_0.x.n1 0.138
R4260 ota_lv_gmid_comparator_0.ota_slow_gmid_ctrl_buff_0.x.n4 ota_lv_gmid_comparator_0.ota_slow_gmid_ctrl_buff_0.x.n3 0.120812
R4261 ota_lv_gmid_comparator_0.ota_slow_gmid_ctrl_buff_0.x ota_lv_gmid_comparator_0.ota_slow_gmid_ctrl_buff_0.x.n5 0.0611897
R4262 ota_lv_gmid_comparator_0.ota_slow_gmid_ctrl_buff_0.x.n6 ota_lv_gmid_comparator_0.ota_slow_gmid_ctrl_buff_0.x 0.0445
R4263 a_n786_n1161.n4 a_n786_n1161.n3 18.7002
R4264 a_n786_n1161.n7 a_n786_n1161.t1 17.2274
R4265 a_n786_n1161.n1 a_n786_n1161.t0 17.2274
R4266 a_n786_n1161.n0 a_n786_n1161.t6 17.2274
R4267 a_n786_n1161.n6 a_n786_n1161.t4 17.2274
R4268 a_n786_n1161.n5 a_n786_n1161.t3 17.2274
R4269 a_n786_n1161.n1 a_n786_n1161.t9 17.2239
R4270 a_n786_n1161.n0 a_n786_n1161.t8 17.2239
R4271 a_n786_n1161.n6 a_n786_n1161.t7 17.2239
R4272 a_n786_n1161.n5 a_n786_n1161.t5 17.2239
R4273 a_n786_n1161.t2 a_n786_n1161.n7 17.2239
R4274 a_n786_n1161.n2 a_n786_n1161.t10 4.10735
R4275 a_n786_n1161.n3 a_n786_n1161.t11 3.64026
R4276 a_n786_n1161.n2 a_n786_n1161.t12 3.4061
R4277 a_n786_n1161.n1 a_n786_n1161.n0 1.293
R4278 a_n786_n1161.n7 a_n786_n1161.n6 1.293
R4279 a_n786_n1161.n6 a_n786_n1161.n5 1.293
R4280 a_n786_n1161.n5 a_n786_n1161.n4 0.942702
R4281 a_n786_n1161.n3 a_n786_n1161.n2 0.413313
R4282 a_n786_n1161.n4 a_n786_n1161.n1 0.303327
R4283 ota_lv_gmid_comparator_0.ota_slow_gmid_ctrl_buff_0.ota_slow_gmid_ctrl_inv_0.x ota_lv_gmid_comparator_0.ota_slow_gmid_ctrl_buff_0.ota_slow_gmid_ctrl_inv_0.x.t2 15.2608
R4284 ota_lv_gmid_comparator_0.ota_slow_gmid_ctrl_buff_0.ota_slow_gmid_ctrl_inv_0.x.n0 ota_lv_gmid_comparator_0.ota_slow_gmid_ctrl_buff_0.ota_slow_gmid_ctrl_inv_0.x.t1 3.55057
R4285 ota_lv_gmid_comparator_0.ota_slow_gmid_ctrl_buff_0.ota_slow_gmid_ctrl_inv_0.x.n0 ota_lv_gmid_comparator_0.ota_slow_gmid_ctrl_buff_0.ota_slow_gmid_ctrl_inv_0.x.t0 3.47311
R4286 ota_lv_gmid_comparator_0.ota_slow_gmid_ctrl_buff_0.ota_slow_gmid_ctrl_inv_0.x ota_lv_gmid_comparator_0.ota_slow_gmid_ctrl_buff_0.ota_slow_gmid_ctrl_inv_0.x.n0 0.204
R4287 RAMP_REF.n3 RAMP_REF.t7 19.3758
R4288 RAMP_REF.n6 RAMP_REF.t6 17.2892
R4289 RAMP_REF.n9 RAMP_REF.t4 17.2892
R4290 RAMP_REF.n7 RAMP_REF.t1 17.0005
R4291 RAMP_REF.n10 RAMP_REF.t5 17.0005
R4292 RAMP_REF.n16 RAMP_REF.t2 17.0005
R4293 RAMP_REF.n17 RAMP_REF 6.60147
R4294 RAMP_REF.n4 RAMP_REF.n3 5.07459
R4295 RAMP_REF.n14 RAMP_REF.n13 4.1831
R4296 RAMP_REF.n17 RAMP_REF.n16 3.91781
R4297 RAMP_REF.n4 RAMP_REF.n2 2.8965
R4298 RAMP_REF.n14 RAMP_REF.n0 2.8965
R4299 RAMP_REF.n13 RAMP_REF.n12 2.89236
R4300 RAMP_REF.n8 RAMP_REF.n7 2.63923
R4301 RAMP_REF.n11 RAMP_REF.n10 2.55533
R4302 RAMP_REF.n16 RAMP_REF.n15 2.35825
R4303 RAMP_REF.n6 RAMP_REF.n5 2.07013
R4304 RAMP_REF.n9 RAMP_REF.n1 1.99987
R4305 RAMP_REF.n13 RAMP_REF.n1 1.40355
R4306 RAMP_REF.n15 RAMP_REF.n14 1.39417
R4307 RAMP_REF.n5 RAMP_REF.n4 1.39372
R4308 RAMP_REF.n7 RAMP_REF.n6 0.28925
R4309 RAMP_REF.n10 RAMP_REF.n9 0.28925
R4310 RAMP_REF.n5 RAMP_REF.t0 0.289018
R4311 RAMP_REF.n15 RAMP_REF.t0 0.288706
R4312 RAMP_REF.t3 RAMP_REF.n1 0.288556
R4313 RAMP_REF.t3 RAMP_REF.n3 0.183493
R4314 RAMP_REF RAMP_REF.n17 0.0360745
R4315 RAMP_REF.n11 RAMP_REF.n8 0.0230019
R4316 RAMP_REF.t3 RAMP_REF.n11 0.00448546
R4317 RAMP_REF.n12 RAMP_REF.n0 0.00353423
R4318 RAMP_REF.n12 RAMP_REF.t3 0.00196564
R4319 RAMP_REF.t3 RAMP_REF.n2 0.001
R4320 RAMP_REF.n2 RAMP_REF.t0 0.001
R4321 RAMP_REF.n8 RAMP_REF.t0 0.001
R4322 RAMP_REF.n0 RAMP_REF.t0 0.001
R4323 ota_lv_gmid_comparator_0.ota_slow_gmid_mirror_0.vota.n2 ota_lv_gmid_comparator_0.ota_slow_gmid_mirror_0.vota.t3 34.4823
R4324 ota_lv_gmid_comparator_0.ota_slow_gmid_mirror_0.vota.n1 ota_lv_gmid_comparator_0.ota_slow_gmid_mirror_0.vota.t2 17.0005
R4325 ota_lv_gmid_comparator_0.ota_slow_gmid_mirror_0.vota.n0 ota_lv_gmid_comparator_0.ota_slow_gmid_mirror_0.vota.t0 11.1062
R4326 ota_lv_gmid_comparator_0.ota_slow_gmid_mirror_0.vota ota_lv_gmid_comparator_0.ota_slow_gmid_mirror_0.vota.n3 5.4993
R4327 ota_lv_gmid_comparator_0.ota_slow_gmid_mirror_0.vota.n0 ota_lv_gmid_comparator_0.ota_slow_gmid_mirror_0.vota.t1 4.52664
R4328 ota_lv_gmid_comparator_0.ota_slow_gmid_mirror_0.vota.n1 ota_lv_gmid_comparator_0.ota_slow_gmid_mirror_0.vota.t4 4.28336
R4329 ota_lv_gmid_comparator_0.ota_slow_gmid_mirror_0.vota.n2 ota_lv_gmid_comparator_0.ota_slow_gmid_mirror_0.vota.t5 4.15409
R4330 ota_lv_gmid_comparator_0.ota_slow_gmid_mirror_0.vota ota_lv_gmid_comparator_0.ota_slow_gmid_mirror_0.vota.n0 2.95082
R4331 ota_lv_gmid_comparator_0.ota_slow_gmid_mirror_0.vota.n3 ota_lv_gmid_comparator_0.ota_slow_gmid_mirror_0.vota.n2 0.677202
R4332 ota_lv_gmid_comparator_0.ota_slow_gmid_mirror_0.vota.n3 ota_lv_gmid_comparator_0.ota_slow_gmid_mirror_0.vota.n1 0.0169567
R4333 a_n586_691.n3 a_n586_691.t0 19.1936
R4334 a_n586_691.n2 a_n586_691.n1 18.7515
R4335 a_n586_691.n2 a_n586_691.t2 18.2143
R4336 a_n586_691.t1 a_n586_691.n3 17.2961
R4337 a_n586_691.n0 a_n586_691.t4 6.77495
R4338 a_n586_691.n1 a_n586_691.t5 6.07724
R4339 a_n586_691.n0 a_n586_691.t3 6.0737
R4340 a_n586_691.n3 a_n586_691.n2 0.9255
R4341 a_n586_691.n1 a_n586_691.n0 0.653317
R4342 CMP_OUTPUT.n0 CMP_OUTPUT.t1 3.55057
R4343 CMP_OUTPUT.n0 CMP_OUTPUT.t0 3.47123
R4344 CMP_OUTPUT CMP_OUTPUT.n0 0.117833
R4345 CMP_OUTPUT.n1 CMP_OUTPUT 0.0646667
R4346 CMP_OUTPUT CMP_OUTPUT.n1 0.0315484
R4347 CMP_OUTPUT.n1 CMP_OUTPUT 0.0111452
R4348 ota_lv_gmid_comparator_0.ota_slow_gmid_common_0/ota_slow_gmid_tail_0.ibiasn.n0 ota_lv_gmid_comparator_0.ota_slow_gmid_common_0/ota_slow_gmid_tail_0.ibiasn.t1 10.2759
R4349 ota_lv_gmid_comparator_0.ota_slow_gmid_common_0/ota_slow_gmid_tail_0.ibiasn ota_lv_gmid_comparator_0.ota_slow_gmid_common_0/ota_slow_gmid_tail_0.ibiasn.n0 5.8926
R4350 ota_lv_gmid_comparator_0.ota_slow_gmid_common_0/ota_slow_gmid_tail_0.ibiasn.n0 ota_lv_gmid_comparator_0.ota_slow_gmid_common_0/ota_slow_gmid_tail_0.ibiasn.t0 5.69411
R4351 a_2150_2812.t0 a_2150_2812.t1 30.5928
C143 SEL_MEAS VSS 4.59184f
C144 VCAL VSS 7.80456f
C145 VMEAS VSS 0.73673f
C146 SEL_CAL VSS 6.71182f
C147 CMP_OUTPUT VSS 0.64562f
C148 RAMP_REF VSS 15.51012f
C149 RAMP_RESET VSS 9.44726f
C150 VRAMP VSS 0.19824p
C151 RAMP_EN VSS 0.27968f
C152 VBIAS VSS 11.08033f
C153 VDD VSS 8.14563f
C154 a_n14157_n862# VSS 0.07783f $ **FLOATING
C155 ota_lv_gmid_comparator_0.ota_slow_gmid_ctrl_buff_0.ota_slow_gmid_ctrl_inv_0.x VSS 1.16116f $ **FLOATING
C156 ota_lv_gmid_comparator_0.ota_slow_gmid_ctrl_buff_1.ota_slow_gmid_ctrl_inv_0.x VSS 1.15142f $ **FLOATING
C157 a_n7237_n850# VSS 0.01683f $ **FLOATING
C158 a_n16305_n850# VSS 0.01836f $ **FLOATING
C159 ota_lv_gmid_comparator_0.ota_slow_gmid_ctrl_buff_0.x VSS 4.36395f $ **FLOATING
C160 ota_lv_gmid_comparator_0.ota_slow_gmid_ctrl_buff_1.y VSS 4.96662f $ **FLOATING
C161 ota_lv_gmid_comparator_0.ota_slow_gmid_mirror_0.vref VSS 7.08129f $ **FLOATING
C162 ota_lv_gmid_comparator_0.ota_slow_gmid_mirror_0.vota VSS 15.69252f $ **FLOATING
C163 a_n7165_579# VSS 0.06265f $ **FLOATING
C164 a_n17365_579# VSS 0.06265f $ **FLOATING
C165 a_n7165_763# VSS 0.01645f $ **FLOATING
C166 a_n17365_763# VSS 0.01645f $ **FLOATING
C167 a_n7165_947# VSS 0.01645f $ **FLOATING
C168 a_n17365_947# VSS 0.01645f $ **FLOATING
C169 a_n7165_1131# VSS 0.01645f $ **FLOATING
C170 a_n17365_1131# VSS 0.01645f $ **FLOATING
C171 a_n7165_1315# VSS 0.01645f $ **FLOATING
C172 a_n17365_1315# VSS 0.01645f $ **FLOATING
C173 a_n7165_1499# VSS 0.01645f $ **FLOATING
C174 a_n17365_1499# VSS 0.01645f $ **FLOATING
C175 a_n7165_1683# VSS 0.01645f $ **FLOATING
C176 a_n17365_1683# VSS 0.01645f $ **FLOATING
C177 a_n7165_1867# VSS 0.07307f $ **FLOATING
C178 a_n17365_1867# VSS 0.07307f $ **FLOATING
C179 ramp_generator_0.ramp_generator_input_select_0.v_cmp VSS 12.87826f $ **FLOATING
C180 ramp_generator_0.ramp_generator_nmos_mirror_0.pmos_ref VSS 7.36003f $ **FLOATING
C181 a_1650_2812# VSS 0.19218f
C182 a_n2151_2812# VSS 0.1922f
C183 a_1650_3092# VSS 0.23143f
C184 a_n2151_3092# VSS 0.23148f
C185 a_1595_3318# VSS 0.4272f $ **FLOATING
C186 a_1251_3470# VSS 0.28373f
C187 a_971_3470# VSS 0.2829f
C188 ota_lv_gmid_comparator_0.ota_slow_gmid_common_0/ota_slow_gmid_pairs_0.tail VSS 0.30818f $ **FLOATING
C189 ota_lv_gmid_comparator_0.ota_slow_gmid_common_0/ota_slow_gmid_tail_0.ibiasn VSS 0.11097f $ **FLOATING
C190 ota_lv_gmid_comparator_0.ota_slow_gmid_mirror_0.vout1 VSS 9.4921f $ **FLOATING
C191 a_n1072_3470# VSS 0.2886f
C192 a_n1352_3470# VSS 0.28373f
C193 a_n2196_3318# VSS 0.42884f $ **FLOATING
C194 ota_lv_gmid_comparator_0.ota_slow_gmid_mirror_0.vota.t1 VSS 0.29967f $ **FLOATING
C195 ota_lv_gmid_comparator_0.ota_slow_gmid_mirror_0.vota.t0 VSS 0.41627f $ **FLOATING
C196 ota_lv_gmid_comparator_0.ota_slow_gmid_mirror_0.vota.n0 VSS 0.51021f $ **FLOATING
C197 ota_lv_gmid_comparator_0.ota_slow_gmid_mirror_0.vota.t4 VSS 3.88659f $ **FLOATING
C198 ota_lv_gmid_comparator_0.ota_slow_gmid_mirror_0.vota.t2 VSS 0.03793f $ **FLOATING
C199 ota_lv_gmid_comparator_0.ota_slow_gmid_mirror_0.vota.n1 VSS 0.195f $ **FLOATING
C200 ota_lv_gmid_comparator_0.ota_slow_gmid_mirror_0.vota.t5 VSS 3.88501f $ **FLOATING
C201 ota_lv_gmid_comparator_0.ota_slow_gmid_mirror_0.vota.t3 VSS 0.33873f $ **FLOATING
C202 ota_lv_gmid_comparator_0.ota_slow_gmid_mirror_0.vota.n2 VSS 1.04386f $ **FLOATING
C203 ota_lv_gmid_comparator_0.ota_slow_gmid_mirror_0.vota.n3 VSS 0.06081f $ **FLOATING
C204 RAMP_REF.t0 VSS 1.57379f $ **FLOATING
C205 RAMP_REF.n0 VSS 0.08288f $ **FLOATING
C206 RAMP_REF.n1 VSS 0.03367f $ **FLOATING
C207 RAMP_REF.n3 VSS 0.13694f $ **FLOATING
C208 RAMP_REF.n4 VSS 0.1157f $ **FLOATING
C209 RAMP_REF.n5 VSS 0.03419f $ **FLOATING
C210 RAMP_REF.n6 VSS 0.02715f $ **FLOATING
C211 RAMP_REF.n7 VSS 0.02927f $ **FLOATING
C212 RAMP_REF.n8 VSS 0.17162f $ **FLOATING
C213 RAMP_REF.n9 VSS 0.02687f $ **FLOATING
C214 RAMP_REF.n10 VSS 0.02896f $ **FLOATING
C215 RAMP_REF.n11 VSS 0.04475f $ **FLOATING
C216 RAMP_REF.t3 VSS 1.67494f $ **FLOATING
C217 RAMP_REF.n12 VSS 0.01776f $ **FLOATING
C218 RAMP_REF.n13 VSS 0.09847f $ **FLOATING
C219 RAMP_REF.n14 VSS 0.0984f $ **FLOATING
C220 RAMP_REF.n15 VSS 0.03689f $ **FLOATING
C221 RAMP_REF.n16 VSS 0.06815f $ **FLOATING
C222 RAMP_REF.n17 VSS 0.5167f $ **FLOATING
C223 ota_lv_gmid_comparator_0.ota_slow_gmid_ctrl_buff_0.x.t8 VSS 0.6053f $ **FLOATING
C224 ota_lv_gmid_comparator_0.ota_slow_gmid_ctrl_buff_0.x.t5 VSS 0.0618f $ **FLOATING
C225 ota_lv_gmid_comparator_0.ota_slow_gmid_ctrl_buff_0.x.t4 VSS 0.06885f $ **FLOATING
C226 ota_lv_gmid_comparator_0.ota_slow_gmid_ctrl_buff_0.x.t3 VSS 0.07337f $ **FLOATING
C227 ota_lv_gmid_comparator_0.ota_slow_gmid_ctrl_buff_0.x.n0 VSS 0.09246f $ **FLOATING
C228 ota_lv_gmid_comparator_0.ota_slow_gmid_ctrl_buff_0.x.n1 VSS 0.0459f $ **FLOATING
C229 ota_lv_gmid_comparator_0.ota_slow_gmid_ctrl_buff_0.x.t0 VSS 0.10344f $ **FLOATING
C230 ota_lv_gmid_comparator_0.ota_slow_gmid_ctrl_buff_0.x.t2 VSS 0.12408f $ **FLOATING
C231 ota_lv_gmid_comparator_0.ota_slow_gmid_ctrl_buff_0.x.t1 VSS 0.11472f $ **FLOATING
C232 ota_lv_gmid_comparator_0.ota_slow_gmid_ctrl_buff_0.x.n2 VSS 0.11004f $ **FLOATING
C233 ota_lv_gmid_comparator_0.ota_slow_gmid_ctrl_buff_0.x.n3 VSS 0.05683f $ **FLOATING
C234 ota_lv_gmid_comparator_0.ota_slow_gmid_ctrl_buff_0.x.n4 VSS 0.21461f $ **FLOATING
C235 ota_lv_gmid_comparator_0.ota_slow_gmid_ctrl_buff_0.x.n5 VSS 0.18088f $ **FLOATING
C236 ota_lv_gmid_comparator_0.ota_slow_gmid_ctrl_buff_0.x.t6 VSS 0.60374f $ **FLOATING
C237 ota_lv_gmid_comparator_0.ota_slow_gmid_ctrl_buff_0.x.t7 VSS 0.11643f $ **FLOATING
C238 ota_lv_gmid_comparator_0.ota_slow_gmid_ctrl_buff_0.x.n6 VSS 0.0357f $ **FLOATING
C239 ota_lv_gmid_comparator_0.ota_slow_gmid_ctrl_buff_0.x.n7 VSS 0.22171f $ **FLOATING
C240 ota_lv_gmid_comparator_0.ota_slow_gmid_mirror_0.vout1.t8 VSS 0.14355f $ **FLOATING
C241 ota_lv_gmid_comparator_0.ota_slow_gmid_mirror_0.vout1.t9 VSS 0.11225f $ **FLOATING
C242 ota_lv_gmid_comparator_0.ota_slow_gmid_mirror_0.vout1.n0 VSS 0.2173f $ **FLOATING
C243 ota_lv_gmid_comparator_0.ota_slow_gmid_mirror_0.vout1.t15 VSS 0.15959f $ **FLOATING
C244 ota_lv_gmid_comparator_0.ota_slow_gmid_mirror_0.vout1.t14 VSS 1.20128f $ **FLOATING
C245 ota_lv_gmid_comparator_0.ota_slow_gmid_mirror_0.vout1.n1 VSS 0.6043f $ **FLOATING
C246 ota_lv_gmid_comparator_0.ota_slow_gmid_mirror_0.vout1.t16 VSS 0.09913f $ **FLOATING
C247 ota_lv_gmid_comparator_0.ota_slow_gmid_mirror_0.vout1.n2 VSS 0.39788f $ **FLOATING
C248 ota_lv_gmid_comparator_0.ota_slow_gmid_mirror_0.vout1.t11 VSS 0.0561f $ **FLOATING
C249 ota_lv_gmid_comparator_0.ota_slow_gmid_mirror_0.vout1.t10 VSS 0.05665f $ **FLOATING
C250 ota_lv_gmid_comparator_0.ota_slow_gmid_mirror_0.vout1.t13 VSS 0.32077f $ **FLOATING
C251 ota_lv_gmid_comparator_0.ota_slow_gmid_mirror_0.vout1.t12 VSS 0.05665f $ **FLOATING
C252 ota_lv_gmid_comparator_0.ota_slow_gmid_mirror_0.vout1.n3 VSS 1.10407f $ **FLOATING
C253 ota_lv_gmid_comparator_0.ota_slow_gmid_mirror_0.vout1.n4 VSS 0.79214f $ **FLOATING
C254 ota_lv_gmid_comparator_0.ota_slow_gmid_mirror_0.vout1.n5 VSS 0.56954f $ **FLOATING
C255 ota_lv_gmid_comparator_0.ota_slow_gmid_mirror_0.vout1.n6 VSS 2.22669f $ **FLOATING
C256 ota_lv_gmid_comparator_0.ota_slow_gmid_mirror_0.vout1.n7 VSS 1.70659f $ **FLOATING
C257 ota_lv_gmid_comparator_0.ota_slow_gmid_mirror_0.vout1.n8 VSS 0.03974f $ **FLOATING
C258 ota_lv_gmid_comparator_0.ota_slow_gmid_mirror_0.vout1.t6 VSS 0.2079f $ **FLOATING
C259 ota_lv_gmid_comparator_0.ota_slow_gmid_mirror_0.vout1.t2 VSS 0.20093f $ **FLOATING
C260 ota_lv_gmid_comparator_0.ota_slow_gmid_mirror_0.vout1.t3 VSS 0.21974f $ **FLOATING
C261 ota_lv_gmid_comparator_0.ota_slow_gmid_mirror_0.vout1.t4 VSS 0.22671f $ **FLOATING
C262 ota_lv_gmid_comparator_0.ota_slow_gmid_mirror_0.vout1.t0 VSS 0.21974f $ **FLOATING
C263 ota_lv_gmid_comparator_0.ota_slow_gmid_mirror_0.vout1.t5 VSS 0.22671f $ **FLOATING
C264 ota_lv_gmid_comparator_0.ota_slow_gmid_mirror_0.vout1.t1 VSS 0.21974f $ **FLOATING
C265 ota_lv_gmid_comparator_0.ota_slow_gmid_mirror_0.vout1.n9 VSS 0.27213f $ **FLOATING
C266 ota_lv_gmid_comparator_0.ota_slow_gmid_mirror_0.vout1.n10 VSS 0.30393f $ **FLOATING
C267 ota_lv_gmid_comparator_0.ota_slow_gmid_mirror_0.vout1.t7 VSS 0.22671f $ **FLOATING
C268 ota_lv_gmid_comparator_0.ota_slow_gmid_mirror_0.vout1.n11 VSS 0.30393f $ **FLOATING
C269 ota_lv_gmid_comparator_0.ota_slow_gmid_mirror_0.vout1.n12 VSS 0.30897f $ **FLOATING
C270 ota_lv_gmid_comparator_0.ota_slow_gmid_mirror_0.vref.t0 VSS 0.28711f $ **FLOATING
C271 ota_lv_gmid_comparator_0.ota_slow_gmid_mirror_0.vref.t3 VSS 0.04275f $ **FLOATING
C272 ota_lv_gmid_comparator_0.ota_slow_gmid_mirror_0.vref.t2 VSS 6.91168f $ **FLOATING
C273 ota_lv_gmid_comparator_0.ota_slow_gmid_mirror_0.vref.t4 VSS 0.08315f $ **FLOATING
C274 ota_lv_gmid_comparator_0.ota_slow_gmid_mirror_0.vref.n0 VSS 1.75279f $ **FLOATING
C275 ota_lv_gmid_comparator_0.ota_slow_gmid_mirror_0.vref.n1 VSS 0.31896f $ **FLOATING
C276 ota_lv_gmid_comparator_0.ota_slow_gmid_mirror_0.vref.t1 VSS 0.51369f $ **FLOATING
C277 ota_lv_gmid_comparator_0.ota_slow_gmid_mirror_0.vref.n2 VSS 1.04645f $ **FLOATING
C278 ota_lv_gmid_comparator_0.ota_slow_gmid_mirror_0.vref.n3 VSS 0.44097f $ **FLOATING
C279 ramp_generator_0.ramp_generator_nmos_mirror_0.pmos_ref.t21 VSS 0.01912f $ **FLOATING
C280 ramp_generator_0.ramp_generator_nmos_mirror_0.pmos_ref.t20 VSS 0.11842f $ **FLOATING
C281 ramp_generator_0.ramp_generator_nmos_mirror_0.pmos_ref.n0 VSS 0.55688f $ **FLOATING
C282 ramp_generator_0.ramp_generator_nmos_mirror_0.pmos_ref.t38 VSS 0.01582f $ **FLOATING
C283 ramp_generator_0.ramp_generator_nmos_mirror_0.pmos_ref.t39 VSS 0.01582f $ **FLOATING
C284 ramp_generator_0.ramp_generator_nmos_mirror_0.pmos_ref.n1 VSS 0.05684f $ **FLOATING
C285 ramp_generator_0.ramp_generator_nmos_mirror_0.pmos_ref.t22 VSS 43.9889f $ **FLOATING
C286 ramp_generator_0.ramp_generator_nmos_mirror_0.pmos_ref.t23 VSS 0.01582f $ **FLOATING
C287 ramp_generator_0.ramp_generator_nmos_mirror_0.pmos_ref.n2 VSS 0.61213f $ **FLOATING
C288 ramp_generator_0.ramp_generator_nmos_mirror_0.pmos_ref.n3 VSS 0.67019f $ **FLOATING
C289 ramp_generator_0.ramp_generator_nmos_mirror_0.pmos_ref.t27 VSS 0.01582f $ **FLOATING
C290 ramp_generator_0.ramp_generator_nmos_mirror_0.pmos_ref.t48 VSS 0.01582f $ **FLOATING
C291 ramp_generator_0.ramp_generator_nmos_mirror_0.pmos_ref.n4 VSS 0.05141f $ **FLOATING
C292 ramp_generator_0.ramp_generator_nmos_mirror_0.pmos_ref.n5 VSS 0.20525f $ **FLOATING
C293 ramp_generator_0.ramp_generator_nmos_mirror_0.pmos_ref.t46 VSS 0.01582f $ **FLOATING
C294 ramp_generator_0.ramp_generator_nmos_mirror_0.pmos_ref.t40 VSS 0.01582f $ **FLOATING
C295 ramp_generator_0.ramp_generator_nmos_mirror_0.pmos_ref.n6 VSS 0.06625f $ **FLOATING
C296 ramp_generator_0.ramp_generator_nmos_mirror_0.pmos_ref.n7 VSS 0.20513f $ **FLOATING
C297 ramp_generator_0.ramp_generator_nmos_mirror_0.pmos_ref.t28 VSS 0.01582f $ **FLOATING
C298 ramp_generator_0.ramp_generator_nmos_mirror_0.pmos_ref.t49 VSS 0.01582f $ **FLOATING
C299 ramp_generator_0.ramp_generator_nmos_mirror_0.pmos_ref.n8 VSS 0.05533f $ **FLOATING
C300 ramp_generator_0.ramp_generator_nmos_mirror_0.pmos_ref.n9 VSS 0.1552f $ **FLOATING
C301 ramp_generator_0.ramp_generator_nmos_mirror_0.pmos_ref.t32 VSS 0.01582f $ **FLOATING
C302 ramp_generator_0.ramp_generator_nmos_mirror_0.pmos_ref.t45 VSS 0.01582f $ **FLOATING
C303 ramp_generator_0.ramp_generator_nmos_mirror_0.pmos_ref.n11 VSS 0.20533f $ **FLOATING
C304 ramp_generator_0.ramp_generator_nmos_mirror_0.pmos_ref.t47 VSS 0.01582f $ **FLOATING
C305 ramp_generator_0.ramp_generator_nmos_mirror_0.pmos_ref.n12 VSS 0.05382f $ **FLOATING
C306 ramp_generator_0.ramp_generator_nmos_mirror_0.pmos_ref.n13 VSS 0.15201f $ **FLOATING
C307 ramp_generator_0.ramp_generator_nmos_mirror_0.pmos_ref.t37 VSS 0.01582f $ **FLOATING
C308 ramp_generator_0.ramp_generator_nmos_mirror_0.pmos_ref.t35 VSS 0.01582f $ **FLOATING
C309 ramp_generator_0.ramp_generator_nmos_mirror_0.pmos_ref.t31 VSS 0.01582f $ **FLOATING
C310 ramp_generator_0.ramp_generator_nmos_mirror_0.pmos_ref.n15 VSS 0.05141f $ **FLOATING
C311 ramp_generator_0.ramp_generator_nmos_mirror_0.pmos_ref.n16 VSS 0.20494f $ **FLOATING
C312 ramp_generator_0.ramp_generator_nmos_mirror_0.pmos_ref.t24 VSS 0.01582f $ **FLOATING
C313 ramp_generator_0.ramp_generator_nmos_mirror_0.pmos_ref.t51 VSS 0.01582f $ **FLOATING
C314 ramp_generator_0.ramp_generator_nmos_mirror_0.pmos_ref.n17 VSS 0.03801f $ **FLOATING
C315 ramp_generator_0.ramp_generator_nmos_mirror_0.pmos_ref.t19 VSS 0.0616f $ **FLOATING
C316 ramp_generator_0.ramp_generator_nmos_mirror_0.pmos_ref.t7 VSS 0.0616f $ **FLOATING
C317 ramp_generator_0.ramp_generator_nmos_mirror_0.pmos_ref.t6 VSS 0.0616f $ **FLOATING
C318 ramp_generator_0.ramp_generator_nmos_mirror_0.pmos_ref.t14 VSS 0.0616f $ **FLOATING
C319 ramp_generator_0.ramp_generator_nmos_mirror_0.pmos_ref.t10 VSS 0.0616f $ **FLOATING
C320 ramp_generator_0.ramp_generator_nmos_mirror_0.pmos_ref.t16 VSS 0.0616f $ **FLOATING
C321 ramp_generator_0.ramp_generator_nmos_mirror_0.pmos_ref.t8 VSS 0.0616f $ **FLOATING
C322 ramp_generator_0.ramp_generator_nmos_mirror_0.pmos_ref.t0 VSS 0.0616f $ **FLOATING
C323 ramp_generator_0.ramp_generator_nmos_mirror_0.pmos_ref.t11 VSS 0.06497f $ **FLOATING
C324 ramp_generator_0.ramp_generator_nmos_mirror_0.pmos_ref.n18 VSS 0.13129f $ **FLOATING
C325 ramp_generator_0.ramp_generator_nmos_mirror_0.pmos_ref.n19 VSS 0.07732f $ **FLOATING
C326 ramp_generator_0.ramp_generator_nmos_mirror_0.pmos_ref.n20 VSS 0.07732f $ **FLOATING
C327 ramp_generator_0.ramp_generator_nmos_mirror_0.pmos_ref.t9 VSS 0.0616f $ **FLOATING
C328 ramp_generator_0.ramp_generator_nmos_mirror_0.pmos_ref.n21 VSS 0.07732f $ **FLOATING
C329 ramp_generator_0.ramp_generator_nmos_mirror_0.pmos_ref.n22 VSS 0.07732f $ **FLOATING
C330 ramp_generator_0.ramp_generator_nmos_mirror_0.pmos_ref.n23 VSS 0.07732f $ **FLOATING
C331 ramp_generator_0.ramp_generator_nmos_mirror_0.pmos_ref.n24 VSS 0.07732f $ **FLOATING
C332 ramp_generator_0.ramp_generator_nmos_mirror_0.pmos_ref.n25 VSS 0.07732f $ **FLOATING
C333 ramp_generator_0.ramp_generator_nmos_mirror_0.pmos_ref.n26 VSS 0.06548f $ **FLOATING
C334 ramp_generator_0.ramp_generator_nmos_mirror_0.pmos_ref.t15 VSS 0.0616f $ **FLOATING
C335 ramp_generator_0.ramp_generator_nmos_mirror_0.pmos_ref.t3 VSS 0.0616f $ **FLOATING
C336 ramp_generator_0.ramp_generator_nmos_mirror_0.pmos_ref.t18 VSS 0.0616f $ **FLOATING
C337 ramp_generator_0.ramp_generator_nmos_mirror_0.pmos_ref.t4 VSS 0.0616f $ **FLOATING
C338 ramp_generator_0.ramp_generator_nmos_mirror_0.pmos_ref.t13 VSS 0.0616f $ **FLOATING
C339 ramp_generator_0.ramp_generator_nmos_mirror_0.pmos_ref.t5 VSS 0.0616f $ **FLOATING
C340 ramp_generator_0.ramp_generator_nmos_mirror_0.pmos_ref.t1 VSS 0.0616f $ **FLOATING
C341 ramp_generator_0.ramp_generator_nmos_mirror_0.pmos_ref.t12 VSS 0.0616f $ **FLOATING
C342 ramp_generator_0.ramp_generator_nmos_mirror_0.pmos_ref.t17 VSS 0.0616f $ **FLOATING
C343 ramp_generator_0.ramp_generator_nmos_mirror_0.pmos_ref.t2 VSS 0.06497f $ **FLOATING
C344 ramp_generator_0.ramp_generator_nmos_mirror_0.pmos_ref.n27 VSS 0.13129f $ **FLOATING
C345 ramp_generator_0.ramp_generator_nmos_mirror_0.pmos_ref.n28 VSS 0.07732f $ **FLOATING
C346 ramp_generator_0.ramp_generator_nmos_mirror_0.pmos_ref.n29 VSS 0.07732f $ **FLOATING
C347 ramp_generator_0.ramp_generator_nmos_mirror_0.pmos_ref.n30 VSS 0.07732f $ **FLOATING
C348 ramp_generator_0.ramp_generator_nmos_mirror_0.pmos_ref.n31 VSS 0.07732f $ **FLOATING
C349 ramp_generator_0.ramp_generator_nmos_mirror_0.pmos_ref.n32 VSS 0.07732f $ **FLOATING
C350 ramp_generator_0.ramp_generator_nmos_mirror_0.pmos_ref.n33 VSS 0.07732f $ **FLOATING
C351 ramp_generator_0.ramp_generator_nmos_mirror_0.pmos_ref.n34 VSS 0.07732f $ **FLOATING
C352 ramp_generator_0.ramp_generator_nmos_mirror_0.pmos_ref.n35 VSS 0.06548f $ **FLOATING
C353 ramp_generator_0.ramp_generator_nmos_mirror_0.pmos_ref.n36 VSS 0.70937f $ **FLOATING
C354 ramp_generator_0.ramp_generator_nmos_mirror_0.pmos_ref.n37 VSS 0.58395f $ **FLOATING
C355 ramp_generator_0.ramp_generator_nmos_mirror_0.pmos_ref.n38 VSS 0.20061f $ **FLOATING
C356 ramp_generator_0.ramp_generator_nmos_mirror_0.pmos_ref.t36 VSS 0.01582f $ **FLOATING
C357 ramp_generator_0.ramp_generator_nmos_mirror_0.pmos_ref.t33 VSS 0.01582f $ **FLOATING
C358 ramp_generator_0.ramp_generator_nmos_mirror_0.pmos_ref.n39 VSS 0.0677f $ **FLOATING
C359 ramp_generator_0.ramp_generator_nmos_mirror_0.pmos_ref.n40 VSS 0.20494f $ **FLOATING
C360 ramp_generator_0.ramp_generator_nmos_mirror_0.pmos_ref.t44 VSS 0.01582f $ **FLOATING
C361 ramp_generator_0.ramp_generator_nmos_mirror_0.pmos_ref.t42 VSS 0.01582f $ **FLOATING
C362 ramp_generator_0.ramp_generator_nmos_mirror_0.pmos_ref.n41 VSS 0.05416f $ **FLOATING
C363 ramp_generator_0.ramp_generator_nmos_mirror_0.pmos_ref.n42 VSS 0.15445f $ **FLOATING
C364 ramp_generator_0.ramp_generator_nmos_mirror_0.pmos_ref.n43 VSS 0.64534f $ **FLOATING
C365 ramp_generator_0.ramp_generator_nmos_mirror_0.pmos_ref.n44 VSS 0.1522f $ **FLOATING
C366 ramp_generator_0.ramp_generator_nmos_mirror_0.pmos_ref.t29 VSS 0.01582f $ **FLOATING
C367 ramp_generator_0.ramp_generator_nmos_mirror_0.pmos_ref.t50 VSS 0.01582f $ **FLOATING
C368 ramp_generator_0.ramp_generator_nmos_mirror_0.pmos_ref.n45 VSS 0.05279f $ **FLOATING
C369 ramp_generator_0.ramp_generator_nmos_mirror_0.pmos_ref.n46 VSS 0.2052f $ **FLOATING
C370 ramp_generator_0.ramp_generator_nmos_mirror_0.pmos_ref.t52 VSS 0.01582f $ **FLOATING
C371 ramp_generator_0.ramp_generator_nmos_mirror_0.pmos_ref.t25 VSS 0.01582f $ **FLOATING
C372 ramp_generator_0.ramp_generator_nmos_mirror_0.pmos_ref.n47 VSS 0.06734f $ **FLOATING
C373 ramp_generator_0.ramp_generator_nmos_mirror_0.pmos_ref.n48 VSS 0.20542f $ **FLOATING
C374 ramp_generator_0.ramp_generator_nmos_mirror_0.pmos_ref.t41 VSS 0.01582f $ **FLOATING
C375 ramp_generator_0.ramp_generator_nmos_mirror_0.pmos_ref.t43 VSS 0.01582f $ **FLOATING
C376 ramp_generator_0.ramp_generator_nmos_mirror_0.pmos_ref.n49 VSS 0.06698f $ **FLOATING
C377 ramp_generator_0.ramp_generator_nmos_mirror_0.pmos_ref.n50 VSS 0.20502f $ **FLOATING
C378 ramp_generator_0.ramp_generator_nmos_mirror_0.pmos_ref.t30 VSS 0.01582f $ **FLOATING
C379 ramp_generator_0.ramp_generator_nmos_mirror_0.pmos_ref.t34 VSS 0.01582f $ **FLOATING
C380 ramp_generator_0.ramp_generator_nmos_mirror_0.pmos_ref.n51 VSS 0.54683f $ **FLOATING
C381 ramp_generator_0.ramp_generator_nmos_mirror_0.pmos_ref.t26 VSS 0.01582f $ **FLOATING
C382 ramp_generator_0.ramp_generator_nmos_mirror_0.pmos_ref.n52 VSS 0.54647f $ **FLOATING
C383 ramp_generator_0.ramp_generator_nmos_mirror_0.pmos_ref.n53 VSS 0.18545f $ **FLOATING
C384 ramp_generator_0.ramp_generator_nmos_mirror_0.pmos_ref.n54 VSS 0.10147f $ **FLOATING
C385 ramp_generator_0.ramp_generator_nmos_mirror_0.pmos_ref.n55 VSS 0.37899f $ **FLOATING
C386 RAMP_EN.t1 VSS 0.18306f $ **FLOATING
C387 RAMP_EN.n0 VSS 0.06797f $ **FLOATING
C388 RAMP_EN.t0 VSS 2.56392f $ **FLOATING
C389 RAMP_EN.n1 VSS 3.90937f $ **FLOATING
C390 RAMP_EN.n2 VSS 14.6822f $ **FLOATING
C391 ota_lv_gmid_comparator_0.ota_slow_gmid_ctrl_buff_1.y.t2 VSS 1.17819f $ **FLOATING
C392 ota_lv_gmid_comparator_0.ota_slow_gmid_ctrl_buff_1.y.t3 VSS 1.17819f $ **FLOATING
C393 ota_lv_gmid_comparator_0.ota_slow_gmid_ctrl_buff_1.y.n0 VSS 0.5985f $ **FLOATING
C394 ota_lv_gmid_comparator_0.ota_slow_gmid_ctrl_buff_1.y.n1 VSS 0.82648f $ **FLOATING
C395 ota_lv_gmid_comparator_0.ota_slow_gmid_ctrl_buff_1.y.t1 VSS 0.18946f $ **FLOATING
C396 ota_lv_gmid_comparator_0.ota_slow_gmid_ctrl_buff_1.y.t0 VSS 0.18771f $ **FLOATING
C397 ota_lv_gmid_comparator_0.ota_slow_gmid_ctrl_buff_1.y.n2 VSS 0.18459f $ **FLOATING
C398 VCAL.t1 VSS 0.16023f $ **FLOATING
C399 VCAL.t7 VSS 0.16023f $ **FLOATING
C400 VCAL.t5 VSS 0.16023f $ **FLOATING
C401 VCAL.t0 VSS 0.16023f $ **FLOATING
C402 VCAL.t6 VSS 0.16023f $ **FLOATING
C403 VCAL.t3 VSS 0.16928f $ **FLOATING
C404 VCAL.n0 VSS 0.31373f $ **FLOATING
C405 VCAL.n1 VSS 0.18482f $ **FLOATING
C406 VCAL.n2 VSS 0.18482f $ **FLOATING
C407 VCAL.n3 VSS 0.18482f $ **FLOATING
C408 VCAL.n4 VSS 0.12951f $ **FLOATING
C409 VCAL.t8 VSS 0.16023f $ **FLOATING
C410 VCAL.t2 VSS 0.16023f $ **FLOATING
C411 VCAL.t9 VSS 0.16023f $ **FLOATING
C412 VCAL.t4 VSS 0.16928f $ **FLOATING
C413 VCAL.n5 VSS 0.31373f $ **FLOATING
C414 VCAL.n6 VSS 0.18482f $ **FLOATING
C415 VCAL.n7 VSS 0.18454f $ **FLOATING
C416 VCAL.n8 VSS 0.13748f $ **FLOATING
C417 VCAL.n9 VSS 2.85606f $ **FLOATING
C418 SEL_CAL.t0 VSS 1.9227f $ **FLOATING
C419 ramp_generator_0.ramp_generator_input_select_0.v_cmp.t22 VSS 3.97353f $ **FLOATING
C420 ramp_generator_0.ramp_generator_input_select_0.v_cmp.t21 VSS 3.74185f $ **FLOATING
C421 ramp_generator_0.ramp_generator_input_select_0.v_cmp.n0 VSS 0.69465f $ **FLOATING
C422 ramp_generator_0.ramp_generator_input_select_0.v_cmp.t6 VSS 0.11183f $ **FLOATING
C423 ramp_generator_0.ramp_generator_input_select_0.v_cmp.t2 VSS 0.11183f $ **FLOATING
C424 ramp_generator_0.ramp_generator_input_select_0.v_cmp.t5 VSS 0.11183f $ **FLOATING
C425 ramp_generator_0.ramp_generator_input_select_0.v_cmp.t1 VSS 0.11183f $ **FLOATING
C426 ramp_generator_0.ramp_generator_input_select_0.v_cmp.t10 VSS 0.11183f $ **FLOATING
C427 ramp_generator_0.ramp_generator_input_select_0.v_cmp.t0 VSS 0.11183f $ **FLOATING
C428 ramp_generator_0.ramp_generator_input_select_0.v_cmp.t9 VSS 0.11183f $ **FLOATING
C429 ramp_generator_0.ramp_generator_input_select_0.v_cmp.t8 VSS 0.11183f $ **FLOATING
C430 ramp_generator_0.ramp_generator_input_select_0.v_cmp.t7 VSS 0.10667f $ **FLOATING
C431 ramp_generator_0.ramp_generator_input_select_0.v_cmp.n1 VSS 0.21896f $ **FLOATING
C432 ramp_generator_0.ramp_generator_input_select_0.v_cmp.t4 VSS 0.11183f $ **FLOATING
C433 ramp_generator_0.ramp_generator_input_select_0.v_cmp.n2 VSS 0.12899f $ **FLOATING
C434 ramp_generator_0.ramp_generator_input_select_0.v_cmp.n3 VSS 0.12899f $ **FLOATING
C435 ramp_generator_0.ramp_generator_input_select_0.v_cmp.n4 VSS 0.12899f $ **FLOATING
C436 ramp_generator_0.ramp_generator_input_select_0.v_cmp.n5 VSS 0.12899f $ **FLOATING
C437 ramp_generator_0.ramp_generator_input_select_0.v_cmp.n6 VSS 0.12899f $ **FLOATING
C438 ramp_generator_0.ramp_generator_input_select_0.v_cmp.n7 VSS 0.12899f $ **FLOATING
C439 ramp_generator_0.ramp_generator_input_select_0.v_cmp.n8 VSS 0.12899f $ **FLOATING
C440 ramp_generator_0.ramp_generator_input_select_0.v_cmp.n9 VSS 0.12785f $ **FLOATING
C441 ramp_generator_0.ramp_generator_input_select_0.v_cmp.t3 VSS 0.11183f $ **FLOATING
C442 ramp_generator_0.ramp_generator_input_select_0.v_cmp.t20 VSS 0.11183f $ **FLOATING
C443 ramp_generator_0.ramp_generator_input_select_0.v_cmp.t11 VSS 0.11183f $ **FLOATING
C444 ramp_generator_0.ramp_generator_input_select_0.v_cmp.t12 VSS 0.11183f $ **FLOATING
C445 ramp_generator_0.ramp_generator_input_select_0.v_cmp.t17 VSS 0.11183f $ **FLOATING
C446 ramp_generator_0.ramp_generator_input_select_0.v_cmp.t14 VSS 0.11183f $ **FLOATING
C447 ramp_generator_0.ramp_generator_input_select_0.v_cmp.t13 VSS 0.11183f $ **FLOATING
C448 ramp_generator_0.ramp_generator_input_select_0.v_cmp.t19 VSS 0.11183f $ **FLOATING
C449 ramp_generator_0.ramp_generator_input_select_0.v_cmp.t18 VSS 0.11183f $ **FLOATING
C450 ramp_generator_0.ramp_generator_input_select_0.v_cmp.t15 VSS 0.11183f $ **FLOATING
C451 ramp_generator_0.ramp_generator_input_select_0.v_cmp.t16 VSS 0.10667f $ **FLOATING
C452 ramp_generator_0.ramp_generator_input_select_0.v_cmp.n10 VSS 0.21896f $ **FLOATING
C453 ramp_generator_0.ramp_generator_input_select_0.v_cmp.n11 VSS 0.12899f $ **FLOATING
C454 ramp_generator_0.ramp_generator_input_select_0.v_cmp.n12 VSS 0.12899f $ **FLOATING
C455 ramp_generator_0.ramp_generator_input_select_0.v_cmp.n13 VSS 0.12899f $ **FLOATING
C456 ramp_generator_0.ramp_generator_input_select_0.v_cmp.n14 VSS 0.12899f $ **FLOATING
C457 ramp_generator_0.ramp_generator_input_select_0.v_cmp.n15 VSS 0.12899f $ **FLOATING
C458 ramp_generator_0.ramp_generator_input_select_0.v_cmp.n16 VSS 0.12899f $ **FLOATING
C459 ramp_generator_0.ramp_generator_input_select_0.v_cmp.n17 VSS 0.12899f $ **FLOATING
C460 ramp_generator_0.ramp_generator_input_select_0.v_cmp.n18 VSS 0.12899f $ **FLOATING
C461 ramp_generator_0.ramp_generator_input_select_0.v_cmp.n19 VSS 0.09135f $ **FLOATING
C462 ramp_generator_0.ramp_generator_input_select_0.v_cmp.n20 VSS 0.68415f $ **FLOATING
C463 SEL_MEAS.t6 VSS 0.15448f $ **FLOATING
C464 SEL_MEAS.t3 VSS 0.15448f $ **FLOATING
C465 SEL_MEAS.t4 VSS 0.15448f $ **FLOATING
C466 SEL_MEAS.t9 VSS 0.15448f $ **FLOATING
C467 SEL_MEAS.t2 VSS 0.16321f $ **FLOATING
C468 SEL_MEAS.n0 VSS 0.30248f $ **FLOATING
C469 SEL_MEAS.n1 VSS 0.17819f $ **FLOATING
C470 SEL_MEAS.n2 VSS 0.17819f $ **FLOATING
C471 SEL_MEAS.n3 VSS 0.17662f $ **FLOATING
C472 SEL_MEAS.t5 VSS 0.15448f $ **FLOATING
C473 SEL_MEAS.t7 VSS 0.15448f $ **FLOATING
C474 SEL_MEAS.t8 VSS 0.15448f $ **FLOATING
C475 SEL_MEAS.t1 VSS 0.15448f $ **FLOATING
C476 SEL_MEAS.t0 VSS 0.16321f $ **FLOATING
C477 SEL_MEAS.n4 VSS 0.30248f $ **FLOATING
C478 SEL_MEAS.n5 VSS 0.17819f $ **FLOATING
C479 SEL_MEAS.n6 VSS 0.17819f $ **FLOATING
C480 SEL_MEAS.n7 VSS 0.12619f $ **FLOATING
C481 SEL_MEAS.n8 VSS 0.09099f $ **FLOATING
C482 SEL_MEAS.n9 VSS 9.16536f $ **FLOATING
C483 VMEAS.t0 VSS 1.87085f $ **FLOATING
C484 VMEAS.n0 VSS 10.7893f $ **FLOATING
C485 VRAMP.n4 VSS 0.02457f $ **FLOATING
C486 VRAMP.n5 VSS 0.04235f $ **FLOATING
C487 VRAMP.n6 VSS 0.04235f $ **FLOATING
C488 VRAMP.n7 VSS 0.14326f $ **FLOATING
C489 VRAMP.n8 VSS 0.04235f $ **FLOATING
C490 VRAMP.n9 VSS 0.04235f $ **FLOATING
C491 VRAMP.n10 VSS 0.04235f $ **FLOATING
C492 VRAMP.n11 VSS 0.39042f $ **FLOATING
C493 VRAMP.n12 VSS 0.04235f $ **FLOATING
C494 VRAMP.t14 VSS 0.09445f $ **FLOATING
C495 VRAMP.n13 VSS 0.0183f $ **FLOATING
C496 VRAMP.t15 VSS 0.09564f $ **FLOATING
C497 VRAMP.n14 VSS 0.01391f $ **FLOATING
C498 VRAMP.n15 VSS 0.20921f $ **FLOATING
C499 VRAMP.n16 VSS 0.03022f $ **FLOATING
C500 VRAMP.n17 VSS 0.03183f $ **FLOATING
C501 VRAMP.n18 VSS 0.04235f $ **FLOATING
C502 VRAMP.n19 VSS 0.04235f $ **FLOATING
C503 VRAMP.n20 VSS 0.02457f $ **FLOATING
C504 VRAMP.n21 VSS 0.02457f $ **FLOATING
C505 VRAMP.n22 VSS 0.04235f $ **FLOATING
C506 VRAMP.n24 VSS 0.02457f $ **FLOATING
C507 VRAMP.n25 VSS 0.04235f $ **FLOATING
C508 VRAMP.n26 VSS 0.04235f $ **FLOATING
C509 VRAMP.n27 VSS 0.14326f $ **FLOATING
C510 VRAMP.n28 VSS 0.14326f $ **FLOATING
C511 VRAMP.n29 VSS 0.14326f $ **FLOATING
C512 VRAMP.n30 VSS 0.04235f $ **FLOATING
C513 VRAMP.n31 VSS 0.04235f $ **FLOATING
C514 VRAMP.n33 VSS 0.02457f $ **FLOATING
C515 VRAMP.n34 VSS 0.04235f $ **FLOATING
C516 VRAMP.n35 VSS 0.02457f $ **FLOATING
C517 VRAMP.n36 VSS 0.04235f $ **FLOATING
C518 VRAMP.n37 VSS 0.04235f $ **FLOATING
C519 VRAMP.n38 VSS 0.14326f $ **FLOATING
C520 VRAMP.n39 VSS 0.14326f $ **FLOATING
C521 VRAMP.t4 VSS 0.01025f $ **FLOATING
C522 VRAMP.t11 VSS 0.01025f $ **FLOATING
C523 VRAMP.t8 VSS 0.01025f $ **FLOATING
C524 VRAMP.n42 VSS 0.02932f $ **FLOATING
C525 VRAMP.t1 VSS 9.18551f $ **FLOATING
C526 VRAMP.n43 VSS 0.0666f $ **FLOATING
C527 VRAMP.n44 VSS 6.17767f $ **FLOATING
C528 VRAMP.t0 VSS 3.8508f $ **FLOATING
C529 VRAMP.t9 VSS 0.01025f $ **FLOATING
C530 VRAMP.t13 VSS 0.01025f $ **FLOATING
C531 VRAMP.t10 VSS 0.01025f $ **FLOATING
C532 VRAMP.n49 VSS 2.4209f $ **FLOATING
C533 VRAMP.n50 VSS 1.73625f $ **FLOATING
C534 VRAMP.n51 VSS 0.03f $ **FLOATING
C535 VRAMP.n52 VSS 0.0302f $ **FLOATING
C536 VRAMP.n53 VSS 0.0172f $ **FLOATING
C537 VRAMP.n54 VSS 0.29977f $ **FLOATING
C538 VRAMP.n55 VSS 0.64932f $ **FLOATING
C539 RAMP_RESET.t0 VSS 0.35823f $ **FLOATING
C540 RAMP_RESET.n0 VSS 2.45587f $ **FLOATING
C541 RAMP_RESET.n1 VSS 0.86517f $ **FLOATING
C542 RAMP_RESET.t1 VSS 0.35811f $ **FLOATING
C543 RAMP_RESET.n2 VSS 0.02627f $ **FLOATING
C544 RAMP_RESET.n3 VSS 0.72179f $ **FLOATING
C545 VDD.n1 VSS 0.73514f $ **FLOATING
C546 VDD.t137 VSS 0.01879f $ **FLOATING
C547 VDD.t161 VSS 0.01879f $ **FLOATING
C548 VDD.t135 VSS 0.01879f $ **FLOATING
C549 VDD.t159 VSS 0.01879f $ **FLOATING
C550 VDD.t134 VSS 0.01879f $ **FLOATING
C551 VDD.t119 VSS 0.01879f $ **FLOATING
C552 VDD.t162 VSS 0.01687f $ **FLOATING
C553 VDD.n2 VSS 0.07453f $ **FLOATING
C554 VDD.n3 VSS 0.01737f $ **FLOATING
C555 VDD.n4 VSS 0.01737f $ **FLOATING
C556 VDD.n5 VSS 0.01737f $ **FLOATING
C557 VDD.n6 VSS 0.01737f $ **FLOATING
C558 VDD.n7 VSS 0.01737f $ **FLOATING
C559 VDD.n8 VSS 0.01737f $ **FLOATING
C560 VDD.n9 VSS 0.01737f $ **FLOATING
C561 VDD.n10 VSS 0.01737f $ **FLOATING
C562 VDD.n11 VSS 0.01737f $ **FLOATING
C563 VDD.n12 VSS 0.01737f $ **FLOATING
C564 VDD.n13 VSS 0.01737f $ **FLOATING
C565 VDD.n14 VSS 0.01737f $ **FLOATING
C566 VDD.n15 VSS 0.01737f $ **FLOATING
C567 VDD.n16 VSS 0.01737f $ **FLOATING
C568 VDD.n17 VSS 0.01737f $ **FLOATING
C569 VDD.n18 VSS 0.01737f $ **FLOATING
C570 VDD.n19 VSS 0.01737f $ **FLOATING
C571 VDD.n20 VSS 0.01737f $ **FLOATING
C572 VDD.n21 VSS 0.01737f $ **FLOATING
C573 VDD.n22 VSS 0.01737f $ **FLOATING
C574 VDD.n23 VSS 0.01737f $ **FLOATING
C575 VDD.n24 VSS 0.01737f $ **FLOATING
C576 VDD.n25 VSS 0.01737f $ **FLOATING
C577 VDD.n26 VSS 0.01737f $ **FLOATING
C578 VDD.n27 VSS 0.01737f $ **FLOATING
C579 VDD.n28 VSS 0.01737f $ **FLOATING
C580 VDD.n29 VSS 0.01737f $ **FLOATING
C581 VDD.n30 VSS 0.01737f $ **FLOATING
C582 VDD.n31 VSS 0.01737f $ **FLOATING
C583 VDD.n32 VSS 0.01737f $ **FLOATING
C584 VDD.n34 VSS 0.01098f $ **FLOATING
C585 VDD.n35 VSS 0.01737f $ **FLOATING
C586 VDD.n36 VSS 0.01737f $ **FLOATING
C587 VDD.n37 VSS 0.01737f $ **FLOATING
C588 VDD.n38 VSS 0.01737f $ **FLOATING
C589 VDD.n39 VSS 0.01737f $ **FLOATING
C590 VDD.n40 VSS 0.01737f $ **FLOATING
C591 VDD.n41 VSS 0.01737f $ **FLOATING
C592 VDD.n42 VSS 0.01737f $ **FLOATING
C593 VDD.n43 VSS 0.01737f $ **FLOATING
C594 VDD.n44 VSS 0.01737f $ **FLOATING
C595 VDD.n45 VSS 0.01737f $ **FLOATING
C596 VDD.n46 VSS 0.01737f $ **FLOATING
C597 VDD.n47 VSS 0.01737f $ **FLOATING
C598 VDD.n48 VSS 0.01737f $ **FLOATING
C599 VDD.n49 VSS 0.01737f $ **FLOATING
C600 VDD.n50 VSS 0.01737f $ **FLOATING
C601 VDD.n51 VSS 0.01737f $ **FLOATING
C602 VDD.n52 VSS 0.01737f $ **FLOATING
C603 VDD.n53 VSS 0.01737f $ **FLOATING
C604 VDD.n54 VSS 0.01737f $ **FLOATING
C605 VDD.n55 VSS 0.01737f $ **FLOATING
C606 VDD.n56 VSS 0.01737f $ **FLOATING
C607 VDD.n57 VSS 0.01737f $ **FLOATING
C608 VDD.n58 VSS 0.01737f $ **FLOATING
C609 VDD.n59 VSS 0.01737f $ **FLOATING
C610 VDD.n60 VSS 0.01737f $ **FLOATING
C611 VDD.n61 VSS 0.01737f $ **FLOATING
C612 VDD.n62 VSS 0.01737f $ **FLOATING
C613 VDD.n63 VSS 0.01737f $ **FLOATING
C614 VDD.n65 VSS 0.01737f $ **FLOATING
C615 VDD.t123 VSS 0.01687f $ **FLOATING
C616 VDD.t141 VSS 0.01879f $ **FLOATING
C617 VDD.t140 VSS 0.01879f $ **FLOATING
C618 VDD.t150 VSS 0.01879f $ **FLOATING
C619 VDD.t121 VSS 0.01879f $ **FLOATING
C620 VDD.t128 VSS 0.01879f $ **FLOATING
C621 VDD.t154 VSS 0.01879f $ **FLOATING
C622 VDD.t127 VSS 0.01879f $ **FLOATING
C623 VDD.t125 VSS 0.01879f $ **FLOATING
C624 VDD.t142 VSS 0.01879f $ **FLOATING
C625 VDD.t147 VSS 0.01879f $ **FLOATING
C626 VDD.t132 VSS 0.01879f $ **FLOATING
C627 VDD.t145 VSS 0.01879f $ **FLOATING
C628 VDD.t130 VSS 0.01879f $ **FLOATING
C629 VDD.n67 VSS 0.02556f $ **FLOATING
C630 VDD.n68 VSS 0.01409f $ **FLOATING
C631 VDD.n69 VSS 0.03598f $ **FLOATING
C632 VDD.n70 VSS 0.01406f $ **FLOATING
C633 VDD.n71 VSS 0.03605f $ **FLOATING
C634 VDD.n72 VSS 0.01409f $ **FLOATING
C635 VDD.n73 VSS 0.03451f $ **FLOATING
C636 VDD.n74 VSS 0.01796f $ **FLOATING
C637 VDD.n75 VSS 0.03131f $ **FLOATING
C638 VDD.n76 VSS 0.01409f $ **FLOATING
C639 VDD.n77 VSS 0.03605f $ **FLOATING
C640 VDD.n78 VSS 0.01406f $ **FLOATING
C641 VDD.n79 VSS 0.03598f $ **FLOATING
C642 VDD.n80 VSS 0.01409f $ **FLOATING
C643 VDD.n81 VSS 0.03605f $ **FLOATING
C644 VDD.n82 VSS 0.01406f $ **FLOATING
C645 VDD.n83 VSS 0.03598f $ **FLOATING
C646 VDD.n84 VSS 0.01409f $ **FLOATING
C647 VDD.n85 VSS 0.03605f $ **FLOATING
C648 VDD.n86 VSS 0.01406f $ **FLOATING
C649 VDD.n87 VSS 0.03598f $ **FLOATING
C650 VDD.n88 VSS 0.01409f $ **FLOATING
C651 VDD.n89 VSS 0.03605f $ **FLOATING
C652 VDD.n90 VSS 0.01406f $ **FLOATING
C653 VDD.n91 VSS 0.03598f $ **FLOATING
C654 VDD.n92 VSS 0.01409f $ **FLOATING
C655 VDD.n93 VSS 0.02536f $ **FLOATING
C656 VDD.n94 VSS 0.02934f $ **FLOATING
C657 VDD.n96 VSS 0.02054f $ **FLOATING
C658 VDD.n97 VSS 0.01011f $ **FLOATING
C659 VDD.n98 VSS 0.07086f $ **FLOATING
C660 VDD.n99 VSS 0.06824f $ **FLOATING
C661 VDD.n100 VSS 0.02692f $ **FLOATING
C662 VDD.n101 VSS 0.0406f $ **FLOATING
C663 VDD.n102 VSS 0.0406f $ **FLOATING
C664 VDD.n103 VSS 0.0406f $ **FLOATING
C665 VDD.n104 VSS 0.0406f $ **FLOATING
C666 VDD.n105 VSS 0.0406f $ **FLOATING
C667 VDD.n106 VSS 0.0406f $ **FLOATING
C668 VDD.n107 VSS 0.04149f $ **FLOATING
C669 VDD.n108 VSS 0.03447f $ **FLOATING
C670 VDD.n110 VSS 0.01967f $ **FLOATING
C671 VDD.n112 VSS 0.13296f $ **FLOATING
C672 VDD.n113 VSS 0.21049f $ **FLOATING
C673 VDD.n114 VSS 0.13357f $ **FLOATING
C674 VDD.n115 VSS 0.21458f $ **FLOATING
C675 VDD.n116 VSS 0.09051f $ **FLOATING
C676 VDD.n117 VSS 0.24934f $ **FLOATING
C677 VDD.n118 VSS 0.09481f $ **FLOATING
C678 VDD.n119 VSS 0.23414f $ **FLOATING
C679 VDD.n120 VSS 0.10913f $ **FLOATING
C680 VDD.n121 VSS 0.23414f $ **FLOATING
C681 VDD.n122 VSS 0.09481f $ **FLOATING
C682 VDD.n123 VSS 0.24934f $ **FLOATING
C683 VDD.n124 VSS 0.09051f $ **FLOATING
C684 VDD.n125 VSS 0.21458f $ **FLOATING
C685 VDD.n126 VSS 0.13357f $ **FLOATING
C686 VDD.t138 VSS 0.49135f $ **FLOATING
C687 VDD.t118 VSS 0.38092f $ **FLOATING
C688 VDD.t148 VSS 0.43373f $ **FLOATING
C689 VDD.t133 VSS 0.49135f $ **FLOATING
C690 VDD.t158 VSS 0.38092f $ **FLOATING
C691 VDD.t149 VSS 0.43373f $ **FLOATING
C692 VDD.t40 VSS 0.49135f $ **FLOATING
C693 VDD.t160 VSS 0.38092f $ **FLOATING
C694 VDD.t136 VSS 0.43373f $ **FLOATING
C695 VDD.t144 VSS 0.49135f $ **FLOATING
C696 VDD.t129 VSS 0.38092f $ **FLOATING
C697 VDD.t167 VSS 0.43373f $ **FLOATING
C698 VDD.t131 VSS 0.49135f $ **FLOATING
C699 VDD.t168 VSS 0.38092f $ **FLOATING
C700 VDD.t146 VSS 0.60178f $ **FLOATING
C701 VDD.t169 VSS 0.38252f $ **FLOATING
C702 VDD.t124 VSS 0.54256f $ **FLOATING
C703 VDD.t165 VSS 0.38092f $ **FLOATING
C704 VDD.t152 VSS 0.38252f $ **FLOATING
C705 VDD.t126 VSS 0.54256f $ **FLOATING
C706 VDD.t153 VSS 0.38092f $ **FLOATING
C707 VDD.t143 VSS 0.38252f $ **FLOATING
C708 VDD.t42 VSS 0.54256f $ **FLOATING
C709 VDD.t120 VSS 0.38092f $ **FLOATING
C710 VDD.t163 VSS 0.38252f $ **FLOATING
C711 VDD.t139 VSS 0.54256f $ **FLOATING
C712 VDD.t164 VSS 0.38092f $ **FLOATING
C713 VDD.t151 VSS 0.38252f $ **FLOATING
C714 VDD.t122 VSS 0.54256f $ **FLOATING
C715 VDD.n157 VSS 0.3281f $ **FLOATING
C716 VDD.n159 VSS 0.43533f $ **FLOATING
C717 VDD.n177 VSS 0.24742f $ **FLOATING
C718 VDD.t10 VSS 8.77974f $ **FLOATING
C719 VDD.n181 VSS 0.60626f $ **FLOATING
C720 VDD.n182 VSS 0.52652f $ **FLOATING
C721 VDD.n183 VSS 0.59665f $ **FLOATING
C722 VDD.n184 VSS 0.13357f $ **FLOATING
C723 VDD.n185 VSS 0.20818f $ **FLOATING
C724 VDD.n186 VSS 0.09451f $ **FLOATING
C725 VDD.n187 VSS 0.25174f $ **FLOATING
C726 VDD.n188 VSS 0.09481f $ **FLOATING
C727 VDD.n189 VSS 0.23414f $ **FLOATING
C728 VDD.n190 VSS 0.10913f $ **FLOATING
C729 VDD.n191 VSS 0.23037f $ **FLOATING
C730 VDD.n192 VSS 0.09447f $ **FLOATING
C731 VDD.n193 VSS 0.25346f $ **FLOATING
C732 VDD.n194 VSS 0.09051f $ **FLOATING
C733 VDD.n195 VSS 0.21458f $ **FLOATING
C734 VDD.n196 VSS 0.57868f $ **FLOATING
C735 VDD.n197 VSS 0.13357f $ **FLOATING
C736 VDD.n198 VSS 0.43533f $ **FLOATING
C737 VDD.t7 VSS 8.99741f $ **FLOATING
C738 VDD.n200 VSS 1.83986f $ **FLOATING
C739 VDD.n201 VSS 0.01737f $ **FLOATING
C740 VDD.n203 VSS 0.07681f $ **FLOATING
C741 VDD.n204 VSS 0.01143f $ **FLOATING
C742 VDD.t174 VSS 0.05622f $ **FLOATING
C743 VDD.n205 VSS 0.1375f $ **FLOATING
C744 VDD.t173 VSS 0.04516f $ **FLOATING
C745 VDD.t21 VSS 0.01647f $ **FLOATING
C746 VDD.t36 VSS 0.01067f $ **FLOATING
C747 VDD.t6 VSS 0.01031f $ **FLOATING
C748 VDD.n206 VSS 0.07462f $ **FLOATING
C749 VDD.n207 VSS 0.04729f $ **FLOATING
C750 VDD.n210 VSS 0.01123f $ **FLOATING
C751 VDD.n211 VSS 0.01123f $ **FLOATING
C752 VDD.n226 VSS 0.95898f $ **FLOATING
C753 VDD.n228 VSS 0.01088f $ **FLOATING
C754 VDD.n229 VSS 0.01087f $ **FLOATING
C755 VDD.n230 VSS 0.19524f $ **FLOATING
C756 VDD.n232 VSS 0.05473f $ **FLOATING
C757 VDD.n233 VSS 0.0254f $ **FLOATING
C758 VDD.n234 VSS 0.07321f $ **FLOATING
C759 VDD.n235 VSS 0.02651f $ **FLOATING
C760 VDD.n237 VSS 0.01052f $ **FLOATING
C761 VDD.n238 VSS 0.01052f $ **FLOATING
C762 VDD.n240 VSS 0.01052f $ **FLOATING
C763 VDD.n241 VSS 0.01052f $ **FLOATING
C764 VDD.n243 VSS 0.02326f $ **FLOATING
C765 VDD.t32 VSS 0.23687f $ **FLOATING
C766 VDD.n246 VSS 0.16079f $ **FLOATING
C767 VDD.n252 VSS 0.01052f $ **FLOATING
C768 VDD.n255 VSS 0.01052f $ **FLOATING
C769 VDD.n257 VSS 0.01052f $ **FLOATING
C770 VDD.n258 VSS 0.01052f $ **FLOATING
C771 VDD.n261 VSS 0.01052f $ **FLOATING
C772 VDD.t180 VSS 0.01647f $ **FLOATING
C773 VDD.t185 VSS 0.07148f $ **FLOATING
C774 VDD.t184 VSS 0.07946f $ **FLOATING
C775 VDD.t183 VSS 1.28966f $ **FLOATING
C776 VDD.n262 VSS 0.22329f $ **FLOATING
C777 VDD.n263 VSS 0.07083f $ **FLOATING
C778 VDD.n264 VSS 0.16032f $ **FLOATING
C779 VDD.n265 VSS 0.14596f $ **FLOATING
C780 VDD.n266 VSS 0.07069f $ **FLOATING
C781 VDD.t23 VSS 0.01031f $ **FLOATING
C782 VDD.n268 VSS 0.19071f $ **FLOATING
C783 VDD.n269 VSS 0.13683f $ **FLOATING
C784 VDD.t30 VSS 0.01031f $ **FLOATING
C785 VDD.n271 VSS 0.177f $ **FLOATING
C786 VDD.t24 VSS 0.0107f $ **FLOATING
C787 VDD.t31 VSS 0.01031f $ **FLOATING
C788 VDD.n272 VSS 0.0378f $ **FLOATING
C789 VDD.n273 VSS 0.22194f $ **FLOATING
C790 VDD.n274 VSS 0.08292f $ **FLOATING
C791 VDD.n275 VSS 0.06113f $ **FLOATING
C792 VDD.n276 VSS 0.0682f $ **FLOATING
C793 VDD.t19 VSS 0.19524f $ **FLOATING
C794 VDD.n277 VSS 0.19524f $ **FLOATING
C795 VDD.n278 VSS 0.39048f $ **FLOATING
C796 VDD.n279 VSS 0.01281f $ **FLOATING
C797 VDD.t88 VSS 6.69784f $ **FLOATING
C798 VDD.n281 VSS 0.19524f $ **FLOATING
C799 VDD.n282 VSS 0.15568f $ **FLOATING
C800 VDD.n283 VSS 0.01179f $ **FLOATING
C801 VDD.n284 VSS 0.19524f $ **FLOATING
C802 VDD.n286 VSS 0.06193f $ **FLOATING
C803 VDD.t194 VSS 0.01631f $ **FLOATING
C804 VDD.t219 VSS 0.01631f $ **FLOATING
C805 VDD.t203 VSS 0.01631f $ **FLOATING
C806 VDD.n287 VSS 0.05399f $ **FLOATING
C807 VDD.n289 VSS 0.06669f $ **FLOATING
C808 VDD.n290 VSS 0.01006f $ **FLOATING
C809 VDD.t13 VSS 0.01827f $ **FLOATING
C810 VDD.t16 VSS 0.02248f $ **FLOATING
C811 VDD.t14 VSS 0.0215f $ **FLOATING
C812 VDD.n291 VSS 0.04518f $ **FLOATING
C813 VDD.n292 VSS 0.01274f $ **FLOATING
C814 VDD.t228 VSS 0.01631f $ **FLOATING
C815 VDD.t212 VSS 0.01631f $ **FLOATING
C816 VDD.t199 VSS 0.01631f $ **FLOATING
C817 VDD.n294 VSS 0.05399f $ **FLOATING
C818 VDD.n295 VSS 0.07066f $ **FLOATING
C819 VDD.t198 VSS 0.09691f $ **FLOATING
C820 VDD.n296 VSS 0.05399f $ **FLOATING
C821 VDD.n297 VSS 0.06907f $ **FLOATING
C822 VDD.t229 VSS 0.01631f $ **FLOATING
C823 VDD.t213 VSS 0.01631f $ **FLOATING
C824 VDD.t200 VSS 0.01631f $ **FLOATING
C825 VDD.n298 VSS 0.05399f $ **FLOATING
C826 VDD.n299 VSS 0.0127f $ **FLOATING
C827 VDD.n300 VSS 0.9296f $ **FLOATING
C828 VDD.n301 VSS 0.01837f $ **FLOATING
C829 VDD.n303 VSS 0.04518f $ **FLOATING
C830 VDD.t193 VSS 0.01631f $ **FLOATING
C831 VDD.t192 VSS 0.09691f $ **FLOATING
C832 VDD.n304 VSS 0.05399f $ **FLOATING
C833 VDD.n305 VSS 0.07304f $ **FLOATING
C834 VDD.t218 VSS 0.01631f $ **FLOATING
C835 VDD.t202 VSS 0.01631f $ **FLOATING
C836 VDD.n306 VSS 0.05399f $ **FLOATING
C837 VDD.n307 VSS 0.0127f $ **FLOATING
C838 VDD.n308 VSS 0.29014f $ **FLOATING
C839 VDD.n309 VSS 0.06068f $ **FLOATING
C840 VDD.n310 VSS 0.06034f $ **FLOATING
C841 VDD.n311 VSS 0.07955f $ **FLOATING
C842 VDD.n312 VSS 0.01707f $ **FLOATING
C843 VDD.t2 VSS 0.39048f $ **FLOATING
C844 VDD.n313 VSS 0.19524f $ **FLOATING
C845 VDD.t3 VSS 0.19524f $ **FLOATING
C846 VDD.n315 VSS 0.01052f $ **FLOATING
C847 VDD.n316 VSS 0.19524f $ **FLOATING
C848 VDD.n318 VSS 0.04132f $ **FLOATING
C849 VDD.n319 VSS 0.03538f $ **FLOATING
C850 VDD.t0 VSS 0.22395f $ **FLOATING
C851 VDD.n321 VSS 0.16653f $ **FLOATING
C852 VDD.n322 VSS 0.19524f $ **FLOATING
C853 VDD.n324 VSS 0.19524f $ **FLOATING
C854 VDD.t4 VSS 0.2297f $ **FLOATING
C855 VDD.n326 VSS 0.19524f $ **FLOATING
C856 VDD.n329 VSS 0.01052f $ **FLOATING
C857 VDD.n331 VSS 0.01052f $ **FLOATING
C858 VDD.n332 VSS 0.01052f $ **FLOATING
C859 VDD.n333 VSS 0.01052f $ **FLOATING
C860 VDD.n335 VSS 0.08431f $ **FLOATING
C861 VDD.t94 VSS 0.02703f $ **FLOATING
C862 VDD.t97 VSS 0.02534f $ **FLOATING
C863 VDD.n343 VSS 0.06472f $ **FLOATING
C864 VDD.t93 VSS 0.02703f $ **FLOATING
C865 VDD.t96 VSS 0.02807f $ **FLOATING
C866 VDD.n344 VSS 0.06472f $ **FLOATING
C867 VDD.n345 VSS 0.02127f $ **FLOATING
C868 VDD.n348 VSS 0.05341f $ **FLOATING
C869 VDD.n350 VSS 0.05414f $ **FLOATING
C870 VDD.n351 VSS 0.05341f $ **FLOATING
C871 VDD.n352 VSS 0.05341f $ **FLOATING
C872 VDD.n353 VSS 0.05414f $ **FLOATING
C873 VDD.t208 VSS 0.04078f $ **FLOATING
C874 VDD.n354 VSS 0.04975f $ **FLOATING
C875 VDD.n355 VSS 0.04975f $ **FLOATING
C876 VDD.n356 VSS 0.09849f $ **FLOATING
C877 VDD.n358 VSS 0.12199f $ **FLOATING
C878 VDD.n359 VSS 0.01737f $ **FLOATING
C879 VDD.n360 VSS 0.09803f $ **FLOATING
C880 VDD.n361 VSS 0.04975f $ **FLOATING
C881 VDD.t207 VSS 0.06898f $ **FLOATING
C882 VDD.n362 VSS 0.04975f $ **FLOATING
C883 VDD.n363 VSS 0.06218f $ **FLOATING
C884 VDD.n364 VSS 0.04975f $ **FLOATING
C885 VDD.t204 VSS 0.50412f $ **FLOATING
C886 VDD.n365 VSS 0.02472f $ **FLOATING
C887 VDD.n366 VSS 0.02926f $ **FLOATING
C888 VDD.n367 VSS 0.02515f $ **FLOATING
C889 VDD.n371 VSS 0.06145f $ **FLOATING
C890 VDD.t206 VSS 0.49149f $ **FLOATING
C891 VDD.n373 VSS 0.04975f $ **FLOATING
C892 VDD.n374 VSS 0.06365f $ **FLOATING
C893 VDD.n375 VSS 0.05341f $ **FLOATING
C894 VDD.n376 VSS 0.05341f $ **FLOATING
C895 VDD.n377 VSS 0.05414f $ **FLOATING
C896 VDD.n378 VSS 0.05341f $ **FLOATING
C897 VDD.n380 VSS 0.05414f $ **FLOATING
C898 VDD.t224 VSS 0.04078f $ **FLOATING
C899 VDD.n381 VSS 0.09849f $ **FLOATING
C900 VDD.n382 VSS 0.04975f $ **FLOATING
C901 VDD.n383 VSS 0.04975f $ **FLOATING
C902 VDD.n385 VSS 0.04975f $ **FLOATING
C903 VDD.n386 VSS 0.01737f $ **FLOATING
C904 VDD.n387 VSS 0.04975f $ **FLOATING
C905 VDD.n388 VSS 0.09803f $ **FLOATING
C906 VDD.t205 VSS 0.06898f $ **FLOATING
C907 VDD.n389 VSS 0.08695f $ **FLOATING
C908 VDD.t22 VSS 0.01041f $ **FLOATING
C909 VDD.n390 VSS 0.12845f $ **FLOATING
C910 VDD.n391 VSS 0.09445f $ **FLOATING
C911 VDD.n394 VSS 0.36534f $ **FLOATING
C912 VDD.n395 VSS 0.01f $ **FLOATING
C913 VDD.t89 VSS 0.03708f $ **FLOATING
C914 VDD.t91 VSS 0.02703f $ **FLOATING
C915 VDD.t92 VSS 0.02703f $ **FLOATING
C916 VDD.n396 VSS 0.01004f $ **FLOATING
C917 VDD.t101 VSS 0.02703f $ **FLOATING
C918 VDD.n397 VSS 0.01003f $ **FLOATING
C919 VDD.t90 VSS 0.0243f $ **FLOATING
C920 VDD.t233 VSS 0.03708f $ **FLOATING
C921 VDD.n398 VSS 0.015f $ **FLOATING
C922 VDD.n399 VSS 0.05698f $ **FLOATING
C923 VDD.n403 VSS 0.02548f $ **FLOATING
C924 VDD.n405 VSS 0.02088f $ **FLOATING
C925 VDD.n406 VSS 0.01109f $ **FLOATING
C926 VDD.n407 VSS 0.02088f $ **FLOATING
C927 VDD.n408 VSS 0.01256f $ **FLOATING
C928 VDD.n409 VSS 0.03171f $ **FLOATING
C929 VDD.n410 VSS 0.01353f $ **FLOATING
C930 VDD.n411 VSS 0.01073f $ **FLOATING
C931 VDD.n418 VSS 0.02098f $ **FLOATING
C932 VDD.n419 VSS 0.01849f $ **FLOATING
C933 VDD.n420 VSS 0.01913f $ **FLOATING
C934 VDD.n422 VSS 0.0226f $ **FLOATING
C935 VDD.n424 VSS 0.02045f $ **FLOATING
C936 VDD.n425 VSS 0.02553f $ **FLOATING
C937 VDD.n426 VSS 0.01794f $ **FLOATING
C938 VDD.n427 VSS 0.0491f $ **FLOATING
C939 VDD.n429 VSS 0.03333f $ **FLOATING
C940 VDD.n430 VSS 0.01116f $ **FLOATING
C941 VDD.n431 VSS 0.05594f $ **FLOATING
C942 VDD.n432 VSS 0.03877f $ **FLOATING
C943 VDD.n433 VSS 0.02175f $ **FLOATING
C944 VDD.n434 VSS 0.03714f $ **FLOATING
C945 VDD.n436 VSS 0.05141f $ **FLOATING
C946 VDD.n437 VSS 0.03021f $ **FLOATING
C947 VDD.n438 VSS 0.01257f $ **FLOATING
C948 VDD.n439 VSS 0.05636f $ **FLOATING
C949 VDD.n440 VSS 0.01532f $ **FLOATING
C950 VDD.n441 VSS 0.02146f $ **FLOATING
C951 VDD.n442 VSS 0.01166f $ **FLOATING
C952 VDD.n449 VSS 0.21772f $ **FLOATING
C953 VDD.n451 VSS 0.02088f $ **FLOATING
C954 VDD.n452 VSS 0.01109f $ **FLOATING
C955 VDD.n453 VSS 0.02088f $ **FLOATING
C956 VDD.n454 VSS 0.01109f $ **FLOATING
C957 VDD.n455 VSS 0.02088f $ **FLOATING
C958 VDD.n457 VSS 0.02851f $ **FLOATING
C959 VDD.n458 VSS 0.11435f $ **FLOATING
C960 VDD.n459 VSS 0.04681f $ **FLOATING
C961 VDD.n461 VSS 0.01052f $ **FLOATING
C962 VDD.n462 VSS 0.03346f $ **FLOATING
C963 VDD.n464 VSS 0.01971f $ **FLOATING
C964 VDD.n466 VSS 0.05446f $ **FLOATING
C965 VDD.n468 VSS 0.01052f $ **FLOATING
C966 VDD.n469 VSS 0.39048f $ **FLOATING
C967 VDD.n471 VSS 0.01052f $ **FLOATING
C968 VDD.n473 VSS 0.39048f $ **FLOATING
C969 VDD.n475 VSS 0.01052f $ **FLOATING
C970 VDD.n476 VSS 0.12665f $ **FLOATING
C971 VDD.t27 VSS 0.39048f $ **FLOATING
C972 VDD.n478 VSS 0.0734f $ **FLOATING
C973 VDD.n479 VSS 0.02098f $ **FLOATING
C974 VDD.n480 VSS 0.02176f $ **FLOATING
C975 VDD.n481 VSS 0.3045f $ **FLOATING
C976 VDD.n482 VSS 0.01693f $ **FLOATING
C977 VDD.n483 VSS 0.18471f $ **FLOATING
C978 VDD.n484 VSS 0.01192f $ **FLOATING
C979 VDD.n485 VSS 0.12276f $ **FLOATING
C980 VDD.n486 VSS 0.0128f $ **FLOATING
C981 VDD.n487 VSS 0.0641f $ **FLOATING
C982 VDD.n488 VSS 0.0641f $ **FLOATING
C983 VDD.n489 VSS 0.0641f $ **FLOATING
C984 VDD.n490 VSS 0.01697f $ **FLOATING
C985 VDD.n491 VSS 0.04713f $ **FLOATING
C986 VDD.n492 VSS 0.0641f $ **FLOATING
C987 VDD.t179 VSS 0.01035f $ **FLOATING
C988 VDD.n493 VSS 0.06221f $ **FLOATING
C989 VDD.n494 VSS 0.02922f $ **FLOATING
C990 VDD.n495 VSS 0.0641f $ **FLOATING
C991 VDD.n496 VSS 0.0641f $ **FLOATING
C992 VDD.n497 VSS 0.0641f $ **FLOATING
C993 VDD.n498 VSS 0.0641f $ **FLOATING
C994 VDD.n499 VSS 0.0641f $ **FLOATING
C995 VDD.n500 VSS 0.0641f $ **FLOATING
C996 VDD.n501 VSS 0.0641f $ **FLOATING
C997 VDD.n502 VSS 0.0641f $ **FLOATING
C998 VDD.n503 VSS 0.01603f $ **FLOATING
C999 VDD.n504 VSS 0.05047f $ **FLOATING
C1000 VDD.t111 VSS 0.02703f $ **FLOATING
C1001 VDD.t114 VSS 0.02807f $ **FLOATING
C1002 VDD.n505 VSS 0.06472f $ **FLOATING
C1003 VDD.t112 VSS 0.02703f $ **FLOATING
C1004 VDD.t115 VSS 0.02534f $ **FLOATING
C1005 VDD.n506 VSS 0.06472f $ **FLOATING
C1006 VDD.t29 VSS 0.03708f $ **FLOATING
C1007 VDD.n507 VSS 0.02589f $ **FLOATING
C1008 VDD.n508 VSS 0.01003f $ **FLOATING
C1009 VDD.n509 VSS 0.01003f $ **FLOATING
C1010 VDD.t105 VSS 0.02703f $ **FLOATING
C1011 VDD.t104 VSS 0.02703f $ **FLOATING
C1012 VDD.t232 VSS 0.03708f $ **FLOATING
C1013 VDD.t107 VSS 0.02703f $ **FLOATING
C1014 VDD.n510 VSS 0.08145f $ **FLOATING
C1015 VDD.n511 VSS 0.01718f $ **FLOATING
C1016 VDD.n512 VSS 0.03634f $ **FLOATING
C1017 VDD.n514 VSS 0.01944f $ **FLOATING
C1018 VDD.n515 VSS 0.04254f $ **FLOATING
C1019 VDD.n516 VSS 0.01374f $ **FLOATING
C1020 VDD.n517 VSS 0.03903f $ **FLOATING
C1021 VDD.n518 VSS 0.04407f $ **FLOATING
C1022 VDD.n519 VSS 0.01191f $ **FLOATING
C1023 VDD.n520 VSS 0.0307f $ **FLOATING
C1024 VDD.t109 VSS 0.0243f $ **FLOATING
C1025 VDD.n523 VSS 0.07344f $ **FLOATING
C1026 VDD.n524 VSS 0.03083f $ **FLOATING
C1027 VDD.n525 VSS 0.01283f $ **FLOATING
C1028 VDD.n526 VSS 0.0489f $ **FLOATING
C1029 VDD.n527 VSS 0.01004f $ **FLOATING
C1030 VDD.t28 VSS 6.49111f $ **FLOATING
C1031 VDD.n529 VSS 0.0356f $ **FLOATING
C1032 VDD.n531 VSS 0.0215f $ **FLOATING
C1033 VDD.n533 VSS 0.02729f $ **FLOATING
C1034 VDD.n534 VSS 0.02599f $ **FLOATING
C1035 VDD.n535 VSS 0.04079f $ **FLOATING
C1036 VDD.n536 VSS 0.01392f $ **FLOATING
C1037 VDD.n537 VSS 0.03057f $ **FLOATING
C1038 VDD.n538 VSS 0.09357f $ **FLOATING
C1039 VDD.n539 VSS 0.06033f $ **FLOATING
C1040 VDD.t196 VSS 0.08635f $ **FLOATING
C1041 VDD.n540 VSS 0.05939f $ **FLOATING
C1042 VDD.n541 VSS 0.05185f $ **FLOATING
C1043 VDD.t210 VSS 0.08635f $ **FLOATING
C1044 VDD.n542 VSS 0.57328f $ **FLOATING
C1045 VDD.n543 VSS 0.02656f $ **FLOATING
C1046 VDD.n544 VSS 0.0641f $ **FLOATING
C1047 VDD.n545 VSS 0.16578f $ **FLOATING
C1048 VDD.t195 VSS 1.07475f $ **FLOATING
C1049 VDD.n546 VSS 0.12135f $ **FLOATING
C1050 VDD.n547 VSS 0.0781f $ **FLOATING
C1051 VDD.t197 VSS 0.04078f $ **FLOATING
C1052 VDD.t216 VSS 0.04078f $ **FLOATING
C1053 VDD.n548 VSS 0.09372f $ **FLOATING
C1054 VDD.n549 VSS 3.04386f $ **FLOATING
C1055 VDD.n551 VSS 0.01052f $ **FLOATING
C1056 VDD.n552 VSS 0.03287f $ **FLOATING
C1057 VDD.n553 VSS 0.02862f $ **FLOATING
C1058 VDD.n554 VSS 0.01801f $ **FLOATING
C1059 VDD.n555 VSS 0.01801f $ **FLOATING
C1060 VDD.n556 VSS 0.01939f $ **FLOATING
C1061 VDD.n557 VSS 0.01215f $ **FLOATING
C1062 VDD.n558 VSS 0.01011f $ **FLOATING
C1063 VDD.n559 VSS 0.02876f $ **FLOATING
C1064 VDD.n560 VSS 0.01808f $ **FLOATING
C1065 VDD.n561 VSS 0.01266f $ **FLOATING
C1066 VDD.n562 VSS 0.05919f $ **FLOATING
C1067 VDD.n563 VSS 0.07269f $ **FLOATING
C1068 VDD.n564 VSS 0.02112f $ **FLOATING
C1069 VDD.n565 VSS 0.41319f $ **FLOATING
C1070 VDD.t1 VSS 4.32879f $ **FLOATING
C1071 VDD.n568 VSS 0.01468f $ **FLOATING
C1072 VDD.n569 VSS 0.07781f $ **FLOATING
C1073 VDD.n570 VSS 0.06326f $ **FLOATING
C1074 VDD.t5 VSS 0.01031f $ **FLOATING
C1075 VDD.n572 VSS 0.07787f $ **FLOATING
C1076 VDD.n573 VSS 0.05325f $ **FLOATING
C1077 VDD.t35 VSS 0.01031f $ **FLOATING
C1078 VDD.n575 VSS 0.07069f $ **FLOATING
C1079 VDD.n576 VSS 0.0533f $ **FLOATING
C1080 VDD.n577 VSS 0.03732f $ **FLOATING
C1081 VDD.n578 VSS 0.02869f $ **FLOATING
C1082 VDD.t172 VSS 1.24713f $ **FLOATING
C1083 VDD.n579 VSS 0.10057f $ **FLOATING
C1084 VDD.n580 VSS 0.02836f $ **FLOATING
C1085 VDD.n581 VSS 0.03195f $ **FLOATING
C1086 VDD.n582 VSS 0.46677f $ **FLOATING
C1087 VDD.n583 VSS 0.10498f $ **FLOATING
C1088 VDD.n585 VSS 11.9722f $ **FLOATING
C1089 VDD.n586 VSS 0.15357f $ **FLOATING
C1090 VDD.n587 VSS 0.11024f $ **FLOATING
C1091 VDD.n588 VSS 0.25352f $ **FLOATING
C1092 VDD.n589 VSS 0.11236f $ **FLOATING
C1093 VDD.n590 VSS 0.24746f $ **FLOATING
C1094 VDD.n591 VSS 0.11024f $ **FLOATING
C1095 VDD.n592 VSS 0.25352f $ **FLOATING
C1096 VDD.n593 VSS 0.11236f $ **FLOATING
C1097 VDD.n594 VSS 0.24746f $ **FLOATING
C1098 VDD.n595 VSS 0.11024f $ **FLOATING
C1099 VDD.n596 VSS 0.25352f $ **FLOATING
C1100 VDD.n597 VSS 0.11236f $ **FLOATING
C1101 VDD.n598 VSS 0.20581f $ **FLOATING
C1102 VDD.n599 VSS 0.11457f $ **FLOATING
C1103 VDD.n600 VSS 2.63073f $ **FLOATING
C1104 VBIAS.t3 VSS 0.15313f $ **FLOATING
C1105 VBIAS.t7 VSS 0.148f $ **FLOATING
C1106 VBIAS.t1 VSS 0.16699f $ **FLOATING
C1107 VBIAS.t6 VSS 0.16186f $ **FLOATING
C1108 VBIAS.t0 VSS 0.16699f $ **FLOATING
C1109 VBIAS.t4 VSS 0.16186f $ **FLOATING
C1110 VBIAS.t2 VSS 0.16699f $ **FLOATING
C1111 VBIAS.t5 VSS 0.16186f $ **FLOATING
C1112 VBIAS.n0 VSS 0.20044f $ **FLOATING
C1113 VBIAS.n1 VSS 0.22387f $ **FLOATING
C1114 VBIAS.n2 VSS 0.22387f $ **FLOATING
C1115 VBIAS.n3 VSS 0.23529f $ **FLOATING
C1116 VBIAS.t8 VSS 1.25543f $ **FLOATING
C1117 VBIAS.n4 VSS 0.64869f $ **FLOATING
.ends
