.subckt ramp_generator VDD VSS
.ends
.end
