* NGSPICE file created from top_conditionning.ext - technology: ihp-sg13g2

.subckt top_conditionning VSS IOVDD VOUT S0 S1 S2 S3 SEL_CAL SEL_SENSOR VBG VBIASH
+ EN VBIAS VDD COMPARATOR_RES SENSOR
X0 non_inverting_amplifier_hv_0.ota_hv_slow_gmid_0.vota.t1 VAMP.t62 non_inverting_amplifier_hv_0.ota_hv_slow_gmid_0.ota_hv_slow_gmid_tail_0.tail.t0 IOVDD.t3 sg13_hv_pmos ad=0.6069p pd=4.25u as=0.33915p ps=2.165u w=1.785u l=3u
X1 VSS.t389 VSS.t390 VSS.t388 rhigh l=2.5u w=0.5u
X2 dw_n7292_5488.t8 a_n1031_4249.t0 VSS.t465 rhigh l=2.5u w=0.5u
X3 VDD.t132 VDD.t159 VDD.t132 VDD.t66 sg13_lv_pmos ad=0.475p pd=2.88u as=0 ps=0 w=2.5u l=2u
X4 current_source_1mA_0.ota_med_hv_gmid_0.ota_med_hv_gmid_tail_0.tail.t0 current_source_1mA_0.current_source_1mA_2_stage_0.vcp.t6 current_source_1mA_0.ota_med_hv_gmid_0.ota_med_hv_gmid_mirror_0.Iref.t3 IOVDD.t4 sg13_hv_pmos ad=0.5586p pd=3.32u as=0.9996p ps=6.56u w=2.94u l=1u
X5 VSS.t882 VSS.t517 VSS.t881 VSS.t880 sg13_hv_nmos ad=1.4535p pd=9.23u as=0 ps=0 w=4.275u l=4u
X6 two_stage_instrumentation_amplifier_0.ota_slow_gmid_1.vout1.t3 two_stage_instrumentation_amplifier_0.ota_slow_gmid_1.en_n.t2 VSS.t175 VSS.t184 sg13_lv_nmos ad=0.228p pd=1.58u as=0.228p ps=1.58u w=1.2u l=0.13u
X7 non_inverting_amplifier_hv_0.ota_hv_slow_gmid_0.vota.t2 non_inverting_amplifier_hv_0.ota_hv_slow_gmid_0.vref.t2 VSS.t1016 VSS.t900 sg13_hv_nmos ad=1.4535p pd=9.23u as=0.81225p ps=4.655u w=4.275u l=10u
X8 IOVDD.t193 IOVDD.t64 IOVDD.t167 IOVDD.t16 sg13_hv_pmos ad=0.34p pd=2.68u as=0 ps=0 w=1u l=0.5u
X9 VDD.t87 VBIAS.t32 two_stage_instrumentation_amplifier_0.ota_slow_gmid_1.vout1.t13 VDD.t0 sg13_lv_pmos ad=0.19p pd=1.38u as=0.34p ps=2.68u w=1u l=0.5u
X10 ref_selector_0.I1MA.t13 SEL_CAL.t0 ref_selector_0.ref_selector_r_96_0.vcal.t8 VSS.t211 sg13_lv_nmos ad=0.95p pd=5.38u as=0.95p ps=5.38u w=5u l=0.13u
X11 IOVDD.t85 IOVDD.t73 IOVDD.t85 IOVDD.t25 sg13_hv_pmos ad=0.19p pd=1.38u as=0 ps=0 w=1u l=0.5u
X12 VDD.t59 two_stage_instrumentation_amplifier_0.ota_slow_gmid_0.en.t2 VBIAS.t17 VDD.t68 sg13_lv_pmos ad=0.19p pd=1.38u as=0.19p ps=1.38u w=1u l=0.13u
X13 non_inverting_amplifier_hv_0.ota_hv_slow_gmid_0.vamp.t7 non_inverting_amplifier_hv_0.ota_hv_slow_gmid_0.en_n.t2 VSS.t216 VSS.t212 sg13_hv_nmos ad=0.4218p pd=2.6u as=0.4218p ps=2.6u w=2.22u l=0.45u
X14 VSS.t879 VSS.t507 VSS.t878 VSS.t508 sg13_lv_nmos ad=0.17p pd=1.68u as=0 ps=0 w=0.5u l=2u
X15 VSS.t876 VSS.t492 VSS.t875 VSS.t538 sg13_lv_nmos ad=0.1075p pd=1.34u as=0 ps=0 w=0.25u l=0.5u
X16 SENSOR.t1 SEL_SENSOR.t0 two_stage_instrumentation_amplifier_0.VP.t0 VSS.t169 sg13_lv_nmos ad=0.95p pd=5.38u as=1.7p ps=10.68u w=5u l=0.13u
X17 ota_lv_gmid_comparator_0.ota_slow_gmid_mirror_0.vout1.t5 VBIAS.t33 VDD.t94 VDD.t54 sg13_lv_pmos ad=0.34p pd=2.68u as=0.19p ps=1.38u w=1u l=0.5u
X18 a_n17403_4529.t0 a_n17104_4821.t0 VSS.t391 rhigh l=3u w=0.5u
X19 ref_selector_0.I1MA.t11 current_source_1mA_0.current_source_1mA_2_stage_0.current_source_pass_element_0.iref.t4 IOVDD.t39 IOVDD.t31 sg13_hv_pmos ad=0.285p pd=1.88u as=0.285p ps=1.88u w=1.5u l=0.5u
X20 two_stage_instrumentation_amplifier_0.vamp1.t1 two_stage_instrumentation_amplifier_0.ota_slow_gmid_1.vout1.t19 VDD.t84 VSS.t411 sg13_lv_nmos ad=0.19p pd=1.38u as=0.19p ps=1.38u w=1u l=0.13u
X21 two_stage_instrumentation_amplifier_0.ota_slow_gmid_1.vout1.t2 two_stage_instrumentation_amplifier_0.ota_slow_gmid_1.en_n.t2 VSS.t181 VSS.t183 sg13_lv_nmos ad=0.228p pd=1.58u as=0.228p ps=1.58u w=1.2u l=0.13u
X22 a_n9604_1483.t1 a_n9874_1205.t1 VSS.t395 rhigh l=0.96u w=0.5u
X23 VDD.t72 two_stage_instrumentation_amplifier_0.ota_slow_gmid_0.en.t3 VBIAS.t23 VDD.t55 sg13_lv_pmos ad=0.19p pd=1.38u as=0.19p ps=1.38u w=1u l=0.13u
X24 VSS.t145 VSS.t146 VSS.t144 rppd l=1.43u w=0.5u
X25 a_7225_719.t1 a_7631_719.t1 VSS.t7 rhigh l=1.6u w=0.5u
X26 VSS.t1012 VSS.t1013 VSS.t28 rhigh l=0.96u w=0.5u
X27 VSS.t570 VSS.t568 VSS.t570 VSS.t872 sg13_lv_nmos ad=0.19p pd=1.38u as=0 ps=0 w=1u l=0.13u
X28 VOUT.t2 non_inverting_amplifier_hv_0.ota_hv_slow_gmid_0.vamp.t23 IOVDD.t6 VSS.t205 sg13_hv_nmos ad=0.19p pd=1.38u as=0.19p ps=1.38u w=1u l=1u
X29 VDD.t39 ota_lv_gmid_comparator_0.ota_slow_gmid_ctrl_buff_0.x.t6 a_2285_1463.t5 VSS.t121 sg13_lv_nmos ad=55.85f pd=0.74u as=55.85f ps=0.74u w=0.155u l=0.5u
X30 VSS.t1010 VSS.t1011 VSS.t424 rhigh l=0.96u w=0.5u
X31 VBIAS.t18 two_stage_instrumentation_amplifier_0.ota_slow_gmid_0.en.t3 VDD.t77 VDD.t55 sg13_lv_pmos ad=0.19p pd=1.38u as=0.19p ps=1.38u w=1u l=0.13u
X32 a_17412_7390.t0 a_17412_6864.t0 VSS.t67 rhigh l=0.96u w=0.5u
X33 VSS.t383 VSS.t384 VSS.t141 rppd l=3.69u w=0.5u
X34 VSS.t1039 VSS.t1040 VSS.t167 rhigh l=1.6u w=0.5u
X35 non_inverting_amplifier_hv_0.ota_hv_slow_gmid_0.vamp.t11 non_inverting_amplifier_hv_0.ota_hv_slow_gmid_0.en_n.t3 VSS.t223 VSS.t226 sg13_hv_nmos ad=0.114p pd=0.98u as=0.114p ps=0.98u w=0.6u l=0.45u
X36 two_stage_instrumentation_amplifier_0.vamp1.t61 two_stage_instrumentation_amplifier_0.ota_slow_gmid_1.ota_slow_gmid_buffer_0.ibiasn.t0 VSS.t1002 VSS.t941 sg13_lv_nmos ad=0.1075p pd=1.34u as=0.1075p ps=1.34u w=0.25u l=0.5u
X37 VSS.t1054 VSS.t1055 VSS.t167 rhigh l=1.6u w=0.5u
X38 a_2485_3315.t2 ota_lv_gmid_comparator_0.ota_slow_gmid_mirror_0.vout1.t14 VDD.t53 VDD.t52 sg13_lv_pmos ad=95f pd=0.88u as=0.2p ps=1.8u w=0.5u l=0.5u
X39 VSS.t161 ota_lv_gmid_comparator_0.ota_slow_gmid_ctrl_buff_0.x.t7 a_2485_3315.t1 VDD.t49 sg13_lv_pmos ad=95f pd=0.88u as=95f ps=0.88u w=0.5u l=1u
X40 current_source_1mA_0.ota_med_hv_gmid_0.ota_med_hv_gmid_mirror_0.Iref.t2 current_source_1mA_0.ota_med_hv_gmid_0.ota_med_hv_gmid_mirror_0.Iref.t0 VSS.t439 VSS.t436 sg13_hv_nmos ad=0.646p pd=4.48u as=0.646p ps=4.48u w=1.9u l=2u
X41 VSS.t380 two_stage_instrumentation_amplifier_0.ota_slow_gmid_0.ota_slow_gmid_buffer_0.ibiasn.t0 VAMP.t51 VSS.t323 sg13_lv_nmos ad=0.1075p pd=1.34u as=0.1075p ps=1.34u w=0.25u l=0.5u
X42 VDD.t236 ota_lv_gmid_comparator_0.ota_slow_gmid_ctrl_buff_1.y.t2 ota_lv_gmid_comparator_0.ota_slow_gmid_mirror_0.vout1.t8 VDD.t27 sg13_lv_pmos ad=0.27075p pd=1.805u as=0.27075p ps=1.805u w=1.425u l=0.13u
X43 two_stage_instrumentation_amplifier_0.ota_slow_gmid_1.vout1.t11 two_stage_instrumentation_amplifier_0.ota_slow_gmid_1.en_n.t2 VSS.t179 VSS.t182 sg13_lv_nmos ad=0.408p pd=3.08u as=0.228p ps=1.58u w=1.2u l=0.13u
X44 two_stage_instrumentation_amplifier_0.vamp1.t60 two_stage_instrumentation_amplifier_0.ota_slow_gmid_1.ota_slow_gmid_buffer_0.ibiasn.t0 VSS.t1001 VSS.t945 sg13_lv_nmos ad=0.1075p pd=1.34u as=0.1075p ps=1.34u w=0.25u l=0.5u
X45 VDD.t38 ota_lv_gmid_comparator_0.ota_slow_gmid_ctrl_buff_0.x.t6 a_2285_1463.t4 VSS.t120 sg13_lv_nmos ad=0.10085p pd=1.34u as=55.85f ps=0.74u w=0.155u l=0.5u
X46 VSS.t1000 two_stage_instrumentation_amplifier_0.ota_slow_gmid_1.ota_slow_gmid_buffer_0.ibiasn.t0 two_stage_instrumentation_amplifier_0.vamp1.t59 VSS.t939 sg13_lv_nmos ad=0.1075p pd=1.34u as=0.1075p ps=1.34u w=0.25u l=0.5u
X47 VSS.t16 two_stage_instrumentation_amplifier_0.ota_slow_gmid_1.en_n.t3 two_stage_instrumentation_amplifier_0.ota_slow_gmid_1.vout1.t10 VSS.t23 sg13_lv_nmos ad=0.228p pd=1.58u as=0.228p ps=1.58u w=1.2u l=0.13u
X48 VSS.t871 VSS.t521 VSS.t870 VSS.t544 sg13_lv_nmos ad=0.1075p pd=1.34u as=0 ps=0 w=0.25u l=0.5u
X49 non_inverting_amplifier_hv_0.ota_hv_slow_gmid_0.vamp.t10 non_inverting_amplifier_hv_0.ota_hv_slow_gmid_0.en_n.t4 VSS.t233 VSS.t237 sg13_hv_nmos ad=0.4218p pd=2.6u as=0.4218p ps=2.6u w=2.22u l=0.45u
X50 a_2285_1463.t9 ota_lv_gmid_comparator_0.ota_slow_gmid_ctrl_buff_0.x.t6 VDD.t35 VSS.t119 sg13_lv_nmos ad=55.85f pd=0.74u as=0.10085p ps=1.34u w=0.155u l=0.5u
X51 VSS.t570 VSS.t568 VSS.t570 VSS.t867 sg13_lv_nmos ad=0.19p pd=1.38u as=0 ps=0 w=1u l=0.13u
X52 VDD.t201 VDD.t137 VDD.t201 VDD.t55 sg13_lv_pmos ad=0.475p pd=2.88u as=0 ps=0 w=2.5u l=2u
X53 VSS.t386 VSS.t387 VSS.t385 rppd l=3.69u w=0.5u
X54 IOVDD.t188 IOVDD.t56 IOVDD.t165 IOVDD.t18 sg13_hv_pmos ad=0.34p pd=2.68u as=0 ps=0 w=1u l=0.5u
X55 VSS.t122 VSS.t123 VSS.t28 rhigh l=0.96u w=0.5u
X56 IOVDD.t202 non_inverting_amplifier_hv_0.ota_hv_slow_gmid_0.en.t2 VBIASH.t17 IOVDD.t28 sg13_hv_pmos ad=0.1122p pd=1.34u as=62.69999f ps=0.71u w=0.33u l=0.4u
X57 VSS.t412 VSS.t413 VSS.t247 rhigh l=0.96u w=0.5u
X58 two_stage_instrumentation_amplifier_0.ota_slow_gmid_1.ota_slow_gmid_common_0/ota_slow_gmid_pairs_0.tail.t1 two_stage_instrumentation_amplifier_0.ota_slow_gmid_1.VN.t2 two_stage_instrumentation_amplifier_0.ota_slow_gmid_1.ota_slow_gmid_mirror_0.vref.t1 VDD.t0 sg13_lv_pmos ad=0.475p pd=2.88u as=0.85p ps=5.68u w=2.5u l=5u
X59 ref_selector_0.I1MA.t10 current_source_1mA_0.current_source_1mA_2_stage_0.current_source_pass_element_0.iref.t4 IOVDD.t54 IOVDD.t31 sg13_hv_pmos ad=0.285p pd=1.88u as=0.285p ps=1.88u w=1.5u l=0.5u
X60 a_14214_881.t0 a_14350_881.t0 VSS.t95 rppd l=3.69u w=0.5u
X61 VSS.t866 VSS.t488 VSS.t865 VSS.t554 sg13_lv_nmos ad=0.1075p pd=1.34u as=0 ps=0 w=0.25u l=0.5u
X62 two_stage_instrumentation_amplifier_0.vamp1.t58 two_stage_instrumentation_amplifier_0.ota_slow_gmid_1.ota_slow_gmid_buffer_0.ibiasn.t0 VSS.t999 VSS.t935 sg13_lv_nmos ad=0.1075p pd=1.34u as=0.1075p ps=1.34u w=0.25u l=0.5u
X63 VBIASH.t6 non_inverting_amplifier_hv_0.ota_hv_slow_gmid_0.en.t2 IOVDD.t199 IOVDD.t28 sg13_hv_pmos ad=62.69999f pd=0.71u as=62.69999f ps=0.71u w=0.33u l=0.4u
X64 VSS.t559 VSS.t557 VSS.t559 VSS.t862 sg13_lv_nmos ad=0.19p pd=1.38u as=0 ps=0 w=1u l=0.13u
X65 VSS.t861 VSS.t484 VSS.t860 VSS.t485 sg13_lv_nmos ad=0.17p pd=1.68u as=0 ps=0 w=0.5u l=2u
X66 IOVDD.t96 IOVDD.t67 IOVDD.t96 IOVDD.t28 sg13_hv_pmos ad=0.33915p pd=2.165u as=0 ps=0 w=1.785u l=3u
X67 VAMP.t53 two_stage_instrumentation_amplifier_0.ota_slow_gmid_0.ota_slow_gmid_buffer_0.ibiasn.t0 VSS.t379 VSS.t321 sg13_lv_nmos ad=0.1075p pd=1.34u as=0.1075p ps=1.34u w=0.25u l=0.5u
X68 IOVDD.t90 IOVDD.t89 IOVDD.t90 IOVDD.t18 sg13_hv_pmos ad=0.5586p pd=3.32u as=0 ps=0 w=2.94u l=1u
X69 VSS.t559 VSS.t557 VSS.t559 VSS.t857 sg13_lv_nmos ad=0.19p pd=1.38u as=0 ps=0 w=1u l=0.13u
X70 IOVDD.t74 IOVDD.t73 IOVDD.t74 IOVDD.t25 sg13_hv_pmos ad=0.19p pd=1.38u as=0 ps=0 w=1u l=0.5u
X71 vref.t6 S3.t0 ref_selector_0.ref_selector_r_refs_0.R3.t1 VSS.t923 sg13_lv_nmos ad=1.02p pd=6.68u as=1.02p ps=6.68u w=3u l=0.13u
X72 a_2485_3315.t4 ota_lv_gmid_comparator_0.ota_slow_gmid_mirror_0.vout1.t15 ota_lv_gmid_comparator_0.ota_slow_gmid_ctrl_buff_0.x.t2 VDD.t54 sg13_lv_pmos ad=0.2375p pd=1.63u as=0.2375p ps=1.63u w=1.25u l=0.13u
X73 VBIASH.t17 non_inverting_amplifier_hv_0.ota_hv_slow_gmid_0.en.t2 IOVDD.t198 IOVDD.t28 sg13_hv_pmos ad=62.69999f pd=0.71u as=62.69999f ps=0.71u w=0.33u l=0.4u
X74 VSS.t39 VSS.t40 VSS.t38 rppd l=1.43u w=0.5u
X75 COMPARATOR_RES.t1 ota_lv_gmid_comparator_0.ota_slow_gmid_ctrl_buff_0.ota_slow_gmid_ctrl_inv_0.x.t2 VDD.t28 VDD.t27 sg13_lv_pmos ad=0.68p pd=4.68u as=0.68p ps=4.68u w=2u l=0.13u
X76 a_17952_7916.t1 a_18222_7638.t1 VSS.t46 rhigh l=0.96u w=0.5u
X77 vref.t3 current_source_1mA_0.current_source_1mA_2_stage_0.current_source_pass_element_0.iref.t4 IOVDD.t47 IOVDD.t31 sg13_hv_pmos ad=0.51p pd=3.68u as=0.285p ps=1.88u w=1.5u l=0.5u
X78 non_inverting_amplifier_hv_0.ota_hv_slow_gmid_0.vamp.t8 non_inverting_amplifier_hv_0.ota_hv_slow_gmid_0.en_n.t2 VSS.t218 VSS.t212 sg13_hv_nmos ad=0.4218p pd=2.6u as=0.4218p ps=2.6u w=2.22u l=0.45u
X79 IOVDD.t199 non_inverting_amplifier_hv_0.ota_hv_slow_gmid_0.en.t2 VBIASH.t11 IOVDD.t28 sg13_hv_pmos ad=62.69999f pd=0.71u as=62.69999f ps=0.71u w=0.33u l=0.4u
X80 VDD.t141 VDD.t140 VDD.t141 VDD.t27 sg13_lv_pmos ad=0.475p pd=2.88u as=0 ps=0 w=2.5u l=2u
X81 two_stage_instrumentation_amplifier_0.vamp1.t57 two_stage_instrumentation_amplifier_0.ota_slow_gmid_1.ota_slow_gmid_buffer_0.ibiasn.t0 VSS.t998 VSS.t960 sg13_lv_nmos ad=0.1075p pd=1.34u as=0.1075p ps=1.34u w=0.25u l=0.5u
X82 VDD.t217 VDD.t152 VDD.t114 VDD.t9 sg13_lv_pmos ad=0.85p pd=5.68u as=0 ps=0 w=2.5u l=2u
X83 VSS.t856 VSS.t477 VSS.t855 VSS.t478 sg13_lv_nmos ad=0.17p pd=1.68u as=0 ps=0 w=0.5u l=2u
X84 VSS.t1016 non_inverting_amplifier_hv_0.ota_hv_slow_gmid_0.vref.t2 non_inverting_amplifier_hv_0.ota_hv_slow_gmid_0.vref.t4 VSS.t898 sg13_hv_nmos ad=0.81225p pd=4.655u as=1.4535p ps=9.23u w=4.275u l=10u
X85 a_2285_1463.t7 ota_lv_gmid_comparator_0.ota_slow_gmid_ctrl_buff_0.x.t6 VDD.t32 VSS.t118 sg13_lv_nmos ad=55.85f pd=0.74u as=55.85f ps=0.74u w=0.155u l=0.5u
X86 IOVDD.t179 IOVDD.t61 IOVDD.t46 IOVDD.t31 sg13_hv_pmos ad=0.51p pd=3.68u as=0 ps=0 w=1.5u l=0.5u
X87 VOUT.t1 a_17412_8690.t1 VSS.t67 rhigh l=0.96u w=0.5u
X88 VSS.t997 two_stage_instrumentation_amplifier_0.ota_slow_gmid_1.ota_slow_gmid_buffer_0.ibiasn.t0 two_stage_instrumentation_amplifier_0.vamp1.t56 VSS.t976 sg13_lv_nmos ad=0.1075p pd=1.34u as=0.1075p ps=1.34u w=0.25u l=0.5u
X89 VSS.t99 two_stage_instrumentation_amplifier_0.ota_slow_gmid_1.ota_slow_gmid_mirror_0.vref.t2 two_stage_instrumentation_amplifier_0.ota_slow_gmid_1.vota.t1 VSS.t100 sg13_lv_nmos ad=95f pd=0.88u as=0.17p ps=1.68u w=0.5u l=10u
X90 VSS.t853 VSS.t521 VSS.t852 VSS.t544 sg13_lv_nmos ad=0.1075p pd=1.34u as=0 ps=0 w=0.25u l=0.5u
X91 VSS.t889 ref_selector_0.ref_selector_r_96_0.vcal.t11 VSS.t888 rppd l=1.43u w=0.5u
X92 VDD.t235 ota_lv_gmid_comparator_0.ota_slow_gmid_ctrl_buff_1.y.t2 ota_lv_gmid_comparator_0.ota_slow_gmid_mirror_0.vout1.t7 VDD.t27 sg13_lv_pmos ad=0.27075p pd=1.805u as=0.27075p ps=1.805u w=1.425u l=0.13u
X93 VSS.t400 VSS.t401 VSS.t399 rhigh l=1.6u w=0.5u
X94 a_n9874_2009.t1 two_stage_instrumentation_amplifier_0.ota_slow_gmid_1.VN.t0 VSS.t73 rhigh l=0.96u w=0.5u
X95 VSS.t378 two_stage_instrumentation_amplifier_0.ota_slow_gmid_0.ota_slow_gmid_buffer_0.ibiasn.t0 VAMP.t52 VSS.t307 sg13_lv_nmos ad=0.1075p pd=1.34u as=0.1075p ps=1.34u w=0.25u l=0.5u
X96 a_9187_1799.t0 a_9593_1529.t0 VSS.t86 rhigh l=1.6u w=0.5u
X97 IOVDD.t33 IOVDD.t120 IOVDD.t33 IOVDD.t31 sg13_hv_pmos ad=0.285p pd=1.88u as=0 ps=0 w=1.5u l=0.5u
X98 ref_selector_0.I1MA.t9 current_source_1mA_0.current_source_1mA_2_stage_0.current_source_pass_element_0.iref.t4 IOVDD.t38 IOVDD.t31 sg13_hv_pmos ad=0.285p pd=1.88u as=0.285p ps=1.88u w=1.5u l=0.5u
X99 a_2285_1463.t2 ota_lv_gmid_comparator_0.ota_slow_gmid_ctrl_buff_0.x.t6 VDD.t36 VSS.t117 sg13_lv_nmos ad=55.85f pd=0.74u as=55.85f ps=0.74u w=0.155u l=0.5u
X100 VSS.t87 VSS.t88 VSS.t86 rhigh l=1.6u w=0.5u
X101 VSS.t850 VSS.t488 VSS.t849 VSS.t489 sg13_lv_nmos ad=0.1075p pd=1.34u as=0 ps=0 w=0.25u l=0.5u
X102 a_n14501_5507.t1 a_n14781_4821.t1 VSS.t133 rhigh l=3u w=0.5u
X103 VSS.t377 two_stage_instrumentation_amplifier_0.ota_slow_gmid_0.ota_slow_gmid_buffer_0.ibiasn.t0 VAMP.t54 VSS.t313 sg13_lv_nmos ad=0.1075p pd=1.34u as=0.1075p ps=1.34u w=0.25u l=0.5u
X104 VSS.t847 VSS.t507 VSS.t846 VSS.t508 sg13_lv_nmos ad=0.17p pd=1.68u as=0 ps=0 w=0.5u l=2u
X105 VDD.t214 VDD.t179 VDD.t213 VDD.t54 sg13_lv_pmos ad=0.34p pd=2.68u as=0 ps=0 w=1u l=0.5u
X106 VBIAS.t30 ota_lv_gmid_comparator_0.ota_slow_gmid_ctrl_buff_1.y.t3 VDD.t246 VDD.t108 sg13_lv_pmos ad=0.27075p pd=1.805u as=0.27075p ps=1.805u w=1.425u l=0.13u
X107 VSS.t427 VSS.t428 VSS.t38 rppd l=1.43u w=0.5u
X108 ref_selector_0.ref_selector_r_96_0.vcal.t5 VSS.t410 VSS.t156 rppd l=1.43u w=0.5u
X109 VDD.t211 VDD.t110 VDD.t210 VDD.t54 sg13_lv_pmos ad=0.34p pd=2.68u as=0 ps=0 w=1u l=0.5u
X110 VSS.t549 VSS.t547 VSS.t549 VSS.t843 sg13_lv_nmos ad=0.19p pd=1.38u as=0 ps=0 w=1u l=0.13u
X111 VAMP.t55 two_stage_instrumentation_amplifier_0.ota_slow_gmid_0.ota_slow_gmid_buffer_0.ibiasn.t0 VSS.t376 VSS.t321 sg13_lv_nmos ad=0.1075p pd=1.34u as=0.1075p ps=1.34u w=0.25u l=0.5u
X112 IOVDD.t218 VBIASH.t18 current_source_1mA_0.ota_med_hv_gmid_0.ota_med_hv_gmid_tail_0.tail.t3 IOVDD.t0 sg13_hv_pmos ad=0.19p pd=1.38u as=0.34p ps=2.68u w=1u l=0.5u
X113 a_7225_1529.t0 a_7631_1529.t1 VSS.t6 rhigh l=1.6u w=0.5u
X114 VBIAS.t1 two_stage_instrumentation_amplifier_0.ota_slow_gmid_1.en.t2 VDD.t13 VDD.t16 sg13_lv_pmos ad=0.19p pd=1.38u as=0.19p ps=1.38u w=1u l=0.13u
X115 a_17412_6864.t1 a_17412_6586.t1 VSS.t67 rhigh l=0.96u w=0.5u
X116 two_stage_instrumentation_amplifier_0.ota_slow_gmid_0.vout1.t4 two_stage_instrumentation_amplifier_0.ota_slow_gmid_0.vota.t4 VSS.t414 VSS.t300 sg13_lv_nmos ad=0.17p pd=1.68u as=95f ps=0.88u w=0.5u l=10u
X117 a_7225_1259.t0 a_7631_989.t1 VSS.t7 rhigh l=1.6u w=0.5u
X118 two_stage_instrumentation_amplifier_0.ota_slow_gmid_1.ota_slow_gmid_buffer_0.ibiasn.t4 two_stage_instrumentation_amplifier_0.ota_slow_gmid_1.ota_slow_gmid_buffer_0.ibiasn.t0 VSS.t996 VSS.t945 sg13_lv_nmos ad=0.1075p pd=1.34u as=0.1075p ps=1.34u w=0.25u l=0.5u
X119 a_n14501_5507.t0 a_n13602_4249.t0 VSS.t41 rhigh l=2.5u w=0.5u
X120 current_source_1mA_0.current_source_1mA_2_stage_0.current_source_pass_element_0.iref.t10 current_source_1mA_0.current_source_1mA_2_stage_0.current_source_pass_element_0.vota.t6 current_source_1mA_0.current_source_1mA_2_stage_0.vcp.t0 VSS.t1071 sg13_hv_nmos ad=0.1425p pd=1.13u as=0.1425p ps=1.13u w=0.75u l=0.5u
X121 IOVDD.t65 IOVDD.t64 IOVDD.t65 IOVDD.t16 sg13_hv_pmos ad=0.19p pd=1.38u as=0 ps=0 w=1u l=0.5u
X122 two_stage_instrumentation_amplifier_0.ota_slow_gmid_0.vout1.t7 two_stage_instrumentation_amplifier_0.ota_slow_gmid_0.en_n.t2 VSS.t263 VSS.t276 sg13_lv_nmos ad=0.228p pd=1.58u as=0.228p ps=1.58u w=1.2u l=0.13u
X123 a_n9874_4085.t1 a_n9874_3431.t1 VSS.t73 rhigh l=1.6u w=0.5u
X124 VBIAS.t0 two_stage_instrumentation_amplifier_0.ota_slow_gmid_1.en.t2 VDD.t12 VDD.t11 sg13_lv_pmos ad=0.19p pd=1.38u as=0.19p ps=1.38u w=1u l=0.13u
X125 VDD.t19 two_stage_instrumentation_amplifier_0.ota_slow_gmid_1.en.t3 VBIAS.t9 VDD.t0 sg13_lv_pmos ad=0.19p pd=1.38u as=0.19p ps=1.38u w=1u l=0.13u
X126 VSS.t10 two_stage_instrumentation_amplifier_0.ota_slow_gmid_1.en_n.t3 two_stage_instrumentation_amplifier_0.ota_slow_gmid_1.vout1.t9 VSS.t22 sg13_lv_nmos ad=0.228p pd=1.58u as=0.228p ps=1.58u w=1.2u l=0.13u
X127 VDD.t253 ota_lv_gmid_comparator_0.ota_slow_gmid_ctrl_buff_1.y.t3 VBIAS.t25 VDD.t108 sg13_lv_pmos ad=0.4845p pd=3.53u as=0.27075p ps=1.805u w=1.425u l=0.13u
X128 VBIAS.t11 two_stage_instrumentation_amplifier_0.ota_slow_gmid_1.en.t3 VDD.t21 VDD.t0 sg13_lv_pmos ad=0.34p pd=2.68u as=0.19p ps=1.38u w=1u l=0.13u
X129 ota_lv_gmid_comparator_0.ota_slow_gmid_mirror_0.vout1.t12 ota_lv_gmid_comparator_0.ota_slow_gmid_ctrl_buff_1.y.t2 VDD.t232 VDD.t27 sg13_lv_pmos ad=0.27075p pd=1.805u as=0.27075p ps=1.805u w=1.425u l=0.13u
X130 ref_selector_0.I1MA.t8 current_source_1mA_0.current_source_1mA_2_stage_0.current_source_pass_element_0.iref.t4 IOVDD.t51 IOVDD.t31 sg13_hv_pmos ad=0.285p pd=1.88u as=0.285p ps=1.88u w=1.5u l=0.5u
X131 IOVDD.t172 IOVDD.t59 IOVDD.t60 IOVDD.t3 sg13_hv_pmos ad=0.34p pd=2.68u as=0 ps=0 w=1u l=0.5u
X132 VSS.t995 two_stage_instrumentation_amplifier_0.ota_slow_gmid_1.ota_slow_gmid_buffer_0.ibiasn.t0 two_stage_instrumentation_amplifier_0.vamp1.t55 VSS.t943 sg13_lv_nmos ad=0.1075p pd=1.34u as=0.1075p ps=1.34u w=0.25u l=0.5u
X133 VSS.t842 VSS.t521 VSS.t841 VSS.t522 sg13_lv_nmos ad=0.1075p pd=1.34u as=0 ps=0 w=0.25u l=0.5u
X134 current_source_1mA_0.current_source_1mA_2_stage_0.current_source_pass_element_0.iref.t9 current_source_1mA_0.current_source_1mA_2_stage_0.current_source_pass_element_0.vota.t6 current_source_1mA_0.current_source_1mA_2_stage_0.vcp.t5 VSS.t1070 sg13_hv_nmos ad=0.1425p pd=1.13u as=0.1425p ps=1.13u w=0.75u l=0.5u
X135 a_7879_1529.t0 ref_selector_0.VMIN.t4 VSS.t251 rhigh l=1.6u w=0.5u
X136 VDD.t86 VBIAS.t32 two_stage_instrumentation_amplifier_0.ota_slow_gmid_1.ota_slow_gmid_common_0/ota_slow_gmid_pairs_0.tail.t3 VDD.t0 sg13_lv_pmos ad=0.19p pd=1.38u as=0.34p ps=2.68u w=1u l=0.5u
X137 current_source_1mA_0.current_source_1mA_2_stage_0.vcp.t1 current_source_1mA_0.current_source_1mA_2_stage_0.current_source_pass_element_0.vota.t6 current_source_1mA_0.current_source_1mA_2_stage_0.current_source_pass_element_0.iref.t7 VSS.t1069 sg13_hv_nmos ad=0.1425p pd=1.13u as=0.1425p ps=1.13u w=0.75u l=0.5u
X138 a_9187_2339.t0 a_9593_2609.t1 VSS.t86 rhigh l=1.6u w=0.5u
X139 VSS.t839 VSS.t496 VSS.t838 VSS.t511 sg13_lv_nmos ad=0.1075p pd=1.34u as=0 ps=0 w=0.25u l=0.5u
X140 VDD.t250 ota_lv_gmid_comparator_0.ota_slow_gmid_ctrl_buff_1.y.t3 VBIAS.t31 VDD.t108 sg13_lv_pmos ad=0.27075p pd=1.805u as=0.4845p ps=3.53u w=1.425u l=0.13u
X141 ref_selector_0.VMIN.t2 VSS.t157 VSS.t156 rppd l=1.43u w=0.5u
X142 VSS.t408 VSS.t409 VSS.t70 rppd l=1.43u w=0.5u
X143 a_7879_1259.t0 a_8285_989.t0 VSS.t31 rhigh l=1.6u w=0.5u
X144 a_9187_2339.t1 a_9593_2069.t1 VSS.t86 rhigh l=1.6u w=0.5u
X145 a_834_5436.t0 VDD.t104 VSS.t894 rhigh l=2.5u w=0.5u
X146 ota_lv_gmid_comparator_0.ota_slow_gmid_common_0/ota_slow_gmid_pairs_0.tail.t3 VBIAS.t33 VDD.t92 VDD.t54 sg13_lv_pmos ad=0.34p pd=2.68u as=0.19p ps=1.38u w=1u l=0.5u
X147 VSS.t375 two_stage_instrumentation_amplifier_0.ota_slow_gmid_0.ota_slow_gmid_buffer_0.ibiasn.t0 VAMP.t56 VSS.t330 sg13_lv_nmos ad=0.1075p pd=1.34u as=0.1075p ps=1.34u w=0.25u l=0.5u
X148 a_17952_7390.t0 a_18222_7112.t0 VSS.t46 rhigh l=0.96u w=0.5u
X149 ref_selector_0.I1MA.t12 current_source_1mA_0.current_source_1mA_2_stage_0.current_source_pass_element_0.iref.t4 IOVDD.t43 IOVDD.t31 sg13_hv_pmos ad=0.51p pd=3.68u as=0.285p ps=1.88u w=1.5u l=0.5u
X150 VSS.t836 VSS.t517 VSS.t835 VSS.t834 sg13_hv_nmos ad=1.4535p pd=9.23u as=0 ps=0 w=4.275u l=4u
X151 two_stage_instrumentation_amplifier_0.ota_slow_gmid_0.vout1.t10 two_stage_instrumentation_amplifier_0.ota_slow_gmid_0.en_n.t2 VSS.t273 VSS.t275 sg13_lv_nmos ad=0.408p pd=3.08u as=0.228p ps=1.58u w=1.2u l=0.13u
X152 VSS.t833 VSS.t492 VSS.t832 VSS.t493 sg13_lv_nmos ad=0.1075p pd=1.34u as=0 ps=0 w=0.25u l=0.5u
X153 non_inverting_amplifier_hv_0.ota_hv_slow_gmid_0.vref.t3 non_inverting_amplifier_hv_0.ota_hv_slow_gmid_0.vref.t2 VSS.t1014 VSS.t900 sg13_hv_nmos ad=1.4535p pd=9.23u as=0.81225p ps=4.655u w=4.275u l=10u
X154 a_9187_1799.t1 a_9593_2069.t0 VSS.t86 rhigh l=1.6u w=0.5u
X155 VAMP.t57 two_stage_instrumentation_amplifier_0.ota_slow_gmid_0.ota_slow_gmid_buffer_0.ibiasn.t0 VSS.t374 VSS.t327 sg13_lv_nmos ad=0.1075p pd=1.34u as=0.1075p ps=1.34u w=0.25u l=0.5u
X156 two_stage_instrumentation_amplifier_0.ota_slow_gmid_0.ota_slow_gmid_buffer_0.ibiasn.t4 two_stage_instrumentation_amplifier_0.ota_slow_gmid_0.ota_slow_gmid_buffer_0.ibiasn.t0 VSS.t373 VSS.t316 sg13_lv_nmos ad=0.1075p pd=1.34u as=0.1075p ps=1.34u w=0.25u l=0.5u
X157 a_n9334_4739.t0 a_n9064_4085.t1 VSS.t903 rhigh l=1.6u w=0.5u
X158 VBIASH.t16 non_inverting_amplifier_hv_0.ota_hv_slow_gmid_0.en.t3 IOVDD.t210 IOVDD.t3 sg13_hv_pmos ad=0.1122p pd=1.34u as=62.69999f ps=0.71u w=0.33u l=0.4u
X159 a_n9874_3431.t0 a_n9874_3025.t1 VSS.t73 rhigh l=1.6u w=0.5u
X160 current_source_1mA_0.current_source_1mA_2_stage_0.current_source_pass_element_0.vota.t7 current_source_1mA_0.ota_med_hv_gmid_0.ota_med_hv_gmid_mirror_0.vota.t3 cap_cmim l=26u w=20u
X161 ota_lv_gmid_comparator_0.ota_slow_gmid_ctrl_buff_0.x.t1 ota_lv_gmid_comparator_0.ota_slow_gmid_mirror_0.vout1.t15 a_2485_3315.t3 VDD.t54 sg13_lv_pmos ad=0.425p pd=3.18u as=0.2375p ps=1.63u w=1.25u l=0.13u
X162 IOVDD.t217 VBIASH.t18 current_source_1mA_0.current_source_1mA_2_stage_0.current_source_pass_element_0.vota.t1 IOVDD.t0 sg13_hv_pmos ad=0.19p pd=1.38u as=0.34p ps=2.68u w=1u l=0.5u
X163 VSS.t830 VSS.t711 VSS.t829 VSS.t712 sg13_lv_nmos ad=0.17p pd=1.68u as=0 ps=0 w=0.5u l=2u
X164 VDD.t43 VDD.t44 VSS.t147 rhigh l=3u w=0.5u
X165 VDD.t56 two_stage_instrumentation_amplifier_0.ota_slow_gmid_0.en_n.t3 two_stage_instrumentation_amplifier_0.ota_slow_gmid_0.en.t1 VDD.t55 sg13_lv_pmos ad=0.68p pd=4.68u as=0.68p ps=4.68u w=2u l=0.13u
X166 IOVDD.t13 top_conditionning_level_shifter_0.EN_HV.t2 current_source_1mA_0.current_source_1mA_2_stage_0.current_source_pass_element_0.iref.t3 IOVDD.t0 sg13_hv_pmos ad=0.38p pd=2.38u as=0.38p ps=2.38u w=2u l=0.4u
X167 VSS.t51 VSS.t52 VSS.t50 rppd l=1.43u w=0.5u
X168 IOVDD.t57 IOVDD.t56 IOVDD.t57 IOVDD.t18 sg13_hv_pmos ad=0.19p pd=1.38u as=0 ps=0 w=1u l=0.5u
X169 VSS.t827 VSS.t484 VSS.t826 VSS.t485 sg13_lv_nmos ad=0.17p pd=1.68u as=0 ps=0 w=0.5u l=2u
X170 VAMP.t39 two_stage_instrumentation_amplifier_0.ota_slow_gmid_0.ota_slow_gmid_buffer_0.ibiasn.t0 VSS.t372 VSS.t327 sg13_lv_nmos ad=0.1075p pd=1.34u as=0.1075p ps=1.34u w=0.25u l=0.5u
X171 IOVDD.t6 non_inverting_amplifier_hv_0.ota_hv_slow_gmid_0.vamp.t23 VOUT.t6 VSS.t204 sg13_hv_nmos ad=0.19p pd=1.38u as=0.19p ps=1.38u w=1u l=1u
X172 two_stage_instrumentation_amplifier_0.ota_slow_gmid_1.ota_slow_gmid_common_0/ota_slow_gmid_pairs_0.tail.t2 VBIAS.t32 VDD.t88 VDD.t0 sg13_lv_pmos ad=0.34p pd=2.68u as=0.19p ps=1.38u w=1u l=0.5u
X173 VSS.t158 VSS.t159 VSS.t28 rhigh l=0.96u w=0.5u
X174 current_source_1mA_0.current_source_1mA_2_stage_0.current_source_pass_element_0.iref.t0 top_conditionning_level_shifter_0.EN_HV.t2 IOVDD.t21 IOVDD.t26 sg13_hv_pmos ad=0.38p pd=2.38u as=0.38p ps=2.38u w=2u l=0.4u
X175 IOVDD.t49 current_source_1mA_0.current_source_1mA_2_stage_0.current_source_pass_element_0.iref.t4 ref_selector_0.I1MA.t11 IOVDD.t31 sg13_hv_pmos ad=0.285p pd=1.88u as=0.285p ps=1.88u w=1.5u l=0.5u
X176 two_stage_instrumentation_amplifier_0.ota_slow_gmid_1.en.t1 two_stage_instrumentation_amplifier_0.ota_slow_gmid_1.en_n.t4 VDD.t1 VDD.t0 sg13_lv_pmos ad=0.68p pd=4.68u as=0.68p ps=4.68u w=2u l=0.13u
X177 VSS.t824 VSS.t623 VSS.t823 VSS.t624 sg13_hv_nmos ad=0.646p pd=4.48u as=0 ps=0 w=1.9u l=2u
X178 IOVDD.t167 IOVDD.t64 IOVDD.t167 IOVDD.t16 sg13_hv_pmos ad=0.19p pd=1.38u as=0 ps=0 w=1u l=0.5u
X179 IOVDD.t210 non_inverting_amplifier_hv_0.ota_hv_slow_gmid_0.en.t3 VBIASH.t12 IOVDD.t3 sg13_hv_pmos ad=62.69999f pd=0.71u as=62.69999f ps=0.71u w=0.33u l=0.4u
X180 VSS.t994 two_stage_instrumentation_amplifier_0.ota_slow_gmid_1.ota_slow_gmid_buffer_0.ibiasn.t0 two_stage_instrumentation_amplifier_0.vamp1.t54 VSS.t929 sg13_lv_nmos ad=0.1075p pd=1.34u as=0.1075p ps=1.34u w=0.25u l=0.5u
X181 VOUT.t7 non_inverting_amplifier_hv_0.ota_hv_slow_gmid_0.vamp.t23 IOVDD.t5 VSS.t203 sg13_hv_nmos ad=0.34p pd=2.68u as=0.19p ps=1.38u w=1u l=1u
X182 VSS.t414 two_stage_instrumentation_amplifier_0.ota_slow_gmid_0.vota.t4 two_stage_instrumentation_amplifier_0.ota_slow_gmid_0.vout1.t3 VSS.t303 sg13_lv_nmos ad=95f pd=0.88u as=0.17p ps=1.68u w=0.5u l=10u
X183 two_stage_instrumentation_amplifier_0.vamp1.t53 two_stage_instrumentation_amplifier_0.ota_slow_gmid_1.ota_slow_gmid_buffer_0.ibiasn.t0 VSS.t993 VSS.t927 sg13_lv_nmos ad=0.1075p pd=1.34u as=0.1075p ps=1.34u w=0.25u l=0.5u
X184 non_inverting_amplifier_hv_0.ota_hv_slow_gmid_0.vamp.t15 non_inverting_amplifier_hv_0.ota_hv_slow_gmid_0.en_n.t5 VSS.t225 VSS.t238 sg13_hv_nmos ad=0.204p pd=1.88u as=0.114p ps=0.98u w=0.6u l=0.45u
X185 VSS.t299 non_inverting_amplifier_hv_0.ota_hv_slow_gmid_0.ibiasn.t3 VOUT.t0 VSS.t201 sg13_hv_nmos ad=0.19p pd=1.38u as=0.19p ps=1.38u w=1u l=1u
X186 VSS.t71 VSS.t72 VSS.t70 rppd l=1.43u w=0.5u
X187 two_stage_instrumentation_amplifier_0.ota_slow_gmid_0.vout1.t16 two_stage_instrumentation_amplifier_0.ota_slow_gmid_0.en_n.t4 VSS.t284 VSS.t293 sg13_lv_nmos ad=0.408p pd=3.08u as=0.228p ps=1.58u w=1.2u l=0.13u
X188 VSS.t821 VSS.t496 VSS.t820 VSS.t514 sg13_lv_nmos ad=0.1075p pd=1.34u as=0 ps=0 w=0.25u l=0.5u
X189 vref.t0 S0.t0 ref_selector_0.ref_selector_r_refs_0.R0.t0 VSS.t34 sg13_lv_nmos ad=1.02p pd=6.68u as=1.02p ps=6.68u w=3u l=0.13u
X190 VBIASH.t4 non_inverting_amplifier_hv_0.ota_hv_slow_gmid_0.en.t3 IOVDD.t207 IOVDD.t3 sg13_hv_pmos ad=62.69999f pd=0.71u as=62.69999f ps=0.71u w=0.33u l=0.4u
X191 VSS.t818 VSS.t496 VSS.t817 VSS.t511 sg13_lv_nmos ad=0.1075p pd=1.34u as=0 ps=0 w=0.25u l=0.5u
X192 VSS.t815 VSS.t477 VSS.t814 VSS.t478 sg13_lv_nmos ad=0.17p pd=1.68u as=0 ps=0 w=0.5u l=2u
X193 non_inverting_amplifier_hv_0.ota_hv_slow_gmid_0.en.t1 non_inverting_amplifier_hv_0.ota_hv_slow_gmid_0.en_n.t6 VSS.t240 VSS.t239 sg13_hv_nmos ad=0.408p pd=3.08u as=0.408p ps=3.08u w=1.2u l=0.45u
X194 a_18762_7916.t1 a_19032_7638.t1 VSS.t5 rhigh l=0.96u w=0.5u
X195 VSS.t98 two_stage_instrumentation_amplifier_0.ota_slow_gmid_1.ota_slow_gmid_mirror_0.vref.t2 two_stage_instrumentation_amplifier_0.ota_slow_gmid_1.ota_slow_gmid_mirror_0.vref.t4 VSS.t100 sg13_lv_nmos ad=95f pd=0.88u as=0.17p ps=1.68u w=0.5u l=10u
X196 a_2285_1463.t11 ota_lv_gmid_comparator_0.ota_slow_gmid_mirror_0.vout1.t15 ota_lv_gmid_comparator_0.ota_slow_gmid_ctrl_buff_0.x.t5 VSS.t257 sg13_lv_nmos ad=0.38p pd=2.38u as=0.38p ps=2.38u w=2u l=0.13u
X197 VSS.t812 VSS.t492 VSS.t811 VSS.t640 sg13_lv_nmos ad=0.1075p pd=1.34u as=0 ps=0 w=0.25u l=0.5u
X198 VAMP.t40 two_stage_instrumentation_amplifier_0.ota_slow_gmid_0.ota_slow_gmid_buffer_0.ibiasn.t0 VSS.t371 VSS.t316 sg13_lv_nmos ad=0.1075p pd=1.34u as=0.1075p ps=1.34u w=0.25u l=0.5u
X199 VDD.t208 VDD.t140 VDD.t156 VDD.t27 sg13_lv_pmos ad=0.85p pd=5.68u as=0 ps=0 w=2.5u l=2u
X200 two_stage_instrumentation_amplifier_0.ota_slow_gmid_0.vota.t2 two_stage_instrumentation_amplifier_0.ota_slow_gmid_0.ota_slow_gmid_mirror_0.vref.t2 VSS.t302 VSS.t300 sg13_lv_nmos ad=0.17p pd=1.68u as=95f ps=0.88u w=0.5u l=10u
X201 VAMP.t42 two_stage_instrumentation_amplifier_0.ota_slow_gmid_0.ota_slow_gmid_buffer_0.ibiasn.t0 VSS.t370 VSS.t311 sg13_lv_nmos ad=0.1075p pd=1.34u as=0.1075p ps=1.34u w=0.25u l=0.5u
X202 non_inverting_amplifier_hv_0.top_conditionning_gain_s3_0.vn3.t1 rmod.t1 VSS.t891 rhigh l=1.23u w=0.5u
X203 a_18222_8968.t0 a_17952_8690.t0 VSS.t46 rhigh l=0.96u w=0.5u
X204 VDD.t10 two_stage_instrumentation_amplifier_0.ota_slow_gmid_1.en.t2 VBIAS.t5 VDD.t14 sg13_lv_pmos ad=0.19p pd=1.38u as=0.34p ps=2.68u w=1u l=0.13u
X205 ref_selector_0.I1MA.t7 current_source_1mA_0.current_source_1mA_2_stage_0.current_source_pass_element_0.iref.t4 IOVDD.t37 IOVDD.t31 sg13_hv_pmos ad=0.285p pd=1.88u as=0.285p ps=1.88u w=1.5u l=0.5u
X206 VSS.t160 ota_lv_gmid_comparator_0.ota_slow_gmid_ctrl_buff_0.x.t7 a_2485_3315.t2 VDD.t42 sg13_lv_pmos ad=95f pd=0.88u as=95f ps=0.88u w=0.5u l=1u
X207 non_inverting_amplifier_hv_0.ota_hv_slow_gmid_0.en_n.t1 top_conditionning_level_shifter_0.EN_HV.t3 VSS.t210 VSS.t209 sg13_hv_nmos ad=0.408p pd=3.08u as=0.408p ps=3.08u w=1.2u l=0.45u
X208 VDD.t205 VDD.t164 VDD.t204 VDD.t0 sg13_lv_pmos ad=0.34p pd=2.68u as=0 ps=0 w=1u l=0.5u
X209 VSS.t809 VSS.t696 VSS.t808 VSS.t697 sg13_lv_nmos ad=0.17p pd=1.68u as=0 ps=0 w=0.5u l=2u
X210 VDD.t18 two_stage_instrumentation_amplifier_0.ota_slow_gmid_1.en.t3 VBIAS.t10 VDD.t0 sg13_lv_pmos ad=0.19p pd=1.38u as=0.34p ps=2.68u w=1u l=0.13u
X211 VSS.t154 VSS.t155 VSS.t153 rhigh l=0.96u w=0.5u
X212 non_inverting_amplifier_hv_0.ota_hv_slow_gmid_0.vamp.t13 non_inverting_amplifier_hv_0.ota_hv_slow_gmid_0.en_n.t4 VSS.t236 VSS.t235 sg13_hv_nmos ad=0.4218p pd=2.6u as=0.7548p ps=5.12u w=2.22u l=0.45u
X213 IOVDD.t165 IOVDD.t56 IOVDD.t165 IOVDD.t18 sg13_hv_pmos ad=0.19p pd=1.38u as=0 ps=0 w=1u l=0.5u
X214 IOVDD.t163 IOVDD.t135 IOVDD.t143 IOVDD.t154 sg13_hv_pmos ad=0.34p pd=2.68u as=0 ps=0 w=1u l=0.5u
X215 IOVDD.t47 current_source_1mA_0.current_source_1mA_2_stage_0.current_source_pass_element_0.iref.t4 ref_selector_0.I1MA.t10 IOVDD.t31 sg13_hv_pmos ad=0.285p pd=1.88u as=0.285p ps=1.88u w=1.5u l=0.5u
X216 two_stage_instrumentation_amplifier_0.vamp1.t52 two_stage_instrumentation_amplifier_0.ota_slow_gmid_1.ota_slow_gmid_buffer_0.ibiasn.t0 VSS.t992 VSS.t951 sg13_lv_nmos ad=0.1075p pd=1.34u as=0.1075p ps=1.34u w=0.25u l=0.5u
X217 non_inverting_amplifier_hv_0.ota_hv_slow_gmid_0.ota_hv_slow_gmid_tail_0.tail.t1 VAMP.t63 non_inverting_amplifier_hv_0.ota_hv_slow_gmid_0.vota.t0 IOVDD.t3 sg13_hv_pmos ad=0.33915p pd=2.165u as=0.6069p ps=4.25u w=1.785u l=3u
X218 VSS.t43 VSS.t44 VSS.t42 rppd l=1.43u w=0.5u
X219 VSS.t1014 non_inverting_amplifier_hv_0.ota_hv_slow_gmid_0.vref.t2 non_inverting_amplifier_hv_0.ota_hv_slow_gmid_0.vota.t3 VSS.t898 sg13_hv_nmos ad=0.81225p pd=4.655u as=1.4535p ps=9.23u w=4.275u l=10u
X220 non_inverting_amplifier_hv_0.ota_hv_slow_gmid_0.vamp.t14 non_inverting_amplifier_hv_0.ota_hv_slow_gmid_0.en_n.t7 VSS.t242 VSS.t241 sg13_hv_nmos ad=0.204p pd=1.88u as=0.114p ps=0.98u w=0.6u l=0.45u
X221 VSS.t806 VSS.t496 VSS.t805 VSS.t514 sg13_lv_nmos ad=0.1075p pd=1.34u as=0 ps=0 w=0.25u l=0.5u
X222 VBIAS.t12 two_stage_instrumentation_amplifier_0.ota_slow_gmid_0.en.t2 VDD.t67 VDD.t66 sg13_lv_pmos ad=0.19p pd=1.38u as=0.19p ps=1.38u w=1u l=0.13u
X223 a_18222_6864.t1 a_17952_6586.t0 VSS.t46 rhigh l=0.96u w=0.5u
X224 VDD.t202 VDD.t137 VDD.t201 VDD.t55 sg13_lv_pmos ad=0.85p pd=5.68u as=0 ps=0 w=2.5u l=2u
X225 two_stage_instrumentation_amplifier_0.ota_slow_gmid_0.vout1.t5 two_stage_instrumentation_amplifier_0.ota_slow_gmid_0.en_n.t2 VSS.t271 VSS.t274 sg13_lv_nmos ad=0.228p pd=1.58u as=0.228p ps=1.58u w=1.2u l=0.13u
X226 a_17412_8442.t0 a_17412_8164.t0 VSS.t67 rhigh l=0.96u w=0.5u
X227 VDD.t199 VDD.t110 VDD.t198 VDD.t54 sg13_lv_pmos ad=0.34p pd=2.68u as=0 ps=0 w=1u l=0.5u
X228 current_source_1mA_0.current_source_1mA_2_stage_0.current_source_pass_element_0.vota.t5 current_source_1mA_0.ota_med_hv_gmid_0.ota_med_hv_gmid_mirror_0.vota.t5 VSS.t404 VSS.t402 sg13_hv_nmos ad=0.646p pd=4.48u as=0.646p ps=4.48u w=1.9u l=2u
X229 VSS.t991 two_stage_instrumentation_amplifier_0.ota_slow_gmid_1.ota_slow_gmid_buffer_0.ibiasn.t0 two_stage_instrumentation_amplifier_0.vamp1.t51 VSS.t932 sg13_lv_nmos ad=0.1075p pd=1.34u as=0.1075p ps=1.34u w=0.25u l=0.5u
X230 ref_selector_0.I1MA.t6 current_source_1mA_0.current_source_1mA_2_stage_0.current_source_pass_element_0.iref.t4 IOVDD.t46 IOVDD.t31 sg13_hv_pmos ad=0.285p pd=1.88u as=0.285p ps=1.88u w=1.5u l=0.5u
X231 two_stage_instrumentation_amplifier_0.ota_slow_gmid_0.vout1.t13 two_stage_instrumentation_amplifier_0.ota_slow_gmid_0.en_n.t4 VSS.t290 VSS.t292 sg13_lv_nmos ad=0.228p pd=1.58u as=0.228p ps=1.58u w=1.2u l=0.13u
X232 VAMP.t43 two_stage_instrumentation_amplifier_0.ota_slow_gmid_0.ota_slow_gmid_buffer_0.ibiasn.t0 VSS.t369 VSS.t311 sg13_lv_nmos ad=0.1075p pd=1.34u as=0.1075p ps=1.34u w=0.25u l=0.5u
X233 VSS.t368 two_stage_instrumentation_amplifier_0.ota_slow_gmid_0.ota_slow_gmid_buffer_0.ibiasn.t0 VAMP.t45 VSS.t309 sg13_lv_nmos ad=0.1075p pd=1.34u as=0.1075p ps=1.34u w=0.25u l=0.5u
X234 VSS.t280 two_stage_instrumentation_amplifier_0.ota_slow_gmid_0.en_n.t4 two_stage_instrumentation_amplifier_0.ota_slow_gmid_0.vout1.t15 VSS.t291 sg13_lv_nmos ad=0.228p pd=1.58u as=0.228p ps=1.58u w=1.2u l=0.13u
X235 IOVDD.t68 IOVDD.t67 IOVDD.t68 IOVDD.t28 sg13_hv_pmos ad=0.33915p pd=2.165u as=0 ps=0 w=1.785u l=3u
X236 VSS.t1051 VSS.t1052 VSS.t405 rppd l=3.69u w=0.5u
X237 VSS.t1074 ref_selector_0.ref_selector_r_96_0.vcal.t10 cap_cmim l=20u w=10u
X238 a_n16824_5507.t0 a_n14781_4821.t0 VSS.t8 rhigh l=3u w=0.5u
X239 VSS.t803 VSS.t484 VSS.t802 VSS.t485 sg13_lv_nmos ad=0.17p pd=1.68u as=0 ps=0 w=0.5u l=2u
X240 VSS.t800 VSS.t711 VSS.t799 VSS.t712 sg13_lv_nmos ad=0.17p pd=1.68u as=0 ps=0 w=0.5u l=2u
X241 two_stage_instrumentation_amplifier_0.ota_slow_gmid_1.vout1.t15 two_stage_instrumentation_amplifier_0.ota_slow_gmid_1.vota.t4 VSS.t883 VSS.t97 sg13_lv_nmos ad=0.17p pd=1.68u as=95f ps=0.88u w=0.5u l=10u
X242 IOVDD.t45 current_source_1mA_0.current_source_1mA_2_stage_0.current_source_pass_element_0.iref.t4 ref_selector_0.I1MA.t9 IOVDD.t31 sg13_hv_pmos ad=0.285p pd=1.88u as=0.285p ps=1.88u w=1.5u l=0.5u
X243 VBIASH.t15 non_inverting_amplifier_hv_0.ota_hv_slow_gmid_0.en.t4 IOVDD.t212 IOVDD.t28 sg13_hv_pmos ad=0.255p pd=2.18u as=0.1425p ps=1.13u w=0.75u l=0.4u
X244 current_source_1mA_0.current_source_1mA_2_stage_0.current_source_pass_element_0.iref.t6 current_source_1mA_0.current_source_1mA_2_stage_0.current_source_pass_element_0.iref.t4 IOVDD.t41 IOVDD.t31 sg13_hv_pmos ad=0.51p pd=3.68u as=0.285p ps=1.88u w=1.5u l=0.5u
X245 VSS.t797 VSS.t686 VSS.t796 VSS.t687 sg13_lv_nmos ad=0.17p pd=1.68u as=0 ps=0 w=0.5u l=2u
X246 VSS.t794 VSS.t488 VSS.t793 VSS.t489 sg13_lv_nmos ad=0.1075p pd=1.34u as=0 ps=0 w=0.25u l=0.5u
X247 a_18492_7638.t1 rmod.t0 VSS.t5 rhigh l=0.96u w=0.5u
X248 VSS.t392 VSS.t393 VSS.t42 rppd l=1.43u w=0.5u
X249 ref_selector_0.VMIN.t18 VSS.t1053 VSS.t443 rppd l=1.43u w=0.5u
X250 VSS.t302 two_stage_instrumentation_amplifier_0.ota_slow_gmid_0.ota_slow_gmid_mirror_0.vref.t4 two_stage_instrumentation_amplifier_0.ota_slow_gmid_0.ota_slow_gmid_mirror_0.vref.t5 VSS.t303 sg13_lv_nmos ad=95f pd=0.88u as=0.17p ps=1.68u w=0.5u l=10u
X251 ota_lv_gmid_comparator_0.ota_slow_gmid_ctrl_buff_1.ota_slow_gmid_ctrl_inv_0.x.t0 EN.t0 VSS.t1024 VSS.t1023 sg13_lv_nmos ad=0.68p pd=4.68u as=0.68p ps=4.68u w=2u l=0.13u
X252 IOVDD.t140 IOVDD.t59 IOVDD.t140 IOVDD.t3 sg13_hv_pmos ad=0.19p pd=1.38u as=0 ps=0 w=1u l=0.5u
X253 ota_lv_gmid_comparator_0.ota_slow_gmid_common_0/ota_slow_gmid_pairs_0.tail.t1 VAMP.t64 ota_lv_gmid_comparator_0.ota_slow_gmid_mirror_0.vota.t1 VDD.t42 sg13_lv_pmos ad=0.475p pd=2.88u as=0.85p ps=5.68u w=2.5u l=5u
X254 VSS.t791 VSS.t477 VSS.t790 VSS.t478 sg13_lv_nmos ad=0.17p pd=1.68u as=0 ps=0 w=0.5u l=2u
X255 a_7225_1529.t1 a_8939_1529.t1 VSS.t26 rhigh l=1.6u w=0.5u
X256 VSS.t788 VSS.t521 VSS.t787 VSS.t544 sg13_lv_nmos ad=0.1075p pd=1.34u as=0 ps=0 w=0.25u l=0.5u
X257 current_source_1mA_0.current_source_1mA_2_stage_0.current_source_pass_element_0.vota.t0 VBIASH.t18 IOVDD.t218 IOVDD.t0 sg13_hv_pmos ad=0.34p pd=2.68u as=0.19p ps=1.38u w=1u l=0.5u
X258 IOVDD.t156 IOVDD.t135 IOVDD.t136 IOVDD.t154 sg13_hv_pmos ad=0.34p pd=2.68u as=0 ps=0 w=1u l=0.5u
X259 a_6571_2609.t0 a_6977_2879.t0 VSS.t96 rhigh l=1.6u w=0.5u
X260 VDD.t196 VDD.t134 VDD.t178 VDD.t108 sg13_lv_pmos ad=0.85p pd=5.68u as=0 ps=0 w=2.5u l=2u
X261 VSS.t885 two_stage_instrumentation_amplifier_0.ota_slow_gmid_1.vota.t5 two_stage_instrumentation_amplifier_0.ota_slow_gmid_1.vout1.t17 VSS.t100 sg13_lv_nmos ad=95f pd=0.88u as=0.17p ps=1.68u w=0.5u l=10u
X262 VSS.t483 VSS.t481 VSS.t483 VSS.t784 sg13_lv_nmos ad=0.19p pd=1.38u as=0 ps=0 w=1u l=0.13u
X263 VDD.t256 EN.t1 two_stage_instrumentation_amplifier_0.ota_slow_gmid_0.en_n.t1 VDD.t55 sg13_lv_pmos ad=0.68p pd=4.68u as=0.68p ps=4.68u w=2u l=0.13u
X264 VSS.t448 ota_lv_gmid_comparator_0.ota_slow_gmid_mirror_0.vota.t4 ota_lv_gmid_comparator_0.ota_slow_gmid_mirror_0.vout1.t1 VSS.t449 sg13_lv_nmos ad=95f pd=0.88u as=0.17p ps=1.68u w=0.5u l=10u
X265 a_7631_719.t0 a_8939_989.t0 VSS.t54 rhigh l=1.6u w=0.5u
X266 ref_selector_0.VMIN.t7 VSS.t418 VSS.t396 rppd l=1.43u w=0.5u
X267 ota_lv_gmid_comparator_0.ota_slow_gmid_ctrl_buff_0.x.t4 ota_lv_gmid_comparator_0.ota_slow_gmid_mirror_0.vout1.t15 a_2285_1463.t10 VSS.t256 sg13_lv_nmos ad=0.68p pd=4.68u as=0.38p ps=2.38u w=2u l=0.13u
X268 current_source_1mA_0.current_source_1mA_2_stage_0.vcp.t5 current_source_1mA_0.current_source_1mA_2_stage_0.current_source_pass_element_0.vota.t6 current_source_1mA_0.current_source_1mA_2_stage_0.current_source_pass_element_0.iref.t10 VSS.t1068 sg13_hv_nmos ad=0.1425p pd=1.13u as=0.1425p ps=1.13u w=0.75u l=0.5u
X269 VSS.t367 two_stage_instrumentation_amplifier_0.ota_slow_gmid_0.ota_slow_gmid_buffer_0.ibiasn.t0 VAMP.t60 VSS.t323 sg13_lv_nmos ad=0.1075p pd=1.34u as=0.1075p ps=1.34u w=0.25u l=0.5u
X270 IOVDD.t102 IOVDD.t79 IOVDD.t102 IOVDD.t3 sg13_hv_pmos ad=0.33915p pd=2.165u as=0 ps=0 w=1.785u l=3u
X271 VSS.t990 two_stage_instrumentation_amplifier_0.ota_slow_gmid_1.ota_slow_gmid_buffer_0.ibiasn.t0 two_stage_instrumentation_amplifier_0.vamp1.t50 VSS.t939 sg13_lv_nmos ad=0.1075p pd=1.34u as=0.1075p ps=1.34u w=0.25u l=0.5u
X272 VAMP.t49 two_stage_instrumentation_amplifier_0.ota_slow_gmid_0.ota_slow_gmid_buffer_0.ibiasn.t0 VSS.t366 VSS.t321 sg13_lv_nmos ad=0.1075p pd=1.34u as=0.1075p ps=1.34u w=0.25u l=0.5u
X273 current_source_1mA_0.ota_med_hv_gmid_0.ota_med_hv_gmid_mirror_0.vota.t2 VBG.t0 current_source_1mA_0.ota_med_hv_gmid_0.ota_med_hv_gmid_tail_0.tail.t0 IOVDD.t0 sg13_hv_pmos ad=0.9996p pd=6.56u as=0.5586p ps=3.32u w=2.94u l=1u
X274 VSS.t783 VSS.t492 VSS.t782 VSS.t538 sg13_lv_nmos ad=0.1075p pd=1.34u as=0 ps=0 w=0.25u l=0.5u
X275 non_inverting_amplifier_hv_0.ota_hv_slow_gmid_0.vamp.t5 non_inverting_amplifier_hv_0.ota_hv_slow_gmid_0.en_n.t7 VSS.t243 VSS.t241 sg13_hv_nmos ad=0.114p pd=0.98u as=0.114p ps=0.98u w=0.6u l=0.45u
X276 VDD.t228 ota_lv_gmid_comparator_0.ota_slow_gmid_ctrl_buff_1.y.t2 ota_lv_gmid_comparator_0.ota_slow_gmid_mirror_0.vout1.t6 VDD.t27 sg13_lv_pmos ad=0.27075p pd=1.805u as=0.27075p ps=1.805u w=1.425u l=0.13u
X277 VSS.t780 VSS.t517 VSS.t779 VSS.t778 sg13_hv_nmos ad=1.4535p pd=9.23u as=0 ps=0 w=4.275u l=4u
X278 VDD.t193 VDD.t179 VDD.t192 VDD.t54 sg13_lv_pmos ad=0.34p pd=2.68u as=0 ps=0 w=1u l=0.5u
X279 VSS.t777 VSS.t696 VSS.t776 VSS.t697 sg13_lv_nmos ad=0.17p pd=1.68u as=0 ps=0 w=0.5u l=2u
X280 IOVDD.t198 non_inverting_amplifier_hv_0.ota_hv_slow_gmid_0.en.t2 VBIASH.t14 IOVDD.t28 sg13_hv_pmos ad=62.69999f pd=0.71u as=62.69999f ps=0.71u w=0.33u l=0.4u
X281 VDD.t190 VDD.t131 VDD.t160 VDD.t68 sg13_lv_pmos ad=0.85p pd=5.68u as=0 ps=0 w=2.5u l=2u
X282 VOUT.t6 non_inverting_amplifier_hv_0.ota_hv_slow_gmid_0.vamp.t23 IOVDD.t7 VSS.t202 sg13_hv_nmos ad=0.19p pd=1.38u as=0.34p ps=2.68u w=1u l=1u
X283 VSS.t483 VSS.t481 VSS.t483 VSS.t773 sg13_lv_nmos ad=0.19p pd=1.38u as=0 ps=0 w=1u l=0.13u
X284 VSS.t772 VSS.t488 VSS.t771 VSS.t554 sg13_lv_nmos ad=0.1075p pd=1.34u as=0 ps=0 w=0.25u l=0.5u
X285 IOVDD.t43 current_source_1mA_0.current_source_1mA_2_stage_0.current_source_pass_element_0.iref.t4 ref_selector_0.I1MA.t8 IOVDD.t31 sg13_hv_pmos ad=0.285p pd=1.88u as=0.285p ps=1.88u w=1.5u l=0.5u
X286 VSS.t769 VSS.t767 current_source_1mA_0.current_source_1mA_2_stage_0.vcp.t1 VSS.t768 sg13_hv_nmos ad=0.255p pd=2.18u as=0.1425p ps=1.13u w=0.75u l=0.5u
X287 ref_selector_0.ref_selector_r_96_0.vcal.t6 VSS.t444 VSS.t443 rppd l=1.43u w=0.5u
X288 ota_lv_gmid_comparator_0.ota_slow_gmid_mirror_0.vref.t1 ref_selector_0.VMIN.t20 ota_lv_gmid_comparator_0.ota_slow_gmid_common_0/ota_slow_gmid_pairs_0.tail.t1 VDD.t41 sg13_lv_pmos ad=0.85p pd=5.68u as=0.475p ps=2.88u w=2.5u l=5u
X289 two_stage_instrumentation_amplifier_0.ota_slow_gmid_0.ota_slow_gmid_mirror_0.vref.t3 two_stage_instrumentation_amplifier_0.ota_slow_gmid_0.ota_slow_gmid_mirror_0.vref.t2 VSS.t301 VSS.t300 sg13_lv_nmos ad=0.17p pd=1.68u as=95f ps=0.88u w=0.5u l=10u
X290 non_inverting_amplifier_hv_0.ota_hv_slow_gmid_0.en.t0 non_inverting_amplifier_hv_0.ota_hv_slow_gmid_0.en_n.t6 IOVDD.t30 IOVDD.t3 sg13_hv_pmos ad=0.68p pd=4.68u as=0.68p ps=4.68u w=2u l=0.45u
X291 dw_n7292_5488.t2 two_stage_instrumentation_amplifier_0.ota_slow_gmid_0.vota.t5 dw_n7292_5488.t1 dw_n7292_5488.t0 sg13_lv_pmos ad=1.02p pd=6.68u as=0 ps=0 w=3u l=3u
X292 a_7225_719.t0 a_7631_989.t0 VSS.t7 rhigh l=1.6u w=0.5u
X293 VDD.t105 VDD.t106 VSS.t897 rhigh l=3u w=0.5u
X294 VOUT.t0 non_inverting_amplifier_hv_0.ota_hv_slow_gmid_0.ibiasn.t3 VSS.t297 VSS.t205 sg13_hv_nmos ad=0.19p pd=1.38u as=0.19p ps=1.38u w=1u l=1u
X295 VBIASH.t14 non_inverting_amplifier_hv_0.ota_hv_slow_gmid_0.en.t2 IOVDD.t194 IOVDD.t28 sg13_hv_pmos ad=62.69999f pd=0.71u as=62.69999f ps=0.71u w=0.33u l=0.4u
X296 VBIAS.t17 two_stage_instrumentation_amplifier_0.ota_slow_gmid_0.en.t2 VDD.t65 VDD.t68 sg13_lv_pmos ad=0.19p pd=1.38u as=0.19p ps=1.38u w=1u l=0.13u
X297 VSS.t459 VSS.t460 VSS.t458 rhigh l=2.5u w=0.5u
X298 VSS.t766 VSS.t521 VSS.t765 VSS.t611 sg13_lv_nmos ad=0.1075p pd=1.34u as=0 ps=0 w=0.25u l=0.5u
X299 IOVDD.t133 IOVDD.t70 IOVDD.t133 IOVDD.t87 sg13_hv_pmos ad=0.5586p pd=3.32u as=0 ps=0 w=2.94u l=1u
X300 ota_lv_gmid_comparator_0.ota_slow_gmid_ctrl_buff_1.y.t1 ota_lv_gmid_comparator_0.ota_slow_gmid_ctrl_buff_1.ota_slow_gmid_ctrl_inv_0.x.t2 VDD.t109 VDD.t108 sg13_lv_pmos ad=0.68p pd=4.68u as=0.68p ps=4.68u w=2u l=0.13u
X301 VDD.t84 VSS.t547 VSS.t549 VSS.t762 sg13_lv_nmos ad=0.19p pd=1.38u as=0.19p ps=1.38u w=1u l=0.13u
X302 a_18762_8968.t0 a_19032_8690.t0 VSS.t5 rhigh l=0.96u w=0.5u
X303 IOVDD.t195 non_inverting_amplifier_hv_0.ota_hv_slow_gmid_0.en.t2 VBIASH.t13 IOVDD.t28 sg13_hv_pmos ad=62.69999f pd=0.71u as=0.1122p ps=1.34u w=0.33u l=0.4u
X304 IOVDD.t128 IOVDD.t59 IOVDD.t128 IOVDD.t3 sg13_hv_pmos ad=0.19p pd=1.38u as=0 ps=0 w=1u l=0.5u
X305 two_stage_instrumentation_amplifier_0.vamp1.t49 two_stage_instrumentation_amplifier_0.ota_slow_gmid_1.ota_slow_gmid_buffer_0.ibiasn.t0 VSS.t989 VSS.t941 sg13_lv_nmos ad=0.1075p pd=1.34u as=0.1075p ps=1.34u w=0.25u l=0.5u
X306 VBIAS.t23 two_stage_instrumentation_amplifier_0.ota_slow_gmid_0.en.t3 VDD.t75 VDD.t55 sg13_lv_pmos ad=0.19p pd=1.38u as=0.19p ps=1.38u w=1u l=0.13u
X307 VSS.t761 VSS.t598 VSS.t760 VSS.t599 sg13_hv_nmos ad=0.34p pd=2.68u as=0 ps=0 w=1u l=1u
X308 VDD.t88 VBIAS.t32 two_stage_instrumentation_amplifier_0.ota_slow_gmid_1.ota_slow_gmid_buffer_0.ibiasn.t6 VDD.t0 sg13_lv_pmos ad=0.19p pd=1.38u as=0.34p ps=2.68u w=1u l=0.5u
X309 VSS.t365 two_stage_instrumentation_amplifier_0.ota_slow_gmid_0.ota_slow_gmid_buffer_0.ibiasn.t0 VAMP.t50 VSS.t323 sg13_lv_nmos ad=0.1075p pd=1.34u as=0.1075p ps=1.34u w=0.25u l=0.5u
X310 non_inverting_amplifier_hv_0.ota_hv_slow_gmid_0.en_n.t0 top_conditionning_level_shifter_0.EN_HV.t3 IOVDD.t29 IOVDD.t28 sg13_hv_pmos ad=0.68p pd=4.68u as=0.68p ps=4.68u w=2u l=0.45u
X311 VDD.t77 two_stage_instrumentation_amplifier_0.ota_slow_gmid_0.en.t3 VBIAS.t19 VDD.t55 sg13_lv_pmos ad=0.19p pd=1.38u as=0.19p ps=1.38u w=1u l=0.13u
X312 VSS.t83 VSS.t84 VSS.t82 rhigh l=1.6u w=0.5u
X313 two_stage_instrumentation_amplifier_0.ota_slow_gmid_1.ota_slow_gmid_mirror_0.vref.t0 two_stage_instrumentation_amplifier_0.ota_slow_gmid_1.VN.t3 two_stage_instrumentation_amplifier_0.ota_slow_gmid_1.ota_slow_gmid_common_0/ota_slow_gmid_pairs_0.tail.t0 VDD.t0 sg13_lv_pmos ad=0.85p pd=5.68u as=0.475p ps=2.88u w=2.5u l=5u
X314 current_source_1mA_0.ota_med_hv_gmid_0.ota_med_hv_gmid_tail_0.tail.t2 VBIASH.t18 IOVDD.t217 IOVDD.t0 sg13_hv_pmos ad=0.34p pd=2.68u as=0.19p ps=1.38u w=1u l=0.5u
X315 VSS.t988 two_stage_instrumentation_amplifier_0.ota_slow_gmid_1.ota_slow_gmid_buffer_0.ibiasn.t0 two_stage_instrumentation_amplifier_0.vamp1.t48 VSS.t939 sg13_lv_nmos ad=0.1075p pd=1.34u as=0.1075p ps=1.34u w=0.25u l=0.5u
X316 VSS.t181 two_stage_instrumentation_amplifier_0.ota_slow_gmid_1.en_n.t2 two_stage_instrumentation_amplifier_0.ota_slow_gmid_1.vout1.t8 VSS.t180 sg13_lv_nmos ad=0.228p pd=1.58u as=0.228p ps=1.58u w=1.2u l=0.13u
X317 VAMP.t32 two_stage_instrumentation_amplifier_0.ota_slow_gmid_0.ota_slow_gmid_buffer_0.ibiasn.t0 VSS.t364 VSS.t319 sg13_lv_nmos ad=0.1075p pd=1.34u as=0.1075p ps=1.34u w=0.25u l=0.5u
X318 VSS.t68 VSS.t69 VSS.t31 rhigh l=1.6u w=0.5u
X319 VSS.t758 VSS.t521 VSS.t757 VSS.t522 sg13_lv_nmos ad=0.1075p pd=1.34u as=0 ps=0 w=0.25u l=0.5u
X320 VDD.t187 VDD.t164 VDD.t186 VDD.t0 sg13_lv_pmos ad=0.34p pd=2.68u as=0 ps=0 w=1u l=0.5u
X321 VSS.t129 VSS.t130 VSS.t82 rhigh l=1.6u w=0.5u
X322 two_stage_instrumentation_amplifier_0.ota_slow_gmid_1.ota_slow_gmid_mirror_0.vref.t3 two_stage_instrumentation_amplifier_0.ota_slow_gmid_1.ota_slow_gmid_mirror_0.vref.t2 VSS.t99 VSS.t97 sg13_lv_nmos ad=0.17p pd=1.68u as=95f ps=0.88u w=0.5u l=10u
X323 VSS.t32 VSS.t33 VSS.t31 rhigh l=1.6u w=0.5u
X324 ota_lv_gmid_comparator_0.ota_slow_gmid_mirror_0.vout1.t11 ota_lv_gmid_comparator_0.ota_slow_gmid_ctrl_buff_1.y.t2 VDD.t236 VDD.t27 sg13_lv_pmos ad=0.27075p pd=1.805u as=0.27075p ps=1.805u w=1.425u l=0.13u
X325 IOVDD.t49 IOVDD.t120 IOVDD.t49 IOVDD.t31 sg13_hv_pmos ad=0.285p pd=1.88u as=0 ps=0 w=1.5u l=0.5u
X326 VSS.t179 two_stage_instrumentation_amplifier_0.ota_slow_gmid_1.en_n.t2 two_stage_instrumentation_amplifier_0.ota_slow_gmid_1.vout1.t7 VSS.t178 sg13_lv_nmos ad=0.228p pd=1.58u as=0.228p ps=1.58u w=1.2u l=0.13u
X327 two_stage_instrumentation_amplifier_0.ota_slow_gmid_1.vout1.t10 two_stage_instrumentation_amplifier_0.ota_slow_gmid_1.en_n.t3 VSS.t18 VSS.t21 sg13_lv_nmos ad=0.228p pd=1.58u as=0.228p ps=1.58u w=1.2u l=0.13u
X328 VSS.t755 VSS.t686 VSS.t754 VSS.t687 sg13_lv_nmos ad=0.17p pd=1.68u as=0 ps=0 w=0.5u l=2u
X329 VSS.t752 VSS.t488 VSS.t751 VSS.t554 sg13_lv_nmos ad=0.1075p pd=1.34u as=0 ps=0 w=0.25u l=0.5u
X330 ota_lv_gmid_comparator_0.ota_slow_gmid_mirror_0.vout1.t0 ota_lv_gmid_comparator_0.ota_slow_gmid_mirror_0.vota.t4 VSS.t448 VSS.t447 sg13_lv_nmos ad=0.17p pd=1.68u as=95f ps=0.88u w=0.5u l=10u
X331 a_18762_6864.t0 a_19032_6586.t0 VSS.t5 rhigh l=0.96u w=0.5u
X332 VSS.t570 VSS.t568 VSS.t570 VSS.t748 sg13_lv_nmos ad=0.19p pd=1.38u as=0 ps=0 w=1u l=0.13u
X333 VSS.t234 non_inverting_amplifier_hv_0.ota_hv_slow_gmid_0.en_n.t4 non_inverting_amplifier_hv_0.ota_hv_slow_gmid_0.vamp.t4 VSS.t224 sg13_hv_nmos ad=0.4218p pd=2.6u as=0.4218p ps=2.6u w=2.22u l=0.45u
X334 VSS.t208 current_source_1mA_0.ota_med_hv_gmid_0.ota_med_hv_gmid_mirror_0.vota.t6 current_source_1mA_0.current_source_1mA_2_stage_0.current_source_pass_element_0.vota.t3 VSS.t206 sg13_hv_nmos ad=0.646p pd=4.48u as=0.646p ps=4.48u w=1.9u l=2u
X335 a_18222_8442.t0 a_17682_8164.t0 VSS.t46 rhigh l=0.96u w=0.5u
X336 VDD.t73 two_stage_instrumentation_amplifier_0.ota_slow_gmid_0.en.t3 VBIAS.t21 VDD.t55 sg13_lv_pmos ad=0.19p pd=1.38u as=0.19p ps=1.38u w=1u l=0.13u
X337 VSS.t747 VSS.t711 VSS.t746 VSS.t712 sg13_lv_nmos ad=0.17p pd=1.68u as=0 ps=0 w=0.5u l=2u
X338 VSS.t559 VSS.t557 VSS.t559 VSS.t743 sg13_lv_nmos ad=0.19p pd=1.38u as=0 ps=0 w=1u l=0.13u
X339 ref_selector_0.VMIN.t0 VSS.t59 VSS.t58 rppd l=1.43u w=0.5u
X340 IOVDD.t42 current_source_1mA_0.current_source_1mA_2_stage_0.current_source_pass_element_0.iref.t4 ref_selector_0.I1MA.t7 IOVDD.t31 sg13_hv_pmos ad=0.285p pd=1.88u as=0.285p ps=1.88u w=1.5u l=0.5u
X341 a_n9334_4739.t1 a_n9604_4333.t1 VSS.t1047 rhigh l=1.6u w=0.5u
X342 two_stage_instrumentation_amplifier_0.vamp1.t47 two_stage_instrumentation_amplifier_0.ota_slow_gmid_1.ota_slow_gmid_buffer_0.ibiasn.t0 VSS.t987 VSS.t935 sg13_lv_nmos ad=0.1075p pd=1.34u as=0.1075p ps=1.34u w=0.25u l=0.5u
X343 VSS.t1045 ota_lv_gmid_comparator_0.ota_slow_gmid_mirror_0.vref.t2 ota_lv_gmid_comparator_0.ota_slow_gmid_mirror_0.vota.t3 VSS.t449 sg13_lv_nmos ad=95f pd=0.88u as=0.17p ps=1.68u w=0.5u l=10u
X344 VSS.t742 VSS.t496 VSS.t741 VSS.t511 sg13_lv_nmos ad=0.1075p pd=1.34u as=0 ps=0 w=0.25u l=0.5u
X345 VSS.t911 VSS.t912 VSS.t440 rppd l=1.43u w=0.5u
X346 VSS.t301 two_stage_instrumentation_amplifier_0.ota_slow_gmid_0.ota_slow_gmid_mirror_0.vref.t4 two_stage_instrumentation_amplifier_0.ota_slow_gmid_0.vota.t3 VSS.t303 sg13_lv_nmos ad=95f pd=0.88u as=0.17p ps=1.68u w=0.5u l=10u
X347 a_8533_719.t1 ref_selector_0.VMIN.t17 VSS.t54 rhigh l=1.6u w=0.5u
X348 VSS.t986 two_stage_instrumentation_amplifier_0.ota_slow_gmid_1.ota_slow_gmid_buffer_0.ibiasn.t0 two_stage_instrumentation_amplifier_0.vamp1.t46 VSS.t932 sg13_lv_nmos ad=0.1075p pd=1.34u as=0.1075p ps=1.34u w=0.25u l=0.5u
X349 a_n9874_2535.t0 a_n9874_2009.t0 VSS.t73 rhigh l=0.96u w=0.5u
X350 VSS.t214 non_inverting_amplifier_hv_0.ota_hv_slow_gmid_0.en_n.t2 non_inverting_amplifier_hv_0.ota_hv_slow_gmid_0.vamp.t2 VSS.t212 sg13_hv_nmos ad=0.4218p pd=2.6u as=0.4218p ps=2.6u w=2.22u l=0.45u
X351 VSS.t901 non_inverting_amplifier_hv_0.ota_hv_slow_gmid_0.vota.t4 non_inverting_amplifier_hv_0.ota_hv_slow_gmid_0.vamp.t20 VSS.t898 sg13_hv_nmos ad=0.81225p pd=4.655u as=1.4535p ps=9.23u w=4.275u l=10u
X352 IOVDD.t96 IOVDD.t67 IOVDD.t96 IOVDD.t28 sg13_hv_pmos ad=0.33915p pd=2.165u as=0 ps=0 w=1.785u l=3u
X353 VSS.t985 two_stage_instrumentation_amplifier_0.ota_slow_gmid_1.ota_slow_gmid_buffer_0.ibiasn.t0 two_stage_instrumentation_amplifier_0.vamp1.t45 VSS.t943 sg13_lv_nmos ad=0.1075p pd=1.34u as=0.1075p ps=1.34u w=0.25u l=0.5u
X354 VAMP.t33 two_stage_instrumentation_amplifier_0.ota_slow_gmid_0.ota_slow_gmid_buffer_0.ibiasn.t0 VSS.t363 VSS.t316 sg13_lv_nmos ad=0.1075p pd=1.34u as=0.1075p ps=1.34u w=0.25u l=0.5u
X355 VSS.t362 two_stage_instrumentation_amplifier_0.ota_slow_gmid_0.ota_slow_gmid_buffer_0.ibiasn.t0 VAMP.t34 VSS.t307 sg13_lv_nmos ad=0.1075p pd=1.34u as=0.1075p ps=1.34u w=0.25u l=0.5u
X356 two_stage_instrumentation_amplifier_0.ota_slow_gmid_0.ota_slow_gmid_buffer_0.ibiasn.t3 two_stage_instrumentation_amplifier_0.ota_slow_gmid_0.ota_slow_gmid_buffer_0.ibiasn.t0 VSS.t361 VSS.t311 sg13_lv_nmos ad=0.1075p pd=1.34u as=0.1075p ps=1.34u w=0.25u l=0.5u
X357 IOVDD.t19 top_conditionning_level_shifter_0.EN_HV.t2 VBIASH.t3 IOVDD.t25 sg13_hv_pmos ad=0.38p pd=2.38u as=0.38p ps=2.38u w=2u l=0.4u
X358 VSS.t483 VSS.t481 VDD.t85 VSS.t738 sg13_lv_nmos ad=0.19p pd=1.38u as=0.19p ps=1.38u w=1u l=0.13u
X359 IOVDD.t143 IOVDD.t135 IOVDD.t143 IOVDD.t20 sg13_hv_pmos ad=0.19p pd=1.38u as=0 ps=0 w=1u l=0.5u
X360 VSS.t737 VSS.t488 VSS.t736 VSS.t489 sg13_lv_nmos ad=0.1075p pd=1.34u as=0 ps=0 w=0.25u l=0.5u
X361 VSS.t360 two_stage_instrumentation_amplifier_0.ota_slow_gmid_0.ota_slow_gmid_buffer_0.ibiasn.t0 VAMP.t35 VSS.t313 sg13_lv_nmos ad=0.1075p pd=1.34u as=0.1075p ps=1.34u w=0.25u l=0.5u
X362 a_2285_1463.t8 ota_lv_gmid_comparator_0.ota_slow_gmid_ctrl_buff_0.x.t6 VDD.t30 VSS.t116 sg13_lv_nmos ad=55.85f pd=0.74u as=55.85f ps=0.74u w=0.155u l=0.5u
X363 current_source_1mA_0.current_source_1mA_2_stage_0.current_source_pass_element_0.iref.t3 top_conditionning_level_shifter_0.EN_HV.t2 IOVDD.t22 IOVDD.t4 sg13_hv_pmos ad=0.38p pd=2.38u as=0.38p ps=2.38u w=2u l=0.4u
X364 two_stage_instrumentation_amplifier_0.ota_slow_gmid_0.vout1.t2 two_stage_instrumentation_amplifier_0.ota_slow_gmid_0.vota.t6 VSS.t416 VSS.t300 sg13_lv_nmos ad=0.17p pd=1.68u as=95f ps=0.88u w=0.5u l=10u
X365 VDD.t184 VDD.t149 VDD.t183 VDD.t0 sg13_lv_pmos ad=0.34p pd=2.68u as=0 ps=0 w=1u l=0.5u
X366 a_n9064_2009.t0 a_n9064_1483.t0 VSS.t4 rhigh l=0.96u w=0.5u
X367 VSS.t734 VSS.t492 VSS.t733 VSS.t493 sg13_lv_nmos ad=0.1075p pd=1.34u as=0 ps=0 w=0.25u l=0.5u
X368 ota_lv_gmid_comparator_0.ota_slow_gmid_mirror_0.vout1.t13 ota_lv_gmid_comparator_0.ota_slow_gmid_ctrl_buff_1.y.t2 VDD.t235 VDD.t27 sg13_lv_pmos ad=0.4845p pd=3.53u as=0.27075p ps=1.805u w=1.425u l=0.13u
X369 VSS.t1037 VSS.t1038 VSS.t1036 rhigh l=1.6u w=0.5u
X370 a_19302_7916.t0 a_19032_7638.t0 VSS.t47 rhigh l=0.96u w=0.5u
X371 a_7225_1799.t0 a_7631_1529.t0 VSS.t6 rhigh l=1.6u w=0.5u
X372 VDD.t45 VDD.t46 VSS.t152 rhigh l=3u w=0.5u
X373 VSS.t731 VSS.t696 VSS.t730 VSS.t697 sg13_lv_nmos ad=0.17p pd=1.68u as=0 ps=0 w=0.5u l=2u
X374 VBIASH.t3 top_conditionning_level_shifter_0.EN_HV.t2 IOVDD.t17 IOVDD.t0 sg13_hv_pmos ad=0.38p pd=2.38u as=0.38p ps=2.38u w=2u l=0.4u
X375 VSS.t148 VSS.t149 VSS.t6 rhigh l=1.6u w=0.5u
X376 VDD.t247 ota_lv_gmid_comparator_0.ota_slow_gmid_ctrl_buff_1.y.t3 VBIAS.t30 VDD.t108 sg13_lv_pmos ad=0.27075p pd=1.805u as=0.27075p ps=1.805u w=1.425u l=0.13u
X377 VSS.t728 VSS.t531 VSS.t727 VSS.t532 sg13_hv_nmos ad=0.646p pd=4.48u as=0 ps=0 w=1.9u l=2u
X378 VSS.t725 VSS.t547 VSS.t549 VSS.t723 sg13_lv_nmos ad=0.34p pd=2.68u as=0 ps=0 w=1u l=0.13u
X379 IOVDD.t41 current_source_1mA_0.current_source_1mA_2_stage_0.current_source_pass_element_0.iref.t4 ref_selector_0.I1MA.t6 IOVDD.t31 sg13_hv_pmos ad=0.285p pd=1.88u as=0.285p ps=1.88u w=1.5u l=0.5u
X380 IOVDD.t10 non_inverting_amplifier_hv_0.ota_hv_slow_gmid_0.vamp.t24 VOUT.t5 VSS.t201 sg13_hv_nmos ad=0.19p pd=1.38u as=0.19p ps=1.38u w=1u l=1u
X381 VSS.t278 two_stage_instrumentation_amplifier_0.ota_slow_gmid_0.en_n.t3 two_stage_instrumentation_amplifier_0.ota_slow_gmid_0.en.t0 VSS.t277 sg13_lv_nmos ad=0.68p pd=4.68u as=0.68p ps=4.68u w=2u l=0.13u
X382 VSS.t722 VSS.t496 VSS.t721 VSS.t497 sg13_lv_nmos ad=0.1075p pd=1.34u as=0 ps=0 w=0.25u l=0.5u
X383 IOVDD.t22 top_conditionning_level_shifter_0.EN_HV.t2 current_source_1mA_0.current_source_1mA_2_stage_0.current_source_pass_element_0.iref.t1 IOVDD.t16 sg13_hv_pmos ad=0.38p pd=2.38u as=0.38p ps=2.38u w=2u l=0.4u
X384 VDD.t13 two_stage_instrumentation_amplifier_0.ota_slow_gmid_1.en.t2 VBIAS.t4 VDD.t9 sg13_lv_pmos ad=0.19p pd=1.38u as=0.19p ps=1.38u w=1u l=0.13u
X385 a_2285_1463.t6 ota_lv_gmid_comparator_0.ota_slow_gmid_ctrl_buff_0.x.t6 VDD.t39 VSS.t115 sg13_lv_nmos ad=55.85f pd=0.74u as=55.85f ps=0.74u w=0.155u l=0.5u
X386 non_inverting_amplifier_hv_0.ota_hv_slow_gmid_0.ota_hv_slow_gmid_tail_0.tail.t0 non_inverting_amplifier_hv_0.top_conditionning_gain_s3_0.vn3.t2 non_inverting_amplifier_hv_0.ota_hv_slow_gmid_0.vref.t0 IOVDD.t3 sg13_hv_pmos ad=0.33915p pd=2.165u as=0.6069p ps=4.25u w=1.785u l=3u
X387 IOVDD.t36 current_source_1mA_0.current_source_1mA_2_stage_0.current_source_pass_element_0.iref.t4 ref_selector_0.I1MA.t5 IOVDD.t31 sg13_hv_pmos ad=0.285p pd=1.88u as=0.51p ps=3.68u w=1.5u l=0.5u
X388 VDD.t181 VDD.t179 VDD.t180 VDD.t54 sg13_lv_pmos ad=0.34p pd=2.68u as=0 ps=0 w=1u l=0.5u
X389 IOVDD.t141 IOVDD.t59 IOVDD.t140 IOVDD.t3 sg13_hv_pmos ad=0.34p pd=2.68u as=0 ps=0 w=1u l=0.5u
X390 two_stage_instrumentation_amplifier_0.ota_slow_gmid_1.en.t0 two_stage_instrumentation_amplifier_0.ota_slow_gmid_1.en_n.t4 VSS.t25 VSS.t24 sg13_lv_nmos ad=0.68p pd=4.68u as=0.68p ps=4.68u w=2u l=0.13u
X391 IOVDD.t45 IOVDD.t120 IOVDD.t45 IOVDD.t31 sg13_hv_pmos ad=0.285p pd=1.88u as=0 ps=0 w=1.5u l=0.5u
X392 a_n9064_4085.t0 two_stage_instrumentation_amplifier_0.top_conditionning_gain_s2_0.vn2.t1 VSS.t4 rhigh l=1.6u w=0.5u
X393 VSS.t984 two_stage_instrumentation_amplifier_0.ota_slow_gmid_1.ota_slow_gmid_buffer_0.ibiasn.t0 two_stage_instrumentation_amplifier_0.vamp1.t44 VSS.t943 sg13_lv_nmos ad=0.1075p pd=1.34u as=0.1075p ps=1.34u w=0.25u l=0.5u
X394 VSS.t1032 ref_selector_0.VMIN.t15 VSS.t888 rppd l=1.43u w=0.5u
X395 VSS.t1034 VSS.t1035 VSS.t1033 rhigh l=1.6u w=0.5u
X396 VAMP.t36 two_stage_instrumentation_amplifier_0.ota_slow_gmid_0.ota_slow_gmid_buffer_0.ibiasn.t0 VSS.t359 VSS.t332 sg13_lv_nmos ad=0.1075p pd=1.34u as=0.1075p ps=1.34u w=0.25u l=0.5u
X397 VDD.t178 VDD.t123 VDD.t178 VDD.t108 sg13_lv_pmos ad=0.475p pd=2.88u as=0 ps=0 w=2.5u l=2u
X398 VDD.t12 two_stage_instrumentation_amplifier_0.ota_slow_gmid_1.en.t2 VBIAS.t3 VDD.t11 sg13_lv_pmos ad=0.19p pd=1.38u as=0.19p ps=1.38u w=1u l=0.13u
X399 a_7879_1529.t1 a_8285_1799.t1 VSS.t251 rhigh l=1.6u w=0.5u
X400 ref_selector_0.ref_selector_r_refs_0.R0.t1 a_9593_2609.t0 VSS.t86 rhigh l=1.6u w=0.5u
X401 VDD.t176 VDD.t118 VDD.t119 VDD.t0 sg13_lv_pmos ad=0.85p pd=5.68u as=0 ps=0 w=2.5u l=2u
X402 VBIAS.t9 two_stage_instrumentation_amplifier_0.ota_slow_gmid_1.en.t3 VDD.t17 VDD.t0 sg13_lv_pmos ad=0.19p pd=1.38u as=0.19p ps=1.38u w=1u l=0.13u
X403 VSS.t892 VSS.t893 VSS.t251 rhigh l=1.6u w=0.5u
X404 VSS.t549 VSS.t547 VSS.t549 VSS.t718 sg13_lv_nmos ad=0.19p pd=1.38u as=0 ps=0 w=1u l=0.13u
X405 two_stage_instrumentation_amplifier_0.ota_slow_gmid_1.vout1.t9 two_stage_instrumentation_amplifier_0.ota_slow_gmid_1.en_n.t3 VSS.t14 VSS.t20 sg13_lv_nmos ad=0.228p pd=1.58u as=0.228p ps=1.58u w=1.2u l=0.13u
X406 VSS.t471 VSS.t472 VSS.t470 rppd l=1.43u w=0.5u
X407 ota_lv_gmid_comparator_0.ota_slow_gmid_mirror_0.vref.t4 ota_lv_gmid_comparator_0.ota_slow_gmid_mirror_0.vref.t2 VSS.t1045 VSS.t447 sg13_lv_nmos ad=0.17p pd=1.68u as=95f ps=0.88u w=0.5u l=10u
X408 VSS.t233 non_inverting_amplifier_hv_0.ota_hv_slow_gmid_0.en_n.t4 non_inverting_amplifier_hv_0.ota_hv_slow_gmid_0.vamp.t13 VSS.t232 sg13_hv_nmos ad=0.4218p pd=2.6u as=0.4218p ps=2.6u w=2.22u l=0.45u
X409 VSS.t358 two_stage_instrumentation_amplifier_0.ota_slow_gmid_0.ota_slow_gmid_buffer_0.ibiasn.t0 VAMP.t37 VSS.t307 sg13_lv_nmos ad=0.1075p pd=1.34u as=0.1075p ps=1.34u w=0.25u l=0.5u
X410 VSS.t12 two_stage_instrumentation_amplifier_0.ota_slow_gmid_1.en_n.t3 two_stage_instrumentation_amplifier_0.ota_slow_gmid_1.vout1.t0 VSS.t19 sg13_lv_nmos ad=0.228p pd=1.58u as=0.228p ps=1.58u w=1.2u l=0.13u
X411 VSS.t717 VSS.t492 VSS.t716 VSS.t493 sg13_lv_nmos ad=0.1075p pd=1.34u as=0 ps=0 w=0.25u l=0.5u
X412 IOVDD.t136 IOVDD.t135 IOVDD.t136 IOVDD.t20 sg13_hv_pmos ad=0.19p pd=1.38u as=0 ps=0 w=1u l=0.5u
X413 VSS.t714 VSS.t711 VSS.t713 VSS.t712 sg13_lv_nmos ad=0.17p pd=1.68u as=0 ps=0 w=0.5u l=2u
X414 VSS.t710 VSS.t488 VSS.t709 VSS.t489 sg13_lv_nmos ad=0.1075p pd=1.34u as=0 ps=0 w=0.25u l=0.5u
X415 a_7225_2609.t1 a_7631_2339.t1 VSS.t6 rhigh l=1.6u w=0.5u
X416 non_inverting_amplifier_hv_0.ota_hv_slow_gmid_0.vamp.t19 non_inverting_amplifier_hv_0.ota_hv_slow_gmid_0.vota.t4 VSS.t901 VSS.t900 sg13_hv_nmos ad=1.4535p pd=9.23u as=0.81225p ps=4.655u w=4.275u l=10u
X417 VDD.t231 ota_lv_gmid_comparator_0.ota_slow_gmid_ctrl_buff_1.y.t2 ota_lv_gmid_comparator_0.ota_slow_gmid_mirror_0.vout1.t12 VDD.t27 sg13_lv_pmos ad=0.27075p pd=1.805u as=0.27075p ps=1.805u w=1.425u l=0.13u
X418 two_stage_instrumentation_amplifier_0.ota_slow_gmid_1.vota.t0 two_stage_instrumentation_amplifier_0.ota_slow_gmid_1.ota_slow_gmid_mirror_0.vref.t2 VSS.t98 VSS.t97 sg13_lv_nmos ad=0.17p pd=1.68u as=95f ps=0.88u w=0.5u l=10u
X419 VBIAS.t28 ota_lv_gmid_comparator_0.ota_slow_gmid_ctrl_buff_1.y.t3 VDD.t250 VDD.t108 sg13_lv_pmos ad=0.27075p pd=1.805u as=0.27075p ps=1.805u w=1.425u l=0.13u
X420 VDD.t34 ota_lv_gmid_comparator_0.ota_slow_gmid_ctrl_buff_0.x.t6 a_2285_1463.t9 VSS.t114 sg13_lv_nmos ad=55.85f pd=0.74u as=55.85f ps=0.74u w=0.155u l=0.5u
X421 a_7225_1259.t1 a_7631_2339.t0 VSS.t6 rhigh l=1.6u w=0.5u
X422 VSS.t273 two_stage_instrumentation_amplifier_0.ota_slow_gmid_0.en_n.t2 two_stage_instrumentation_amplifier_0.ota_slow_gmid_0.vout1.t9 VSS.t272 sg13_lv_nmos ad=0.228p pd=1.58u as=0.228p ps=1.58u w=1.2u l=0.13u
X423 VDD.t121 VDD.t118 VDD.t121 VDD.t0 sg13_lv_pmos ad=0.475p pd=2.88u as=0 ps=0 w=2.5u l=2u
X424 VSS.t707 VSS.t686 VSS.t706 VSS.t687 sg13_lv_nmos ad=0.17p pd=1.68u as=0 ps=0 w=0.5u l=2u
X425 IOVDD.t134 IOVDD.t70 IOVDD.t133 IOVDD.t20 sg13_hv_pmos ad=0.9996p pd=6.56u as=0 ps=0 w=2.94u l=1u
X426 VBIAS.t27 ota_lv_gmid_comparator_0.ota_slow_gmid_ctrl_buff_1.y.t3 VDD.t241 VDD.t108 sg13_lv_pmos ad=0.27075p pd=1.805u as=0.27075p ps=1.805u w=1.425u l=0.13u
X427 VAMP.t38 two_stage_instrumentation_amplifier_0.ota_slow_gmid_0.ota_slow_gmid_buffer_0.ibiasn.t0 VSS.t357 VSS.t327 sg13_lv_nmos ad=0.1075p pd=1.34u as=0.1075p ps=1.34u w=0.25u l=0.5u
X428 a_7225_1799.t1 a_6977_2879.t1 VSS.t6 rhigh l=1.6u w=0.5u
X429 VSS.t456 VSS.t457 VSS.t455 rhigh l=1.6u w=0.5u
X430 VSS.t297 non_inverting_amplifier_hv_0.ota_hv_slow_gmid_0.ibiasn.t3 non_inverting_amplifier_hv_0.ota_hv_slow_gmid_0.ibiasn.t2 VSS.t204 sg13_hv_nmos ad=0.19p pd=1.38u as=0.19p ps=1.38u w=1u l=1u
X431 VAMP.t61 a_n9334_3025.t1 VSS.t4 rhigh l=1.6u w=0.5u
X432 VSS.t416 two_stage_instrumentation_amplifier_0.ota_slow_gmid_0.vota.t6 two_stage_instrumentation_amplifier_0.ota_slow_gmid_0.vout1.t1 VSS.t303 sg13_lv_nmos ad=95f pd=0.88u as=0.17p ps=1.68u w=0.5u l=10u
X433 VDD.t37 ota_lv_gmid_comparator_0.ota_slow_gmid_ctrl_buff_0.x.t6 a_2285_1463.t3 VSS.t113 sg13_lv_nmos ad=55.85f pd=0.74u as=55.85f ps=0.74u w=0.155u l=0.5u
X434 VSS.t983 two_stage_instrumentation_amplifier_0.ota_slow_gmid_1.ota_slow_gmid_buffer_0.ibiasn.t0 two_stage_instrumentation_amplifier_0.vamp1.t43 VSS.t929 sg13_lv_nmos ad=0.1075p pd=1.34u as=0.1075p ps=1.34u w=0.25u l=0.5u
X435 VSS.t218 non_inverting_amplifier_hv_0.ota_hv_slow_gmid_0.en_n.t2 non_inverting_amplifier_hv_0.ota_hv_slow_gmid_0.vamp.t12 VSS.t212 sg13_hv_nmos ad=0.4218p pd=2.6u as=0.7548p ps=5.12u w=2.22u l=0.45u
X436 VSS.t982 two_stage_instrumentation_amplifier_0.ota_slow_gmid_1.ota_slow_gmid_buffer_0.ibiasn.t0 two_stage_instrumentation_amplifier_0.vamp1.t42 VSS.t929 sg13_lv_nmos ad=0.1075p pd=1.34u as=0.1075p ps=1.34u w=0.25u l=0.5u
X437 VSS.t299 VSS.t703 VSS.t299 VSS.t203 sg13_hv_nmos ad=0.19p pd=1.38u as=0 ps=0 w=1u l=1u
X438 ref_selector_0.ref_selector_r_96_0.vcal.t9 SEL_CAL.t0 ref_selector_0.I1MA.t13 VSS.t211 sg13_lv_nmos ad=1.7p pd=10.68u as=0.95p ps=5.38u w=5u l=0.13u
X439 a_7879_2609.t1 a_8285_2339.t1 VSS.t251 rhigh l=1.6u w=0.5u
X440 a_18762_8442.t0 a_19032_8164.t0 VSS.t5 rhigh l=0.96u w=0.5u
X441 a_17412_8164.t1 a_17682_7638.t0 VSS.t74 rhigh l=0.96u w=0.5u
X442 two_stage_instrumentation_amplifier_0.vamp1.t41 two_stage_instrumentation_amplifier_0.ota_slow_gmid_1.ota_slow_gmid_buffer_0.ibiasn.t0 VSS.t981 VSS.t927 sg13_lv_nmos ad=0.1075p pd=1.34u as=0.1075p ps=1.34u w=0.25u l=0.5u
X443 VSS.t1043 ota_lv_gmid_comparator_0.ota_slow_gmid_mirror_0.vref.t2 ota_lv_gmid_comparator_0.ota_slow_gmid_mirror_0.vref.t3 VSS.t449 sg13_lv_nmos ad=95f pd=0.88u as=0.17p ps=1.68u w=0.5u l=10u
X444 VDD.t33 ota_lv_gmid_comparator_0.ota_slow_gmid_ctrl_buff_0.x.t6 a_2285_1463.t8 VSS.t112 sg13_lv_nmos ad=55.85f pd=0.74u as=55.85f ps=0.74u w=0.155u l=0.5u
X445 a_19302_7390.t0 a_18762_7112.t0 VSS.t47 rhigh l=0.96u w=0.5u
X446 a_7879_1259.t1 a_8285_2339.t0 VSS.t251 rhigh l=1.6u w=0.5u
X447 IOVDD.t80 IOVDD.t79 IOVDD.t80 IOVDD.t3 sg13_hv_pmos ad=0.33915p pd=2.165u as=0 ps=0 w=1.785u l=3u
X448 IOVDD.t129 IOVDD.t59 IOVDD.t128 IOVDD.t3 sg13_hv_pmos ad=0.34p pd=2.68u as=0 ps=0 w=1u l=0.5u
X449 ota_lv_gmid_comparator_0.ota_slow_gmid_ctrl_buff_0.ota_slow_gmid_ctrl_inv_0.x.t0 ota_lv_gmid_comparator_0.ota_slow_gmid_ctrl_buff_0.x.t8 VSS.t164 VSS.t163 sg13_lv_nmos ad=0.68p pd=4.68u as=0.68p ps=4.68u w=2u l=0.13u
X450 VSS.t419 VSS.t420 VSS.t95 rppd l=3.69u w=0.5u
X451 VDD.t31 ota_lv_gmid_comparator_0.ota_slow_gmid_ctrl_buff_0.x.t6 a_2285_1463.t7 VSS.t111 sg13_lv_nmos ad=55.85f pd=0.74u as=55.85f ps=0.74u w=0.155u l=0.5u
X452 ref_selector_0.ref_selector_r_refs_0.R3.t0 a_8285_1799.t0 VSS.t251 rhigh l=1.6u w=0.5u
X453 VSS.t702 VSS.t492 VSS.t701 VSS.t538 sg13_lv_nmos ad=0.1075p pd=1.34u as=0 ps=0 w=0.25u l=0.5u
X454 VSS.t699 VSS.t696 VSS.t698 VSS.t697 sg13_lv_nmos ad=0.17p pd=1.68u as=0 ps=0 w=0.5u l=2u
X455 VSS.t356 two_stage_instrumentation_amplifier_0.ota_slow_gmid_0.ota_slow_gmid_buffer_0.ibiasn.t0 VAMP.t23 VSS.t309 sg13_lv_nmos ad=0.1075p pd=1.34u as=0.1075p ps=1.34u w=0.25u l=0.5u
X456 ref_selector_0.VMIN.t9 VSS.t446 VSS.t445 rppd l=1.43u w=0.5u
X457 VDD.t244 ota_lv_gmid_comparator_0.ota_slow_gmid_ctrl_buff_1.y.t3 VBIAS.t29 VDD.t108 sg13_lv_pmos ad=0.27075p pd=1.805u as=0.4845p ps=3.53u w=1.425u l=0.13u
X458 IOVDD.t126 IOVDD.t89 IOVDD.t114 IOVDD.t25 sg13_hv_pmos ad=0.9996p pd=6.56u as=0 ps=0 w=2.94u l=1u
X459 a_14614_1527.t1 a_14350_881.t1 VSS.t469 rppd l=3.69u w=0.5u
X460 VSS.t475 VSS.t476 VSS.t50 rppd l=1.43u w=0.5u
X461 a_14214_881.t1 VSS.t474 VSS.t473 rppd l=3.69u w=0.5u
X462 IOVDD.t116 IOVDD.t92 IOVDD.t116 IOVDD.t3 sg13_hv_pmos ad=0.19p pd=1.38u as=0 ps=0 w=1u l=0.5u
X463 ref_selector_0.VMIN.t16 a_6977_719.t1 VSS.t167 rhigh l=1.6u w=0.5u
X464 VBIASH.t12 non_inverting_amplifier_hv_0.ota_hv_slow_gmid_0.en.t3 IOVDD.t205 IOVDD.t3 sg13_hv_pmos ad=62.69999f pd=0.71u as=62.69999f ps=0.71u w=0.33u l=0.4u
X465 two_stage_instrumentation_amplifier_0.ota_slow_gmid_1.vout1.t18 a_n13602_4249.t1 VSS.t41 rhigh l=2.5u w=0.5u
X466 a_n1930_5507.t0 a_n2210_4821.t0 VSS.t131 rhigh l=3u w=0.5u
X467 IOVDD.t21 top_conditionning_level_shifter_0.EN_HV.t2 current_source_1mA_0.current_source_1mA_2_stage_0.current_source_pass_element_0.iref.t2 IOVDD.t20 sg13_hv_pmos ad=0.38p pd=2.38u as=0.68p ps=4.68u w=2u l=0.4u
X468 VSS.t355 two_stage_instrumentation_amplifier_0.ota_slow_gmid_0.ota_slow_gmid_buffer_0.ibiasn.t0 VAMP.t24 VSS.t323 sg13_lv_nmos ad=0.1075p pd=1.34u as=0.1075p ps=1.34u w=0.25u l=0.5u
X469 IOVDD.t207 non_inverting_amplifier_hv_0.ota_hv_slow_gmid_0.en.t3 VBIASH.t9 IOVDD.t3 sg13_hv_pmos ad=62.69999f pd=0.71u as=62.69999f ps=0.71u w=0.33u l=0.4u
X470 two_stage_instrumentation_amplifier_0.vamp1.t40 two_stage_instrumentation_amplifier_0.ota_slow_gmid_1.ota_slow_gmid_buffer_0.ibiasn.t0 VSS.t980 VSS.t945 sg13_lv_nmos ad=0.1075p pd=1.34u as=0.1075p ps=1.34u w=0.25u l=0.5u
X471 VSS.t979 two_stage_instrumentation_amplifier_0.ota_slow_gmid_1.ota_slow_gmid_buffer_0.ibiasn.t0 two_stage_instrumentation_amplifier_0.vamp1.t39 VSS.t939 sg13_lv_nmos ad=0.1075p pd=1.34u as=0.1075p ps=1.34u w=0.25u l=0.5u
X472 a_14614_1527.t0 a_14750_1527.t0 VSS.t0 rppd l=3.69u w=0.5u
X473 VSS.t695 VSS.t521 VSS.t694 VSS.t544 sg13_lv_nmos ad=0.1075p pd=1.34u as=0 ps=0 w=0.25u l=0.5u
X474 VDD.t171 VDD.t149 VDD.t170 VDD.t0 sg13_lv_pmos ad=0.34p pd=2.68u as=0 ps=0 w=1u l=0.5u
X475 VDD.t153 VDD.t113 VDD.t153 VDD.t11 sg13_lv_pmos ad=0.475p pd=2.88u as=0 ps=0 w=2.5u l=2u
X476 current_source_1mA_0.ota_med_hv_gmid_0.ota_med_hv_gmid_tail_0.tail.t1 VBG.t1 current_source_1mA_0.ota_med_hv_gmid_0.ota_med_hv_gmid_mirror_0.vota.t4 IOVDD.t4 sg13_hv_pmos ad=0.5586p pd=3.32u as=0.9996p ps=6.56u w=2.94u l=1u
X477 VDD.t166 VDD.t164 VDD.t165 VDD.t0 sg13_lv_pmos ad=0.34p pd=2.68u as=0 ps=0 w=1u l=0.5u
X478 VSS.t1026 EN.t1 two_stage_instrumentation_amplifier_0.ota_slow_gmid_0.en_n.t0 VSS.t1025 sg13_lv_nmos ad=0.68p pd=4.68u as=0.68p ps=4.68u w=2u l=0.13u
X479 VSS.t692 VSS.t488 VSS.t691 VSS.t554 sg13_lv_nmos ad=0.1075p pd=1.34u as=0 ps=0 w=0.25u l=0.5u
X480 two_stage_instrumentation_amplifier_0.vamp1.t38 two_stage_instrumentation_amplifier_0.ota_slow_gmid_1.ota_slow_gmid_buffer_0.ibiasn.t0 VSS.t978 VSS.t935 sg13_lv_nmos ad=0.1075p pd=1.34u as=0.1075p ps=1.34u w=0.25u l=0.5u
X481 a_834_5436.t1 VDD.t107 VSS.t907 rhigh l=2.5u w=0.5u
X482 IOVDD.t42 IOVDD.t120 IOVDD.t42 IOVDD.t31 sg13_hv_pmos ad=0.285p pd=1.88u as=0 ps=0 w=1.5u l=0.5u
X483 VSS.t1075 ref_selector_0.VMIN.t10 cap_cmim l=20u w=10u
X484 a_19302_8968.t1 a_19032_8690.t1 VSS.t47 rhigh l=0.96u w=0.5u
X485 VDD.t101 VBIAS.t34 two_stage_instrumentation_amplifier_0.ota_slow_gmid_0.ota_slow_gmid_buffer_0.ibiasn.t6 VDD.t55 sg13_lv_pmos ad=0.19p pd=1.38u as=0.34p ps=2.68u w=1u l=0.5u
X486 two_stage_instrumentation_amplifier_0.ota_slow_gmid_1.vout1.t16 two_stage_instrumentation_amplifier_0.ota_slow_gmid_1.vota.t5 VSS.t885 VSS.t97 sg13_lv_nmos ad=0.17p pd=1.68u as=95f ps=0.88u w=0.5u l=10u
X487 VSS.t354 two_stage_instrumentation_amplifier_0.ota_slow_gmid_0.ota_slow_gmid_buffer_0.ibiasn.t0 VAMP.t25 VSS.t309 sg13_lv_nmos ad=0.1075p pd=1.34u as=0.1075p ps=1.34u w=0.25u l=0.5u
X488 VDD.t67 two_stage_instrumentation_amplifier_0.ota_slow_gmid_0.en.t2 VBIAS.t15 VDD.t66 sg13_lv_pmos ad=0.19p pd=1.38u as=0.19p ps=1.38u w=1u l=0.13u
X489 ref_selector_0.I1MA.t0 SEL_SENSOR.t0 SENSOR.t1 VSS.t169 sg13_lv_nmos ad=0.95p pd=5.38u as=0.95p ps=5.38u w=5u l=0.13u
X490 ota_lv_gmid_comparator_0.ota_slow_gmid_mirror_0.vota.t2 ota_lv_gmid_comparator_0.ota_slow_gmid_mirror_0.vref.t2 VSS.t1043 VSS.t447 sg13_lv_nmos ad=0.17p pd=1.68u as=95f ps=0.88u w=0.5u l=10u
X491 VSS.t271 two_stage_instrumentation_amplifier_0.ota_slow_gmid_0.en_n.t2 two_stage_instrumentation_amplifier_0.ota_slow_gmid_0.vout1.t8 VSS.t270 sg13_lv_nmos ad=0.228p pd=1.58u as=0.228p ps=1.58u w=1.2u l=0.13u
X492 VBIAS.t6 two_stage_instrumentation_amplifier_0.ota_slow_gmid_1.en.t3 VDD.t20 VDD.t0 sg13_lv_pmos ad=0.19p pd=1.38u as=0.19p ps=1.38u w=1u l=0.13u
X493 VSS.t689 VSS.t686 VSS.t688 VSS.t687 sg13_lv_nmos ad=0.17p pd=1.68u as=0 ps=0 w=0.5u l=2u
X494 VSS.t151 a_n9874_1205.t0 VSS.t150 rhigh l=0.96u w=0.5u
X495 VSS.t137 VSS.t138 VSS.t136 rppd l=3.69u w=0.5u
X496 VSS.t1028 EN.t2 top_conditionning_level_shifter_0.top_conditionning_inverter_0.X.t2 VSS.t1029 sg13_hv_nmos ad=0.475p pd=2.88u as=0.85p ps=5.68u w=2.5u l=0.45u
X497 two_stage_instrumentation_amplifier_0.ota_slow_gmid_0.ota_slow_gmid_mirror_0.vref.t0 two_stage_instrumentation_amplifier_0.top_conditionning_gain_s2_0.vn2.t2 two_stage_instrumentation_amplifier_0.ota_slow_gmid_0.ota_slow_gmid_common_0/ota_slow_gmid_pairs_0.tail.t1 VDD.t55 sg13_lv_pmos ad=0.85p pd=5.68u as=0.475p ps=2.88u w=2.5u l=5u
X498 VOUT.t5 non_inverting_amplifier_hv_0.ota_hv_slow_gmid_0.vamp.t24 IOVDD.t9 VSS.t205 sg13_hv_nmos ad=0.19p pd=1.38u as=0.19p ps=1.38u w=1u l=1u
X499 VSS.t290 two_stage_instrumentation_amplifier_0.ota_slow_gmid_0.en_n.t4 two_stage_instrumentation_amplifier_0.ota_slow_gmid_0.vout1.t14 VSS.t289 sg13_lv_nmos ad=0.228p pd=1.58u as=0.228p ps=1.58u w=1.2u l=0.13u
X500 VSS.t438 current_source_1mA_0.ota_med_hv_gmid_0.ota_med_hv_gmid_mirror_0.Iref.t0 current_source_1mA_0.ota_med_hv_gmid_0.ota_med_hv_gmid_mirror_0.Iref.t1 VSS.t434 sg13_hv_nmos ad=0.646p pd=4.48u as=0.646p ps=4.48u w=1.9u l=2u
X501 a_17412_7390.t1 a_17682_7112.t0 VSS.t74 rhigh l=0.96u w=0.5u
X502 ref_selector_0.VMIN.t5 VSS.t382 VSS.t381 rppd l=1.43u w=0.5u
X503 two_stage_instrumentation_amplifier_0.ota_slow_gmid_0.vout1.t15 two_stage_instrumentation_amplifier_0.ota_slow_gmid_0.en_n.t4 VSS.t286 VSS.t288 sg13_lv_nmos ad=0.228p pd=1.58u as=0.228p ps=1.58u w=1.2u l=0.13u
X504 a_19302_6864.t0 a_19032_6586.t1 VSS.t47 rhigh l=0.96u w=0.5u
X505 VSS.t977 two_stage_instrumentation_amplifier_0.ota_slow_gmid_1.ota_slow_gmid_buffer_0.ibiasn.t0 two_stage_instrumentation_amplifier_0.vamp1.t37 VSS.t976 sg13_lv_nmos ad=0.1075p pd=1.34u as=0.1075p ps=1.34u w=0.25u l=0.5u
X506 VSS.t450 ota_lv_gmid_comparator_0.ota_slow_gmid_mirror_0.vota.t5 ota_lv_gmid_comparator_0.ota_slow_gmid_mirror_0.vout1.t3 VSS.t449 sg13_lv_nmos ad=95f pd=0.88u as=0.17p ps=1.68u w=0.5u l=10u
X507 VSS.t295 VSS.t296 VSS.t294 rhigh l=1.6u w=0.5u
X508 VDD.t2 VDD.t3 VSS.t45 rhigh l=3u w=0.5u
X509 VSS.t685 VSS.t521 VSS.t684 VSS.t544 sg13_lv_nmos ad=0.1075p pd=1.34u as=0 ps=0 w=0.25u l=0.5u
X510 a_8533_1799.t1 a_8939_1529.t0 VSS.t26 rhigh l=1.6u w=0.5u
X511 VSS.t225 non_inverting_amplifier_hv_0.ota_hv_slow_gmid_0.en_n.t3 non_inverting_amplifier_hv_0.ota_hv_slow_gmid_0.vamp.t11 VSS.t224 sg13_hv_nmos ad=0.114p pd=0.98u as=0.114p ps=0.98u w=0.6u l=0.45u
X512 VSS.t353 two_stage_instrumentation_amplifier_0.ota_slow_gmid_0.ota_slow_gmid_buffer_0.ibiasn.t0 VAMP.t26 VSS.t307 sg13_lv_nmos ad=0.1075p pd=1.34u as=0.1075p ps=1.34u w=0.25u l=0.5u
X513 VSS.t77 VSS.t78 VSS.t26 rhigh l=1.6u w=0.5u
X514 IOVDD.t68 IOVDD.t67 IOVDD.t68 IOVDD.t28 sg13_hv_pmos ad=0.33915p pd=2.165u as=0 ps=0 w=1.785u l=3u
X515 two_stage_instrumentation_amplifier_0.vamp1.t36 two_stage_instrumentation_amplifier_0.ota_slow_gmid_1.ota_slow_gmid_buffer_0.ibiasn.t0 VSS.t975 VSS.t941 sg13_lv_nmos ad=0.1075p pd=1.34u as=0.1075p ps=1.34u w=0.25u l=0.5u
X516 vref.t1 S2.t0 ref_selector_0.ref_selector_r_refs_0.R2.t1 VSS.t35 sg13_lv_nmos ad=1.02p pd=6.68u as=1.02p ps=6.68u w=3u l=0.13u
X517 a_n9874_4739.t0 a_n9604_4333.t0 VSS.t53 rhigh l=1.6u w=0.5u
X518 VSS.t682 VSS.t488 VSS.t681 VSS.t541 sg13_lv_nmos ad=0.1075p pd=1.34u as=0 ps=0 w=0.25u l=0.5u
X519 two_stage_instrumentation_amplifier_0.ota_slow_gmid_0.ota_slow_gmid_common_0/ota_slow_gmid_pairs_0.tail.t1 two_stage_instrumentation_amplifier_0.VP.t2 two_stage_instrumentation_amplifier_0.ota_slow_gmid_0.vota.t1 VDD.t55 sg13_lv_pmos ad=0.475p pd=2.88u as=0.85p ps=5.68u w=2.5u l=5u
X520 VSS.t352 two_stage_instrumentation_amplifier_0.ota_slow_gmid_0.ota_slow_gmid_buffer_0.ibiasn.t0 VAMP.t28 VSS.t323 sg13_lv_nmos ad=0.1075p pd=1.34u as=0.1075p ps=1.34u w=0.25u l=0.5u
X521 VAMP.t29 two_stage_instrumentation_amplifier_0.ota_slow_gmid_0.ota_slow_gmid_buffer_0.ibiasn.t0 VSS.t351 VSS.t321 sg13_lv_nmos ad=0.1075p pd=1.34u as=0.1075p ps=1.34u w=0.25u l=0.5u
X522 VSS.t398 ref_selector_0.ref_selector_r_96_0.vcal.t4 VSS.t190 rppd l=1.43u w=0.5u
X523 VSS.t679 VSS.t492 VSS.t678 VSS.t538 sg13_lv_nmos ad=0.1075p pd=1.34u as=0 ps=0 w=0.25u l=0.5u
X524 VSS.t228 non_inverting_amplifier_hv_0.ota_hv_slow_gmid_0.en_n.t4 non_inverting_amplifier_hv_0.ota_hv_slow_gmid_0.vamp.t10 VSS.t231 sg13_hv_nmos ad=0.4218p pd=2.6u as=0.4218p ps=2.6u w=2.22u l=0.45u
X525 two_stage_instrumentation_amplifier_0.vamp1.t35 two_stage_instrumentation_amplifier_0.ota_slow_gmid_1.ota_slow_gmid_buffer_0.ibiasn.t0 VSS.t974 VSS.t945 sg13_lv_nmos ad=0.1075p pd=1.34u as=0.1075p ps=1.34u w=0.25u l=0.5u
X526 a_17952_8442.t0 a_18492_7638.t0 VSS.t92 rhigh l=0.96u w=0.5u
X527 non_inverting_amplifier_hv_0.ota_hv_slow_gmid_0.ibiasn.t2 VSS.t675 VSS.t676 VSS.t202 sg13_hv_nmos ad=0.19p pd=1.38u as=0.34p ps=2.68u w=1u l=1u
X528 a_n9604_2009.t0 two_stage_instrumentation_amplifier_0.vamp1.t0 VSS.t85 rhigh l=0.96u w=0.5u
X529 current_source_1mA_0.ota_med_hv_gmid_0.ota_med_hv_gmid_mirror_0.vota.t1 current_source_1mA_0.ota_med_hv_gmid_0.ota_med_hv_gmid_mirror_0.Iref.t0 VSS.t437 VSS.t436 sg13_hv_nmos ad=0.646p pd=4.48u as=0.646p ps=4.48u w=1.9u l=2u
X530 a_17682_8968.t0 a_17412_8690.t0 VSS.t74 rhigh l=0.96u w=0.5u
X531 VSS.t483 VSS.t481 VSS.t483 VSS.t673 sg13_lv_nmos ad=0.19p pd=1.38u as=0 ps=0 w=1u l=0.13u
X532 VSS.t142 VSS.t143 VSS.t141 rppd l=3.69u w=0.5u
X533 a_8533_2609.t1 a_8939_2339.t0 VSS.t26 rhigh l=1.6u w=0.5u
X534 VSS.t973 two_stage_instrumentation_amplifier_0.ota_slow_gmid_1.ota_slow_gmid_buffer_0.ibiasn.t0 two_stage_instrumentation_amplifier_0.vamp1.t34 VSS.t943 sg13_lv_nmos ad=0.1075p pd=1.34u as=0.1075p ps=1.34u w=0.25u l=0.5u
X535 VSS.t672 VSS.t521 VSS.t671 VSS.t522 sg13_lv_nmos ad=0.1075p pd=1.34u as=0 ps=0 w=0.25u l=0.5u
X536 VSS.t80 VSS.t81 VSS.t79 rppd l=1.43u w=0.5u
X537 two_stage_instrumentation_amplifier_0.vamp1.t33 two_stage_instrumentation_amplifier_0.ota_slow_gmid_1.ota_slow_gmid_buffer_0.ibiasn.t0 VSS.t972 VSS.t941 sg13_lv_nmos ad=0.1075p pd=1.34u as=0.1075p ps=1.34u w=0.25u l=0.5u
X538 VSS.t669 VSS.t598 VSS.t668 VSS.t599 sg13_hv_nmos ad=0.34p pd=2.68u as=0 ps=0 w=1u l=1u
X539 current_source_1mA_0.current_source_1mA_2_stage_0.vcp.t4 current_source_1mA_0.current_source_1mA_2_stage_0.current_source_pass_element_0.vota.t6 current_source_1mA_0.current_source_1mA_2_stage_0.current_source_pass_element_0.iref.t9 VSS.t1067 sg13_hv_nmos ad=0.1425p pd=1.13u as=0.1425p ps=1.13u w=0.75u l=0.5u
X540 a_7631_2879.t0 a_8939_2339.t1 VSS.t26 rhigh l=1.6u w=0.5u
X541 VSS.t397 ref_selector_0.ref_selector_r_96_0.vcal.t3 VSS.t396 rppd l=1.43u w=0.5u
X542 VDD.t65 two_stage_instrumentation_amplifier_0.ota_slow_gmid_0.en.t2 VBIAS.t16 VDD.t64 sg13_lv_pmos ad=0.19p pd=1.38u as=0.34p ps=2.68u w=1u l=0.13u
X543 ota_lv_gmid_comparator_0.ota_slow_gmid_mirror_0.vout1.t9 ota_lv_gmid_comparator_0.ota_slow_gmid_ctrl_buff_1.y.t2 VDD.t233 VDD.t27 sg13_lv_pmos ad=0.27075p pd=1.805u as=0.4845p ps=3.53u w=1.425u l=0.13u
X544 a_8533_1799.t0 a_8939_2069.t0 VSS.t26 rhigh l=1.6u w=0.5u
X545 VDD.t163 VDD.t125 VDD.t162 VDD.t55 sg13_lv_pmos ad=0.34p pd=2.68u as=0 ps=0 w=1u l=0.5u
X546 VSS.t666 VSS.t492 VSS.t665 VSS.t493 sg13_lv_nmos ad=0.1075p pd=1.34u as=0 ps=0 w=0.25u l=0.5u
X547 VSS.t663 VSS.t521 VSS.t662 VSS.t522 sg13_lv_nmos ad=0.1075p pd=1.34u as=0 ps=0 w=0.25u l=0.5u
X548 VAMP.t30 two_stage_instrumentation_amplifier_0.ota_slow_gmid_0.ota_slow_gmid_buffer_0.ibiasn.t0 VSS.t350 VSS.t327 sg13_lv_nmos ad=0.1075p pd=1.34u as=0.1075p ps=1.34u w=0.25u l=0.5u
X549 VSS.t549 VSS.t547 VSS.t549 VSS.t659 sg13_lv_nmos ad=0.19p pd=1.38u as=0 ps=0 w=1u l=0.13u
X550 VDD.t160 VDD.t159 VDD.t160 VDD.t66 sg13_lv_pmos ad=0.475p pd=2.88u as=0 ps=0 w=2.5u l=2u
X551 ota_lv_gmid_comparator_0.ota_slow_gmid_mirror_0.vout1.t2 ota_lv_gmid_comparator_0.ota_slow_gmid_mirror_0.vota.t5 VSS.t450 VSS.t447 sg13_lv_nmos ad=0.17p pd=1.68u as=95f ps=0.88u w=0.5u l=10u
X552 VAMP.t31 two_stage_instrumentation_amplifier_0.ota_slow_gmid_0.ota_slow_gmid_buffer_0.ibiasn.t0 VSS.t349 VSS.t316 sg13_lv_nmos ad=0.1075p pd=1.34u as=0.1075p ps=1.34u w=0.25u l=0.5u
X553 VDD.t75 two_stage_instrumentation_amplifier_0.ota_slow_gmid_0.en.t3 VBIAS.t22 VDD.t55 sg13_lv_pmos ad=0.19p pd=1.38u as=0.34p ps=2.68u w=1u l=0.13u
X554 VSS.t217 non_inverting_amplifier_hv_0.ota_hv_slow_gmid_0.en_n.t2 non_inverting_amplifier_hv_0.ota_hv_slow_gmid_0.vamp.t6 VSS.t212 sg13_hv_nmos ad=0.7548p pd=5.12u as=0.4218p ps=2.6u w=2.22u l=0.45u
X555 current_source_1mA_0.current_source_1mA_2_stage_0.vcp.t3 current_source_1mA_0.current_source_1mA_2_stage_0.current_source_pass_element_0.vota.t6 current_source_1mA_0.current_source_1mA_2_stage_0.current_source_pass_element_0.iref.t8 VSS.t1066 sg13_hv_nmos ad=0.1425p pd=1.13u as=0.1425p ps=1.13u w=0.75u l=0.5u
X556 a_17682_6864.t0 a_17412_6586.t0 VSS.t74 rhigh l=0.96u w=0.5u
X557 a_n9604_4085.t0 two_stage_instrumentation_amplifier_0.top_conditionning_gain_s2_0.vn2.t0 VSS.t85 rhigh l=1.6u w=0.5u
X558 two_stage_instrumentation_amplifier_0.ota_slow_gmid_1.vout1.t8 two_stage_instrumentation_amplifier_0.ota_slow_gmid_1.en_n.t2 VSS.t173 VSS.t177 sg13_lv_nmos ad=0.228p pd=1.58u as=0.228p ps=1.58u w=1.2u l=0.13u
X559 VSS.t348 two_stage_instrumentation_amplifier_0.ota_slow_gmid_0.ota_slow_gmid_buffer_0.ibiasn.t0 VAMP.t19 VSS.t313 sg13_lv_nmos ad=0.1075p pd=1.34u as=0.1075p ps=1.34u w=0.25u l=0.5u
X560 VAMP.t20 two_stage_instrumentation_amplifier_0.ota_slow_gmid_0.ota_slow_gmid_buffer_0.ibiasn.t0 VSS.t347 VSS.t327 sg13_lv_nmos ad=0.1075p pd=1.34u as=0.1075p ps=1.34u w=0.25u l=0.5u
X561 VDD.t62 two_stage_instrumentation_amplifier_0.ota_slow_gmid_0.en.t2 VBIAS.t13 VDD.t63 sg13_lv_pmos ad=0.19p pd=1.38u as=0.19p ps=1.38u w=1u l=0.13u
X562 VSS.t2 VSS.t3 VSS.t1 rppd l=1.43u w=0.5u
X563 VDD.t232 ota_lv_gmid_comparator_0.ota_slow_gmid_ctrl_buff_1.y.t2 ota_lv_gmid_comparator_0.ota_slow_gmid_mirror_0.vout1.t11 VDD.t27 sg13_lv_pmos ad=0.27075p pd=1.805u as=0.27075p ps=1.805u w=1.425u l=0.13u
X564 VSS.t570 VSS.t568 VSS.t570 VSS.t657 sg13_lv_nmos ad=0.19p pd=1.38u as=0 ps=0 w=1u l=0.13u
X565 two_stage_instrumentation_amplifier_0.ota_slow_gmid_1.vout1.t7 two_stage_instrumentation_amplifier_0.ota_slow_gmid_1.en_n.t2 VSS.t171 VSS.t176 sg13_lv_nmos ad=0.228p pd=1.58u as=0.228p ps=1.58u w=1.2u l=0.13u
X566 VSS.t18 two_stage_instrumentation_amplifier_0.ota_slow_gmid_1.en_n.t3 two_stage_instrumentation_amplifier_0.ota_slow_gmid_1.vout1.t1 VSS.t17 sg13_lv_nmos ad=0.228p pd=1.58u as=0.228p ps=1.58u w=1.2u l=0.13u
X567 non_inverting_amplifier_hv_0.ota_hv_slow_gmid_0.ibiasn.t1 VBIASH.t19 IOVDD.t225 IOVDD.t3 sg13_hv_pmos ad=0.34p pd=2.68u as=0.19p ps=1.38u w=1u l=0.5u
X568 VSS.t656 VSS.t500 VSS.t655 VSS.t501 sg13_hv_nmos ad=0.34p pd=2.68u as=0 ps=0 w=1u l=1u
X569 VSS.t570 VSS.t568 VSS.t570 VSS.t652 sg13_lv_nmos ad=0.19p pd=1.38u as=0 ps=0 w=1u l=0.13u
X570 two_stage_instrumentation_amplifier_0.ota_slow_gmid_1.vout1.t6 two_stage_instrumentation_amplifier_0.ota_slow_gmid_1.en_n.t3 VSS.t16 VSS.t15 sg13_lv_nmos ad=0.408p pd=3.08u as=0.228p ps=1.58u w=1.2u l=0.13u
X571 VSS.t971 two_stage_instrumentation_amplifier_0.ota_slow_gmid_1.ota_slow_gmid_buffer_0.ibiasn.t0 two_stage_instrumentation_amplifier_0.vamp1.t32 VSS.t937 sg13_lv_nmos ad=0.1075p pd=1.34u as=0.1075p ps=1.34u w=0.25u l=0.5u
X572 VSS.t651 VSS.t496 VSS.t650 VSS.t514 sg13_lv_nmos ad=0.1075p pd=1.34u as=0 ps=0 w=0.25u l=0.5u
X573 two_stage_instrumentation_amplifier_0.vamp1.t31 two_stage_instrumentation_amplifier_0.ota_slow_gmid_1.ota_slow_gmid_buffer_0.ibiasn.t0 VSS.t970 VSS.t935 sg13_lv_nmos ad=0.1075p pd=1.34u as=0.1075p ps=1.34u w=0.25u l=0.5u
X574 VBIAS.t21 two_stage_instrumentation_amplifier_0.ota_slow_gmid_0.en.t3 VDD.t71 VDD.t55 sg13_lv_pmos ad=0.19p pd=1.38u as=0.19p ps=1.38u w=1u l=0.13u
X575 IOVDD.t117 IOVDD.t92 IOVDD.t116 IOVDD.t3 sg13_hv_pmos ad=0.34p pd=2.68u as=0 ps=0 w=1u l=0.5u
X576 VSS.t648 VSS.t496 VSS.t647 VSS.t511 sg13_lv_nmos ad=0.1075p pd=1.34u as=0 ps=0 w=0.25u l=0.5u
X577 VDD.t100 VBIAS.t34 two_stage_instrumentation_amplifier_0.ota_slow_gmid_0.vout1.t18 VDD.t55 sg13_lv_pmos ad=0.19p pd=1.38u as=0.34p ps=2.68u w=1u l=0.5u
X578 VDD.t138 VDD.t137 VDD.t138 VDD.t55 sg13_lv_pmos ad=0.475p pd=2.88u as=0 ps=0 w=2.5u l=2u
X579 VSS.t645 VSS.t557 VSS.t559 VSS.t643 sg13_lv_nmos ad=0.34p pd=2.68u as=0 ps=0 w=1u l=0.13u
X580 a_8533_719.t0 a_8939_989.t1 VSS.t54 rhigh l=1.6u w=0.5u
X581 a_18492_7390.t0 a_18222_7112.t1 VSS.t92 rhigh l=0.96u w=0.5u
X582 a_n9604_3431.t1 a_n9334_3025.t0 VSS.t85 rhigh l=1.6u w=0.5u
X583 IOVDD.t39 current_source_1mA_0.current_source_1mA_2_stage_0.current_source_pass_element_0.iref.t4 current_source_1mA_0.current_source_1mA_2_stage_0.current_source_pass_element_0.iref.t5 IOVDD.t31 sg13_hv_pmos ad=0.285p pd=1.88u as=0.51p ps=3.68u w=1.5u l=0.5u
X584 VSS.t642 VSS.t492 VSS.t641 VSS.t640 sg13_lv_nmos ad=0.1075p pd=1.34u as=0 ps=0 w=0.25u l=0.5u
X585 dw_n7292_5488.t5 two_stage_instrumentation_amplifier_0.ota_slow_gmid_0.vota.t7 dw_n7292_5488.t4 dw_n7292_5488.t3 sg13_lv_pmos ad=1.02p pd=6.68u as=0 ps=0 w=3u l=3u
X586 VAMP.t21 two_stage_instrumentation_amplifier_0.ota_slow_gmid_0.ota_slow_gmid_buffer_0.ibiasn.t0 VSS.t346 VSS.t316 sg13_lv_nmos ad=0.1075p pd=1.34u as=0.1075p ps=1.34u w=0.25u l=0.5u
X587 VAMP.t41 two_stage_instrumentation_amplifier_0.ota_slow_gmid_0.ota_slow_gmid_buffer_0.ibiasn.t0 VSS.t345 VSS.t311 sg13_lv_nmos ad=0.1075p pd=1.34u as=0.1075p ps=1.34u w=0.25u l=0.5u
X588 two_stage_instrumentation_amplifier_0.ota_slow_gmid_1.ota_slow_gmid_common_0/ota_slow_gmid_pairs_0.tail.t0 vref.t7 two_stage_instrumentation_amplifier_0.ota_slow_gmid_1.vota.t3 VDD.t0 sg13_lv_pmos ad=0.475p pd=2.88u as=0.85p ps=5.68u w=2.5u l=5u
X589 a_17952_7916.t0 a_17682_7638.t1 VSS.t132 rhigh l=0.96u w=0.5u
X590 a_n9334_2535.t0 a_n9064_2009.t1 VSS.t4 rhigh l=0.96u w=0.5u
X591 ota_lv_gmid_comparator_0.ota_slow_gmid_ctrl_buff_0.x.t2 ota_lv_gmid_comparator_0.ota_slow_gmid_mirror_0.vout1.t15 a_2485_3315.t5 VDD.t54 sg13_lv_pmos ad=0.2375p pd=1.63u as=0.425p ps=3.18u w=1.25u l=0.13u
X592 a_19302_8442.t1 a_19032_8164.t1 VSS.t47 rhigh l=0.96u w=0.5u
X593 VSS.t243 non_inverting_amplifier_hv_0.ota_hv_slow_gmid_0.en_n.t7 non_inverting_amplifier_hv_0.ota_hv_slow_gmid_0.vamp.t9 VSS.t241 sg13_hv_nmos ad=0.114p pd=0.98u as=0.204p ps=1.88u w=0.6u l=0.45u
X594 VSS.t344 two_stage_instrumentation_amplifier_0.ota_slow_gmid_0.ota_slow_gmid_buffer_0.ibiasn.t0 VAMP.t44 VSS.t313 sg13_lv_nmos ad=0.1075p pd=1.34u as=0.1075p ps=1.34u w=0.25u l=0.5u
X595 dw_n18308_4910.t8 two_stage_instrumentation_amplifier_0.ota_slow_gmid_1.vota.t6 dw_n18308_4910.t7 dw_n18308_4910.t1 sg13_lv_pmos ad=1.02p pd=6.68u as=0 ps=0 w=3u l=3u
X596 two_stage_instrumentation_amplifier_0.ota_slow_gmid_0.vout1.t17 VBIAS.t34 VDD.t101 VDD.t55 sg13_lv_pmos ad=0.34p pd=2.68u as=0.19p ps=1.38u w=1u l=0.5u
X597 a_n5418_4249.t1 a_n4832_4529.t0 VSS.t91 rhigh l=2.5u w=0.5u
X598 VSS.t559 VSS.t557 VSS.t559 VSS.t638 sg13_lv_nmos ad=0.19p pd=1.38u as=0 ps=0 w=1u l=0.13u
X599 IOVDD.t9 non_inverting_amplifier_hv_0.ota_hv_slow_gmid_0.vamp.t24 VOUT.t3 VSS.t204 sg13_hv_nmos ad=0.19p pd=1.38u as=0.19p ps=1.38u w=1u l=1u
X600 COMPARATOR_RES.t0 ota_lv_gmid_comparator_0.ota_slow_gmid_ctrl_buff_0.ota_slow_gmid_ctrl_inv_0.x.t2 VSS.t90 VSS.t89 sg13_lv_nmos ad=0.68p pd=4.68u as=0.68p ps=4.68u w=2u l=0.13u
X601 VDD.t156 VDD.t140 VDD.t156 VDD.t27 sg13_lv_pmos ad=0.475p pd=2.88u as=0 ps=0 w=2.5u l=2u
X602 VDD.t85 two_stage_instrumentation_amplifier_0.ota_slow_gmid_0.vout1.t19 VAMP.t0 VSS.t423 sg13_lv_nmos ad=0.19p pd=1.38u as=0.19p ps=1.38u w=1u l=0.13u
X603 VSS.t75 VSS.t76 VSS.t55 rhigh l=0.96u w=0.5u
X604 VOUT.t4 non_inverting_amplifier_hv_0.ota_hv_slow_gmid_0.vamp.t24 IOVDD.t10 VSS.t203 sg13_hv_nmos ad=0.34p pd=2.68u as=0.19p ps=1.38u w=1u l=1u
X605 top_conditionning_level_shifter_0.EN_HV.t1 top_conditionning_level_shifter_0.top_conditionning_inverter_0.X.t3 VSS.t37 VSS.t36 sg13_hv_nmos ad=0.408p pd=3.08u as=0.408p ps=3.08u w=1.2u l=0.45u
X606 ref_selector_0.VMIN.t6 VSS.t394 VSS.t48 rppd l=1.43u w=0.5u
X607 VDD.t154 VDD.t152 VDD.t153 VDD.t9 sg13_lv_pmos ad=0.85p pd=5.68u as=0 ps=0 w=2.5u l=2u
X608 VSS.t637 VSS.t496 VSS.t636 VSS.t514 sg13_lv_nmos ad=0.1075p pd=1.34u as=0 ps=0 w=0.25u l=0.5u
X609 VSS.t441 VSS.t442 VSS.t440 rppd l=1.43u w=0.5u
X610 VSS.t216 non_inverting_amplifier_hv_0.ota_hv_slow_gmid_0.en_n.t2 non_inverting_amplifier_hv_0.ota_hv_slow_gmid_0.vamp.t8 VSS.t212 sg13_hv_nmos ad=0.4218p pd=2.6u as=0.4218p ps=2.6u w=2.22u l=0.45u
X611 VBIAS.t26 ota_lv_gmid_comparator_0.ota_slow_gmid_ctrl_buff_1.y.t3 VDD.t247 VDD.t108 sg13_lv_pmos ad=0.27075p pd=1.805u as=0.27075p ps=1.805u w=1.425u l=0.13u
X612 ref_selector_0.ref_selector_r_96_0.vcal.t1 VSS.t140 VSS.t139 rppd l=1.43u w=0.5u
X613 VDD.t151 VDD.t149 VDD.t150 VDD.t0 sg13_lv_pmos ad=0.34p pd=2.68u as=0 ps=0 w=1u l=0.5u
X614 VSS.t969 two_stage_instrumentation_amplifier_0.ota_slow_gmid_1.ota_slow_gmid_buffer_0.ibiasn.t0 two_stage_instrumentation_amplifier_0.vamp1.t30 VSS.t932 sg13_lv_nmos ad=0.1075p pd=1.34u as=0.1075p ps=1.34u w=0.25u l=0.5u
X615 VDD.t246 ota_lv_gmid_comparator_0.ota_slow_gmid_ctrl_buff_1.y.t3 VBIAS.t28 VDD.t108 sg13_lv_pmos ad=0.27075p pd=1.805u as=0.27075p ps=1.805u w=1.425u l=0.13u
X616 VAMP.t46 two_stage_instrumentation_amplifier_0.ota_slow_gmid_0.ota_slow_gmid_buffer_0.ibiasn.t0 VSS.t343 VSS.t311 sg13_lv_nmos ad=0.1075p pd=1.34u as=0.1075p ps=1.34u w=0.25u l=0.5u
X617 two_stage_instrumentation_amplifier_0.vamp1.t29 two_stage_instrumentation_amplifier_0.ota_slow_gmid_1.ota_slow_gmid_buffer_0.ibiasn.t0 VSS.t968 VSS.t927 sg13_lv_nmos ad=0.1075p pd=1.34u as=0.1075p ps=1.34u w=0.25u l=0.5u
X618 VSS.t342 two_stage_instrumentation_amplifier_0.ota_slow_gmid_0.ota_slow_gmid_buffer_0.ibiasn.t0 two_stage_instrumentation_amplifier_0.ota_slow_gmid_0.ota_slow_gmid_buffer_0.ibiasn.t2 VSS.t309 sg13_lv_nmos ad=0.1075p pd=1.34u as=0.1075p ps=1.34u w=0.25u l=0.5u
X619 VBIAS.t4 two_stage_instrumentation_amplifier_0.ota_slow_gmid_1.en.t2 VDD.t10 VDD.t9 sg13_lv_pmos ad=0.19p pd=1.38u as=0.19p ps=1.38u w=1u l=0.13u
X620 a_18222_8968.t1 a_18492_8690.t0 VSS.t92 rhigh l=0.96u w=0.5u
X621 VBIASH.t11 non_inverting_amplifier_hv_0.ota_hv_slow_gmid_0.en.t2 IOVDD.t195 IOVDD.t28 sg13_hv_pmos ad=62.69999f pd=0.71u as=62.69999f ps=0.71u w=0.33u l=0.4u
X622 VSS.t1021 VSS.t1022 VSS.t55 rhigh l=1.6u w=0.5u
X623 VSS.t341 two_stage_instrumentation_amplifier_0.ota_slow_gmid_0.ota_slow_gmid_buffer_0.ibiasn.t0 VAMP.t22 VSS.t307 sg13_lv_nmos ad=0.1075p pd=1.34u as=0.1075p ps=1.34u w=0.25u l=0.5u
X624 ref_selector_0.ref_selector_r_96_0.vcal.t8 SEL_CAL.t0 two_stage_instrumentation_amplifier_0.VP.t1 VSS.t211 sg13_lv_nmos ad=0.95p pd=5.38u as=1.7p ps=10.68u w=5u l=0.13u
X625 VSS.t175 two_stage_instrumentation_amplifier_0.ota_slow_gmid_1.en_n.t2 two_stage_instrumentation_amplifier_0.ota_slow_gmid_1.vout1.t5 VSS.t174 sg13_lv_nmos ad=0.228p pd=1.58u as=0.408p ps=3.08u w=1.2u l=0.13u
X626 VBIAS.t3 two_stage_instrumentation_amplifier_0.ota_slow_gmid_1.en.t2 VDD.t6 VDD.t8 sg13_lv_pmos ad=0.19p pd=1.38u as=0.19p ps=1.38u w=1u l=0.13u
X627 VSS.t634 VSS.t488 VSS.t633 VSS.t489 sg13_lv_nmos ad=0.1075p pd=1.34u as=0 ps=0 w=0.25u l=0.5u
X628 a_7225_2609.t0 a_7631_2879.t1 VSS.t6 rhigh l=1.6u w=0.5u
X629 VSS.t549 VSS.t547 VSS.t549 VSS.t630 sg13_lv_nmos ad=0.19p pd=1.38u as=0 ps=0 w=1u l=0.13u
X630 VSS.t14 two_stage_instrumentation_amplifier_0.ota_slow_gmid_1.en_n.t3 two_stage_instrumentation_amplifier_0.ota_slow_gmid_1.vout1.t4 VSS.t13 sg13_lv_nmos ad=0.228p pd=1.58u as=0.408p ps=3.08u w=1.2u l=0.13u
X631 VSS.t629 VSS.t550 VSS.t628 VSS.t551 sg13_hv_nmos ad=1.4535p pd=9.23u as=0 ps=0 w=4.275u l=4u
X632 VSS.t626 VSS.t623 VSS.t625 VSS.t624 sg13_hv_nmos ad=0.646p pd=4.48u as=0 ps=0 w=1.9u l=2u
X633 IOVDD.t38 current_source_1mA_0.current_source_1mA_2_stage_0.current_source_pass_element_0.iref.t4 ref_selector_0.I1MA.t4 IOVDD.t31 sg13_hv_pmos ad=0.285p pd=1.88u as=0.51p ps=3.68u w=1.5u l=0.5u
X634 ref_selector_0.VMIN.t19 VSS.t1073 VSS.t139 rppd l=1.43u w=0.5u
X635 ota_lv_gmid_comparator_0.ota_slow_gmid_mirror_0.vout1.t10 ota_lv_gmid_comparator_0.ota_slow_gmid_ctrl_buff_1.y.t2 VDD.t231 VDD.t27 sg13_lv_pmos ad=0.4845p pd=3.53u as=0.27075p ps=1.805u w=1.425u l=0.13u
X636 a_n4832_4529.t1 a_n4533_4821.t1 VSS.t1072 rhigh l=3u w=0.5u
X637 VDD.t148 VDD.t125 VDD.t147 VDD.t55 sg13_lv_pmos ad=0.34p pd=2.68u as=0 ps=0 w=1u l=0.5u
X638 VSS.t622 VSS.t521 VSS.t621 VSS.t544 sg13_lv_nmos ad=0.1075p pd=1.34u as=0 ps=0 w=0.25u l=0.5u
X639 VSS.t967 two_stage_instrumentation_amplifier_0.ota_slow_gmid_1.ota_slow_gmid_buffer_0.ibiasn.t0 two_stage_instrumentation_amplifier_0.vamp1.t28 VSS.t929 sg13_lv_nmos ad=0.1075p pd=1.34u as=0.1075p ps=1.34u w=0.25u l=0.5u
X640 a_18222_6864.t0 a_18492_6586.t0 VSS.t92 rhigh l=0.96u w=0.5u
X641 a_17412_8442.t1 a_17682_8164.t1 VSS.t74 rhigh l=0.96u w=0.5u
X642 two_stage_instrumentation_amplifier_0.ota_slow_gmid_0.vout1.t9 two_stage_instrumentation_amplifier_0.ota_slow_gmid_0.en_n.t2 VSS.t267 VSS.t269 sg13_lv_nmos ad=0.228p pd=1.58u as=0.228p ps=1.58u w=1.2u l=0.13u
X643 a_17952_7390.t1 a_17682_7112.t1 VSS.t132 rhigh l=0.96u w=0.5u
X644 VBIASH.t10 non_inverting_amplifier_hv_0.ota_hv_slow_gmid_0.en.t3 IOVDD.t203 IOVDD.t3 sg13_hv_pmos ad=62.69999f pd=0.71u as=62.69999f ps=0.71u w=0.33u l=0.4u
X645 VBIAS.t2 two_stage_instrumentation_amplifier_0.ota_slow_gmid_1.en.t2 VDD.t4 VDD.t0 sg13_lv_pmos ad=0.34p pd=2.68u as=0.19p ps=1.38u w=1u l=0.13u
X646 VDD.t21 two_stage_instrumentation_amplifier_0.ota_slow_gmid_1.en.t3 VBIAS.t8 VDD.t0 sg13_lv_pmos ad=0.19p pd=1.38u as=0.19p ps=1.38u w=1u l=0.13u
X647 VSS.t186 VSS.t187 VSS.t55 rhigh l=1.6u w=0.5u
X648 VDD.t242 ota_lv_gmid_comparator_0.ota_slow_gmid_ctrl_buff_1.y.t3 VBIAS.t27 VDD.t108 sg13_lv_pmos ad=0.27075p pd=1.805u as=0.27075p ps=1.805u w=1.425u l=0.13u
X649 two_stage_instrumentation_amplifier_0.vamp1.t27 two_stage_instrumentation_amplifier_0.ota_slow_gmid_1.ota_slow_gmid_buffer_0.ibiasn.t0 VSS.t966 VSS.t927 sg13_lv_nmos ad=0.1075p pd=1.34u as=0.1075p ps=1.34u w=0.25u l=0.5u
X650 ref_selector_0.VMIN.t11 vref.t5 VSS.t890 rppd l=1.43u w=0.5u
X651 a_7879_2609.t0 ref_selector_0.ref_selector_r_refs_0.R2.t0 VSS.t251 rhigh l=1.6u w=0.5u
X652 VSS.t340 two_stage_instrumentation_amplifier_0.ota_slow_gmid_0.ota_slow_gmid_buffer_0.ibiasn.t0 VAMP.t12 VSS.t305 sg13_lv_nmos ad=0.1075p pd=1.34u as=0.1075p ps=1.34u w=0.25u l=0.5u
X653 VDD.t51 a_5221_5436.t1 VSS.t252 rhigh l=2.5u w=0.5u
X654 VSS.t619 VSS.t492 VSS.t618 VSS.t538 sg13_lv_nmos ad=0.1075p pd=1.34u as=0 ps=0 w=0.25u l=0.5u
X655 VSS.t1019 VSS.t1020 VSS.t1018 rhigh l=1.6u w=0.5u
X656 a_n4253_5507.t1 a_n2210_4821.t1 VSS.t908 rhigh l=3u w=0.5u
X657 a_n17989_4249.t1 a_n17403_4529.t1 VSS.t922 rhigh l=2.5u w=0.5u
X658 VSS.t616 VSS.t488 VSS.t615 VSS.t554 sg13_lv_nmos ad=0.1075p pd=1.34u as=0 ps=0 w=0.25u l=0.5u
X659 IOVDD.t114 IOVDD.t89 IOVDD.t114 IOVDD.t18 sg13_hv_pmos ad=0.5586p pd=3.32u as=0 ps=0 w=2.94u l=1u
X660 VSS.t466 VSS.t467 VSS.t7 rhigh l=1.6u w=0.5u
X661 current_source_1mA_0.current_source_1mA_2_stage_0.current_source_pass_element_0.iref.t8 current_source_1mA_0.current_source_1mA_2_stage_0.current_source_pass_element_0.vota.t6 current_source_1mA_0.current_source_1mA_2_stage_0.vcp.t4 VSS.t1065 sg13_hv_nmos ad=0.1425p pd=1.13u as=0.1425p ps=1.13u w=0.75u l=0.5u
X662 VSS.t1062 VSS.t1063 VSS.t7 rhigh l=1.6u w=0.5u
X663 ota_lv_gmid_comparator_0.ota_slow_gmid_ctrl_buff_0.x.t0 ota_lv_gmid_comparator_0.ota_slow_gmid_mirror_0.vout1.t15 a_2485_3315.t4 VDD.t54 sg13_lv_pmos ad=0.2375p pd=1.63u as=0.2375p ps=1.63u w=1.25u l=0.13u
X664 VSS.t613 VSS.t521 VSS.t612 VSS.t611 sg13_lv_nmos ad=0.1075p pd=1.34u as=0 ps=0 w=0.25u l=0.5u
X665 IOVDD.t99 IOVDD.t92 IOVDD.t99 IOVDD.t3 sg13_hv_pmos ad=0.19p pd=1.38u as=0 ps=0 w=1u l=0.5u
X666 two_stage_instrumentation_amplifier_0.vamp1.t26 two_stage_instrumentation_amplifier_0.ota_slow_gmid_1.ota_slow_gmid_buffer_0.ibiasn.t0 VSS.t965 VSS.t941 sg13_lv_nmos ad=0.1075p pd=1.34u as=0.1075p ps=1.34u w=0.25u l=0.5u
X667 VBIAS.t24 ota_lv_gmid_comparator_0.ota_slow_gmid_ctrl_buff_1.y.t3 VDD.t244 VDD.t108 sg13_lv_pmos ad=0.27075p pd=1.805u as=0.27075p ps=1.805u w=1.425u l=0.13u
X668 a_6571_989.t1 a_6977_719.t0 VSS.t167 rhigh l=1.6u w=0.5u
X669 a_18762_7916.t0 a_18222_7638.t0 VSS.t192 rhigh l=0.96u w=0.5u
X670 VDD.t93 VBIAS.t33 ota_lv_gmid_comparator_0.ota_slow_gmid_mirror_0.vout1.t4 VDD.t54 sg13_lv_pmos ad=0.19p pd=1.38u as=0.34p ps=2.68u w=1u l=0.5u
X671 current_source_1mA_0.current_source_1mA_2_stage_0.current_source_pass_element_0.vota.t4 current_source_1mA_0.ota_med_hv_gmid_0.ota_med_hv_gmid_mirror_0.vota.t5 VSS.t403 VSS.t402 sg13_hv_nmos ad=0.646p pd=4.48u as=0.646p ps=4.48u w=1.9u l=2u
X672 VSS.t339 two_stage_instrumentation_amplifier_0.ota_slow_gmid_0.ota_slow_gmid_buffer_0.ibiasn.t0 two_stage_instrumentation_amplifier_0.ota_slow_gmid_0.ota_slow_gmid_buffer_0.ibiasn.t1 VSS.t323 sg13_lv_nmos ad=0.1075p pd=1.34u as=0.1075p ps=1.34u w=0.25u l=0.5u
X673 two_stage_instrumentation_amplifier_0.vamp1.t25 two_stage_instrumentation_amplifier_0.ota_slow_gmid_1.ota_slow_gmid_buffer_0.ibiasn.t0 VSS.t964 VSS.t945 sg13_lv_nmos ad=0.1075p pd=1.34u as=0.1075p ps=1.34u w=0.25u l=0.5u
X674 a_9187_719.t0 a_8939_2069.t1 VSS.t82 rhigh l=1.6u w=0.5u
X675 ota_lv_gmid_comparator_0.ota_slow_gmid_ctrl_buff_0.x.t5 ota_lv_gmid_comparator_0.ota_slow_gmid_mirror_0.vout1.t15 a_2285_1463.t12 VSS.t255 sg13_lv_nmos ad=0.38p pd=2.38u as=0.68p ps=4.68u w=2u l=0.13u
X676 IOVDD.t225 VBIASH.t19 non_inverting_amplifier_hv_0.ota_hv_slow_gmid_0.vamp.t22 IOVDD.t3 sg13_hv_pmos ad=0.19p pd=1.38u as=0.34p ps=2.68u w=1u l=0.5u
X677 VSS.t963 two_stage_instrumentation_amplifier_0.ota_slow_gmid_1.ota_slow_gmid_buffer_0.ibiasn.t0 two_stage_instrumentation_amplifier_0.vamp1.t24 VSS.t939 sg13_lv_nmos ad=0.1075p pd=1.34u as=0.1075p ps=1.34u w=0.25u l=0.5u
X678 current_source_1mA_0.ota_med_hv_gmid_0.ota_med_hv_gmid_mirror_0.Iref.t4 current_source_1mA_0.current_source_1mA_2_stage_0.vcp.t7 current_source_1mA_0.ota_med_hv_gmid_0.ota_med_hv_gmid_tail_0.tail.t1 IOVDD.t0 sg13_hv_pmos ad=0.9996p pd=6.56u as=0.5586p ps=3.32u w=2.94u l=1u
X679 VSS.t610 VSS.t521 VSS.t609 VSS.t522 sg13_lv_nmos ad=0.1075p pd=1.34u as=0 ps=0 w=0.25u l=0.5u
X680 VDD.t145 VDD.t115 VDD.t144 VDD.t55 sg13_lv_pmos ad=0.34p pd=2.68u as=0 ps=0 w=1u l=0.5u
X681 a_n9604_2009.t1 two_stage_instrumentation_amplifier_0.ota_slow_gmid_1.VN.t1 VSS.t63 rhigh l=0.96u w=0.5u
X682 a_7879_719.t1 ref_selector_0.VMIN.t13 VSS.t31 rhigh l=1.6u w=0.5u
X683 a_17682_8968.t1 a_17952_8690.t1 VSS.t132 rhigh l=0.96u w=0.5u
X684 two_stage_instrumentation_amplifier_0.ota_slow_gmid_0.ota_slow_gmid_common_0/ota_slow_gmid_pairs_0.tail.t3 VBIAS.t34 VDD.t100 VDD.t55 sg13_lv_pmos ad=0.34p pd=2.68u as=0.19p ps=1.38u w=1u l=0.5u
X685 VSS.t607 VSS.t488 VSS.t606 VSS.t554 sg13_lv_nmos ad=0.1075p pd=1.34u as=0 ps=0 w=0.25u l=0.5u
X686 VOUT.t3 non_inverting_amplifier_hv_0.ota_hv_slow_gmid_0.vamp.t24 IOVDD.t8 VSS.t202 sg13_hv_nmos ad=0.19p pd=1.38u as=0.34p ps=2.68u w=1u l=1u
X687 VSS.t895 VSS.t896 VSS.t198 rppd l=1.43u w=0.5u
X688 VDD.t40 ota_lv_gmid_comparator_0.ota_slow_gmid_ctrl_buff_0.x.t6 a_2285_1463.t6 VSS.t110 sg13_lv_nmos ad=0.10085p pd=1.34u as=55.85f ps=0.74u w=0.155u l=0.5u
X689 two_stage_instrumentation_amplifier_0.vamp1.t23 two_stage_instrumentation_amplifier_0.ota_slow_gmid_1.ota_slow_gmid_buffer_0.ibiasn.t0 VSS.t962 VSS.t935 sg13_lv_nmos ad=0.1075p pd=1.34u as=0.1075p ps=1.34u w=0.25u l=0.5u
X690 VDD.t142 VDD.t140 VDD.t141 VDD.t27 sg13_lv_pmos ad=0.85p pd=5.68u as=0 ps=0 w=2.5u l=2u
X691 VAMP.t13 two_stage_instrumentation_amplifier_0.ota_slow_gmid_0.ota_slow_gmid_buffer_0.ibiasn.t0 VSS.t338 VSS.t321 sg13_lv_nmos ad=0.1075p pd=1.34u as=0.1075p ps=1.34u w=0.25u l=0.5u
X692 a_2285_1463.t0 ota_lv_gmid_comparator_0.ota_slow_gmid_mirror_0.vout1.t16 VSS.t259 VSS.t258 sg13_lv_nmos ad=55.85f pd=0.74u as=0.10085p ps=1.34u w=0.155u l=0.5u
X693 VSS.t1061 ref_selector_0.ref_selector_r_96_0.vcal.t12 VSS.t445 rppd l=1.43u w=0.5u
X694 VSS.t229 non_inverting_amplifier_hv_0.ota_hv_slow_gmid_0.en_n.t4 non_inverting_amplifier_hv_0.ota_hv_slow_gmid_0.vamp.t0 VSS.t222 sg13_hv_nmos ad=0.4218p pd=2.6u as=0.4218p ps=2.6u w=2.22u l=0.45u
X695 VSS.t604 VSS.t550 VSS.t603 VSS.t551 sg13_hv_nmos ad=1.4535p pd=9.23u as=0 ps=0 w=4.275u l=4u
X696 VBIAS.t15 two_stage_instrumentation_amplifier_0.ota_slow_gmid_0.en.t2 VDD.t62 VDD.t61 sg13_lv_pmos ad=0.19p pd=1.38u as=0.19p ps=1.38u w=1u l=0.13u
X697 a_17682_6864.t1 a_17952_6586.t1 VSS.t132 rhigh l=0.96u w=0.5u
X698 two_stage_instrumentation_amplifier_0.vamp1.t22 two_stage_instrumentation_amplifier_0.ota_slow_gmid_1.ota_slow_gmid_buffer_0.ibiasn.t0 VSS.t961 VSS.t960 sg13_lv_nmos ad=0.1075p pd=1.34u as=0.1075p ps=1.34u w=0.25u l=0.5u
X699 a_n9064_1483.t1 a_n9334_1205.t1 VSS.t926 rhigh l=0.96u w=0.5u
X700 VSS.t601 VSS.t598 VSS.t600 VSS.t599 sg13_hv_nmos ad=0.34p pd=2.68u as=0 ps=0 w=1u l=1u
X701 two_stage_instrumentation_amplifier_0.ota_slow_gmid_0.vout1.t8 two_stage_instrumentation_amplifier_0.ota_slow_gmid_0.en_n.t2 VSS.t265 VSS.t268 sg13_lv_nmos ad=0.228p pd=1.58u as=0.228p ps=1.58u w=1.2u l=0.13u
X702 a_n9604_4085.t1 two_stage_instrumentation_amplifier_0.vamp1.t62 VSS.t63 rhigh l=1.6u w=0.5u
X703 VDD.t20 two_stage_instrumentation_amplifier_0.ota_slow_gmid_1.en.t3 VBIAS.t7 VDD.t0 sg13_lv_pmos ad=0.19p pd=1.38u as=0.19p ps=1.38u w=1u l=0.13u
X704 IOVDD.t205 non_inverting_amplifier_hv_0.ota_hv_slow_gmid_0.en.t3 VBIASH.t10 IOVDD.t3 sg13_hv_pmos ad=62.69999f pd=0.71u as=62.69999f ps=0.71u w=0.33u l=0.4u
X705 VDD.t139 VDD.t137 VDD.t138 VDD.t55 sg13_lv_pmos ad=0.85p pd=5.68u as=0 ps=0 w=2.5u l=2u
X706 IOVDD.t93 IOVDD.t92 IOVDD.t93 IOVDD.t3 sg13_hv_pmos ad=0.19p pd=1.38u as=0 ps=0 w=1u l=0.5u
X707 two_stage_instrumentation_amplifier_0.ota_slow_gmid_0.vout1.t14 two_stage_instrumentation_amplifier_0.ota_slow_gmid_0.en_n.t4 VSS.t282 VSS.t287 sg13_lv_nmos ad=0.228p pd=1.58u as=0.228p ps=1.58u w=1.2u l=0.13u
X708 VDD.t98 VBIAS.t34 two_stage_instrumentation_amplifier_0.ota_slow_gmid_0.ota_slow_gmid_common_0/ota_slow_gmid_pairs_0.tail.t2 VDD.t55 sg13_lv_pmos ad=0.19p pd=1.38u as=0.34p ps=2.68u w=1u l=0.5u
X709 VSS.t959 two_stage_instrumentation_amplifier_0.ota_slow_gmid_1.ota_slow_gmid_buffer_0.ibiasn.t0 two_stage_instrumentation_amplifier_0.vamp1.t21 VSS.t932 sg13_lv_nmos ad=0.1075p pd=1.34u as=0.1075p ps=1.34u w=0.25u l=0.5u
X710 ref_selector_0.VMIN.t12 VSS.t919 VSS.t918 rppd l=1.43u w=0.5u
X711 a_2285_1463.t1 ota_lv_gmid_comparator_0.ota_slow_gmid_ctrl_buff_0.x.t6 VDD.t34 VSS.t109 sg13_lv_nmos ad=55.85f pd=0.74u as=55.85f ps=0.74u w=0.155u l=0.5u
X712 VSS.t920 VSS.t921 VSS.t388 rhigh l=2.5u w=0.5u
X713 a_n1930_5507.t1 a_n1031_4249.t1 VSS.t468 rhigh l=2.5u w=0.5u
X714 VSS.t286 two_stage_instrumentation_amplifier_0.ota_slow_gmid_0.en_n.t4 two_stage_instrumentation_amplifier_0.ota_slow_gmid_0.vout1.t13 VSS.t285 sg13_lv_nmos ad=0.228p pd=1.58u as=0.228p ps=1.58u w=1.2u l=0.13u
X715 VBIASH.t9 non_inverting_amplifier_hv_0.ota_hv_slow_gmid_0.en.t3 IOVDD.t204 IOVDD.t3 sg13_hv_pmos ad=62.69999f pd=0.71u as=0.1122p ps=1.34u w=0.33u l=0.4u
X716 VSS.t958 two_stage_instrumentation_amplifier_0.ota_slow_gmid_1.ota_slow_gmid_buffer_0.ibiasn.t0 two_stage_instrumentation_amplifier_0.vamp1.t20 VSS.t943 sg13_lv_nmos ad=0.1075p pd=1.34u as=0.1075p ps=1.34u w=0.25u l=0.5u
X717 VAMP.t14 two_stage_instrumentation_amplifier_0.ota_slow_gmid_0.ota_slow_gmid_buffer_0.ibiasn.t0 VSS.t337 VSS.t316 sg13_lv_nmos ad=0.1075p pd=1.34u as=0.1075p ps=1.34u w=0.25u l=0.5u
X718 IOVDD.t37 current_source_1mA_0.current_source_1mA_2_stage_0.current_source_pass_element_0.iref.t4 vref.t2 IOVDD.t31 sg13_hv_pmos ad=0.285p pd=1.88u as=0.51p ps=3.68u w=1.5u l=0.5u
X719 VSS.t336 two_stage_instrumentation_amplifier_0.ota_slow_gmid_0.ota_slow_gmid_buffer_0.ibiasn.t0 VAMP.t15 VSS.t307 sg13_lv_nmos ad=0.1075p pd=1.34u as=0.1075p ps=1.34u w=0.25u l=0.5u
X720 VBIAS.t14 two_stage_instrumentation_amplifier_0.ota_slow_gmid_0.en.t2 VDD.t57 VDD.t55 sg13_lv_pmos ad=0.34p pd=2.68u as=0.19p ps=1.38u w=1u l=0.13u
X721 VSS.t213 non_inverting_amplifier_hv_0.ota_hv_slow_gmid_0.en_n.t2 non_inverting_amplifier_hv_0.ota_hv_slow_gmid_0.vamp.t7 VSS.t212 sg13_hv_nmos ad=0.4218p pd=2.6u as=0.4218p ps=2.6u w=2.22u l=0.45u
X722 a_2285_1463.t5 ota_lv_gmid_comparator_0.ota_slow_gmid_ctrl_buff_0.x.t6 VDD.t37 VSS.t108 sg13_lv_nmos ad=55.85f pd=0.74u as=55.85f ps=0.74u w=0.155u l=0.5u
X723 VSS.t597 VSS.t488 VSS.t596 VSS.t489 sg13_lv_nmos ad=0.1075p pd=1.34u as=0 ps=0 w=0.25u l=0.5u
X724 VSS.t335 two_stage_instrumentation_amplifier_0.ota_slow_gmid_0.ota_slow_gmid_buffer_0.ibiasn.t0 VAMP.t16 VSS.t313 sg13_lv_nmos ad=0.1075p pd=1.34u as=0.1075p ps=1.34u w=0.25u l=0.5u
X725 VAMP.t17 two_stage_instrumentation_amplifier_0.ota_slow_gmid_0.ota_slow_gmid_buffer_0.ibiasn.t0 VSS.t334 VSS.t321 sg13_lv_nmos ad=0.1075p pd=1.34u as=0.1075p ps=1.34u w=0.25u l=0.5u
X726 a_18222_8442.t1 a_18492_8164.t1 VSS.t92 rhigh l=0.96u w=0.5u
X727 a_18492_7390.t1 a_18762_7112.t1 VSS.t192 rhigh l=0.96u w=0.5u
X728 a_2285_1463.t4 ota_lv_gmid_comparator_0.ota_slow_gmid_ctrl_buff_0.x.t6 VDD.t31 VSS.t107 sg13_lv_nmos ad=55.85f pd=0.74u as=55.85f ps=0.74u w=0.155u l=0.5u
X729 a_2285_1463.t3 ota_lv_gmid_comparator_0.ota_slow_gmid_ctrl_buff_0.x.t6 VDD.t33 VSS.t106 sg13_lv_nmos ad=55.85f pd=0.74u as=55.85f ps=0.74u w=0.155u l=0.5u
X730 dw_n7292_5488.t7 two_stage_instrumentation_amplifier_0.ota_slow_gmid_0.vota.t8 dw_n7292_5488.t6 dw_n7292_5488.t0 sg13_lv_pmos ad=1.02p pd=6.68u as=0 ps=0 w=3u l=3u
X731 a_n9604_3431.t0 a_n9874_3025.t0 VSS.t63 rhigh l=1.6u w=0.5u
X732 VSS.t284 two_stage_instrumentation_amplifier_0.ota_slow_gmid_0.en_n.t4 two_stage_instrumentation_amplifier_0.ota_slow_gmid_0.vout1.t11 VSS.t283 sg13_lv_nmos ad=0.228p pd=1.58u as=0.228p ps=1.58u w=1.2u l=0.13u
X733 two_stage_instrumentation_amplifier_0.vamp1.t19 two_stage_instrumentation_amplifier_0.ota_slow_gmid_1.ota_slow_gmid_buffer_0.ibiasn.t0 VSS.t957 VSS.t945 sg13_lv_nmos ad=0.1075p pd=1.34u as=0.1075p ps=1.34u w=0.25u l=0.5u
X734 VSS.t1004 VSS.t1005 VSS.t1003 rppd l=1.43u w=0.5u
X735 IOVDD.t108 IOVDD.t61 IOVDD.t35 IOVDD.t31 sg13_hv_pmos ad=0.51p pd=3.68u as=0 ps=0 w=1.5u l=0.5u
X736 ota_lv_gmid_comparator_0.ota_slow_gmid_common_0/ota_slow_gmid_pairs_0.tail.t0 ref_selector_0.VMIN.t21 ota_lv_gmid_comparator_0.ota_slow_gmid_mirror_0.vref.t0 VDD.t42 sg13_lv_pmos ad=0.475p pd=2.88u as=0.85p ps=5.68u w=2.5u l=5u
X737 VSS.t594 VSS.t550 VSS.t593 VSS.t551 sg13_hv_nmos ad=1.4535p pd=9.23u as=0 ps=0 w=4.275u l=4u
X738 VDD.t226 a_4666_5942# VDD.t225 VDD.t224 sg13_lv_pmos ad=1.02p pd=6.68u as=0 ps=0 w=3u l=3u
X739 a_n9334_2535.t1 a_n9604_2257.t0 VSS.t85 rhigh l=0.96u w=0.5u
X740 a_6571_1529.t0 a_6977_1259.t1 VSS.t96 rhigh l=1.6u w=0.5u
X741 ota_lv_gmid_comparator_0.ota_slow_gmid_ctrl_buff_1.ota_slow_gmid_ctrl_inv_0.x.t1 EN.t0 VDD.t255 VDD.t108 sg13_lv_pmos ad=0.68p pd=4.68u as=0.68p ps=4.68u w=2u l=0.13u
X742 VDD.t136 VDD.t134 VDD.t124 VDD.t108 sg13_lv_pmos ad=0.85p pd=5.68u as=0 ps=0 w=2.5u l=2u
X743 top_conditionning_level_shifter_0.EN_HV.t0 top_conditionning_level_shifter_0.top_conditionning_inverter_0.X.t3 IOVDD.t2 IOVDD.t1 sg13_hv_pmos ad=0.68p pd=4.68u as=0.68p ps=4.68u w=2u l=0.45u
X744 IOVDD.t105 IOVDD.t79 IOVDD.t102 IOVDD.t3 sg13_hv_pmos ad=0.6069p pd=4.25u as=0 ps=0 w=1.785u l=3u
X745 IOVDD.t102 IOVDD.t79 IOVDD.t102 IOVDD.t3 sg13_hv_pmos ad=0.33915p pd=2.165u as=0 ps=0 w=1.785u l=3u
X746 VBIAS.t20 two_stage_instrumentation_amplifier_0.ota_slow_gmid_0.en.t3 VDD.t73 VDD.t55 sg13_lv_pmos ad=0.34p pd=2.68u as=0.19p ps=1.38u w=1u l=0.13u
X747 a_6571_989.t0 a_6977_1259.t0 VSS.t167 rhigh l=1.6u w=0.5u
X748 a_8533_2609.t0 ref_selector_0.ref_selector_r_refs_0.R1.t0 VSS.t26 rhigh l=1.6u w=0.5u
X749 top_conditionning_level_shifter_0.top_conditionning_inverter_0.X.t0 EN.t2 IOVDD.t216 IOVDD.t1 sg13_hv_pmos ad=0.204p pd=1.88u as=0.204p ps=1.88u w=0.6u l=0.45u
X750 VSS.t956 two_stage_instrumentation_amplifier_0.ota_slow_gmid_1.ota_slow_gmid_buffer_0.ibiasn.t0 two_stage_instrumentation_amplifier_0.vamp1.t18 VSS.t943 sg13_lv_nmos ad=0.1075p pd=1.34u as=0.1075p ps=1.34u w=0.25u l=0.5u
X751 VAMP.t18 two_stage_instrumentation_amplifier_0.ota_slow_gmid_0.ota_slow_gmid_buffer_0.ibiasn.t0 VSS.t333 VSS.t332 sg13_lv_nmos ad=0.1075p pd=1.34u as=0.1075p ps=1.34u w=0.25u l=0.5u
X752 VSS.t483 VSS.t481 VSS.t483 VSS.t590 sg13_lv_nmos ad=0.19p pd=1.38u as=0 ps=0 w=1u l=0.13u
X753 VSS.t589 VSS.t496 VSS.t588 VSS.t511 sg13_lv_nmos ad=0.1075p pd=1.34u as=0 ps=0 w=0.25u l=0.5u
X754 non_inverting_amplifier_hv_0.ota_hv_slow_gmid_0.vamp.t6 non_inverting_amplifier_hv_0.ota_hv_slow_gmid_0.en_n.t2 VSS.t214 VSS.t212 sg13_hv_nmos ad=0.4218p pd=2.6u as=0.4218p ps=2.6u w=2.22u l=0.45u
X755 a_n4253_5507.t0 a_n4533_4821.t0 VSS.t189 rhigh l=3u w=0.5u
X756 VSS.t483 VSS.t481 VSS.t483 VSS.t585 sg13_lv_nmos ad=0.19p pd=1.38u as=0 ps=0 w=1u l=0.13u
X757 VSS.t331 two_stage_instrumentation_amplifier_0.ota_slow_gmid_0.ota_slow_gmid_buffer_0.ibiasn.t0 VAMP.t8 VSS.t330 sg13_lv_nmos ad=0.1075p pd=1.34u as=0.1075p ps=1.34u w=0.25u l=0.5u
X758 VSS.t916 VSS.t917 VSS.t915 rhigh l=3u w=0.5u
X759 VSS.t584 VSS.t492 VSS.t583 VSS.t493 sg13_lv_nmos ad=0.1075p pd=1.34u as=0 ps=0 w=0.25u l=0.5u
X760 VDD.t133 VDD.t131 VDD.t132 VDD.t68 sg13_lv_pmos ad=0.85p pd=5.68u as=0 ps=0 w=2.5u l=2u
X761 VAMP.t48 two_stage_instrumentation_amplifier_0.ota_slow_gmid_0.ota_slow_gmid_buffer_0.ibiasn.t0 VSS.t329 VSS.t327 sg13_lv_nmos ad=0.1075p pd=1.34u as=0.1075p ps=1.34u w=0.25u l=0.5u
X762 ota_lv_gmid_comparator_0.ota_slow_gmid_ctrl_buff_0.x.t3 ota_lv_gmid_comparator_0.ota_slow_gmid_mirror_0.vout1.t15 a_2285_1463.t11 VSS.t254 sg13_lv_nmos ad=0.38p pd=2.38u as=0.38p ps=2.38u w=2u l=0.13u
X763 VSS.t191 ref_selector_0.VMIN.t3 VSS.t190 rppd l=1.43u w=0.5u
X764 VDD.t32 ota_lv_gmid_comparator_0.ota_slow_gmid_ctrl_buff_0.x.t6 a_2285_1463.t2 VSS.t105 sg13_lv_nmos ad=55.85f pd=0.74u as=55.85f ps=0.74u w=0.155u l=0.5u
X765 ota_lv_gmid_comparator_0.ota_slow_gmid_mirror_0.vota.t0 VAMP.t65 ota_lv_gmid_comparator_0.ota_slow_gmid_common_0/ota_slow_gmid_pairs_0.tail.t0 VDD.t41 sg13_lv_pmos ad=0.85p pd=5.68u as=0.475p ps=2.88u w=2.5u l=5u
X766 VDD.t227 ota_lv_gmid_comparator_0.ota_slow_gmid_ctrl_buff_1.y.t2 ota_lv_gmid_comparator_0.ota_slow_gmid_mirror_0.vout1.t9 VDD.t27 sg13_lv_pmos ad=0.27075p pd=1.805u as=0.27075p ps=1.805u w=1.425u l=0.13u
X767 VBIASH.t8 non_inverting_amplifier_hv_0.ota_hv_slow_gmid_0.en.t5 IOVDD.t214 IOVDD.t3 sg13_hv_pmos ad=0.255p pd=2.18u as=0.1425p ps=1.13u w=0.75u l=0.4u
X768 VSS.t242 non_inverting_amplifier_hv_0.ota_hv_slow_gmid_0.en_n.t7 non_inverting_amplifier_hv_0.ota_hv_slow_gmid_0.vamp.t5 VSS.t241 sg13_hv_nmos ad=0.114p pd=0.98u as=0.114p ps=0.98u w=0.6u l=0.45u
X769 VAMP.t9 two_stage_instrumentation_amplifier_0.ota_slow_gmid_0.ota_slow_gmid_buffer_0.ibiasn.t0 VSS.t328 VSS.t327 sg13_lv_nmos ad=0.1075p pd=1.34u as=0.1075p ps=1.34u w=0.25u l=0.5u
X770 VDD.t36 ota_lv_gmid_comparator_0.ota_slow_gmid_ctrl_buff_0.x.t6 a_2285_1463.t1 VSS.t104 sg13_lv_nmos ad=55.85f pd=0.74u as=55.85f ps=0.74u w=0.155u l=0.5u
X771 a_18762_8968.t1 a_18492_8690.t1 VSS.t192 rhigh l=0.96u w=0.5u
X772 VSS.t955 two_stage_instrumentation_amplifier_0.ota_slow_gmid_1.ota_slow_gmid_buffer_0.ibiasn.t0 two_stage_instrumentation_amplifier_0.vamp1.t17 VSS.t929 sg13_lv_nmos ad=0.1075p pd=1.34u as=0.1075p ps=1.34u w=0.25u l=0.5u
X773 ota_lv_gmid_comparator_0.ota_slow_gmid_ctrl_buff_1.y.t0 ota_lv_gmid_comparator_0.ota_slow_gmid_ctrl_buff_1.ota_slow_gmid_ctrl_inv_0.x.t2 VSS.t914 VSS.t913 sg13_lv_nmos ad=0.68p pd=4.68u as=0.68p ps=4.68u w=2u l=0.13u
X774 VDD.t130 VDD.t115 VDD.t129 VDD.t55 sg13_lv_pmos ad=0.34p pd=2.68u as=0 ps=0 w=1u l=0.5u
X775 VDD.t127 VDD.t125 VDD.t126 VDD.t55 sg13_lv_pmos ad=0.34p pd=2.68u as=0 ps=0 w=1u l=0.5u
X776 VSS.t173 two_stage_instrumentation_amplifier_0.ota_slow_gmid_1.en_n.t2 two_stage_instrumentation_amplifier_0.ota_slow_gmid_1.vout1.t3 VSS.t172 sg13_lv_nmos ad=0.228p pd=1.58u as=0.228p ps=1.58u w=1.2u l=0.13u
X777 non_inverting_amplifier_hv_0.ota_hv_slow_gmid_0.ota_hv_slow_gmid_tail_0.tail.t3 VBIASH.t19 IOVDD.t222 IOVDD.t3 sg13_hv_pmos ad=0.34p pd=2.68u as=0.19p ps=1.38u w=1u l=0.5u
X778 VSS.t954 two_stage_instrumentation_amplifier_0.ota_slow_gmid_1.ota_slow_gmid_buffer_0.ibiasn.t0 two_stage_instrumentation_amplifier_0.vamp1.t16 VSS.t929 sg13_lv_nmos ad=0.1075p pd=1.34u as=0.1075p ps=1.34u w=0.25u l=0.5u
X779 VSS.t581 VSS.t500 VSS.t580 VSS.t501 sg13_hv_nmos ad=0.34p pd=2.68u as=0 ps=0 w=1u l=1u
X780 two_stage_instrumentation_amplifier_0.ota_slow_gmid_1.vota.t2 vref.t8 two_stage_instrumentation_amplifier_0.ota_slow_gmid_1.ota_slow_gmid_common_0/ota_slow_gmid_pairs_0.tail.t1 VDD.t0 sg13_lv_pmos ad=0.85p pd=5.68u as=0.475p ps=2.88u w=2.5u l=5u
X781 two_stage_instrumentation_amplifier_0.ota_slow_gmid_1.ota_slow_gmid_buffer_0.ibiasn.t3 two_stage_instrumentation_amplifier_0.ota_slow_gmid_1.ota_slow_gmid_buffer_0.ibiasn.t0 VSS.t953 VSS.t927 sg13_lv_nmos ad=0.1075p pd=1.34u as=0.1075p ps=1.34u w=0.25u l=0.5u
X782 VSS.t165 VSS.t166 VSS.t79 rppd l=1.43u w=0.5u
X783 VSS.t578 VSS.t496 VSS.t577 VSS.t514 sg13_lv_nmos ad=0.1075p pd=1.34u as=0 ps=0 w=0.25u l=0.5u
X784 IOVDD.t100 IOVDD.t92 IOVDD.t99 IOVDD.t3 sg13_hv_pmos ad=0.34p pd=2.68u as=0 ps=0 w=1u l=0.5u
X785 IOVDD.t214 non_inverting_amplifier_hv_0.ota_hv_slow_gmid_0.en.t5 VBIASH.t7 IOVDD.t3 sg13_hv_pmos ad=0.1425p pd=1.13u as=0.255p ps=2.18u w=0.75u l=0.4u
X786 VBIAS.t13 two_stage_instrumentation_amplifier_0.ota_slow_gmid_0.en.t2 VDD.t59 VDD.t58 sg13_lv_pmos ad=0.19p pd=1.38u as=0.19p ps=1.38u w=1u l=0.13u
X787 VSS.t575 VSS.t496 VSS.t574 VSS.t511 sg13_lv_nmos ad=0.1075p pd=1.34u as=0 ps=0 w=0.25u l=0.5u
X788 VSS.t570 VSS.t568 two_stage_instrumentation_amplifier_0.vamp1.t1 VSS.t571 sg13_lv_nmos ad=0.19p pd=1.38u as=0.19p ps=1.38u w=1u l=0.13u
X789 VSS.t171 two_stage_instrumentation_amplifier_0.ota_slow_gmid_1.en_n.t2 two_stage_instrumentation_amplifier_0.ota_slow_gmid_1.vout1.t2 VSS.t170 sg13_lv_nmos ad=0.228p pd=1.58u as=0.228p ps=1.58u w=1.2u l=0.13u
X790 two_stage_instrumentation_amplifier_0.ota_slow_gmid_1.vout1.t1 two_stage_instrumentation_amplifier_0.ota_slow_gmid_1.en_n.t3 VSS.t12 VSS.t11 sg13_lv_nmos ad=0.228p pd=1.58u as=0.228p ps=1.58u w=1.2u l=0.13u
X791 VBIAS.t19 two_stage_instrumentation_amplifier_0.ota_slow_gmid_0.en.t3 VDD.t72 VDD.t55 sg13_lv_pmos ad=0.19p pd=1.38u as=0.19p ps=1.38u w=1u l=0.13u
X792 IOVDD.t15 top_conditionning_level_shifter_0.EN_HV.t2 VBIASH.t2 IOVDD.t14 sg13_hv_pmos ad=0.38p pd=2.38u as=0.38p ps=2.38u w=2u l=0.4u
X793 VSS.t570 VSS.t568 VSS.t570 VSS.t569 sg13_lv_nmos ad=0.19p pd=1.38u as=0 ps=0 w=1u l=0.13u
X794 VDD.t71 two_stage_instrumentation_amplifier_0.ota_slow_gmid_0.en.t3 VBIAS.t18 VDD.t55 sg13_lv_pmos ad=0.19p pd=1.38u as=0.19p ps=1.38u w=1u l=0.13u
X795 VSS.t567 VSS.t492 VSS.t566 VSS.t538 sg13_lv_nmos ad=0.1075p pd=1.34u as=0 ps=0 w=0.25u l=0.5u
X796 a_17952_8442.t1 a_17412_7948.t0 VSS.t132 rhigh l=0.96u w=0.5u
X797 a_18762_6864.t1 a_18492_6586.t1 VSS.t192 rhigh l=0.96u w=0.5u
X798 dw_n18308_4910.t6 two_stage_instrumentation_amplifier_0.ota_slow_gmid_1.vota.t7 dw_n18308_4910.t5 dw_n18308_4910.t4 sg13_lv_pmos ad=1.02p pd=6.68u as=0 ps=0 w=3u l=3u
X799 VSS.t326 two_stage_instrumentation_amplifier_0.ota_slow_gmid_0.ota_slow_gmid_buffer_0.ibiasn.t0 VAMP.t10 VSS.t309 sg13_lv_nmos ad=0.1075p pd=1.34u as=0.1075p ps=1.34u w=0.25u l=0.5u
X800 IOVDD.t194 non_inverting_amplifier_hv_0.ota_hv_slow_gmid_0.en.t2 VBIASH.t6 IOVDD.t28 sg13_hv_pmos ad=62.69999f pd=0.71u as=62.69999f ps=0.71u w=0.33u l=0.4u
X801 ref_selector_0.VMIN.t14 VSS.t1007 VSS.t1006 rppd l=1.43u w=0.5u
X802 VSS.t1008 VSS.t1009 VSS.t469 rppd l=3.69u w=0.5u
X803 ota_lv_gmid_comparator_0.ota_slow_gmid_mirror_0.vout1.t8 ota_lv_gmid_comparator_0.ota_slow_gmid_ctrl_buff_1.y.t2 VDD.t229 VDD.t27 sg13_lv_pmos ad=0.27075p pd=1.805u as=0.4845p ps=3.53u w=1.425u l=0.13u
X804 VBIASH.t2 top_conditionning_level_shifter_0.EN_HV.t2 IOVDD.t19 IOVDD.t14 sg13_hv_pmos ad=0.38p pd=2.38u as=0.38p ps=2.38u w=2u l=0.4u
X805 VSS.t56 VSS.t57 VSS.t55 rhigh l=0.96u w=0.5u
X806 VSS.t909 VSS.t910 VSS.t424 rhigh l=0.96u w=0.5u
X807 IOVDD.t97 IOVDD.t67 IOVDD.t96 IOVDD.t28 sg13_hv_pmos ad=0.6069p pd=4.25u as=0 ps=0 w=1.785u l=3u
X808 two_stage_instrumentation_amplifier_0.ota_slow_gmid_1.en_n.t1 EN.t3 VDD.t257 VDD.t0 sg13_lv_pmos ad=0.68p pd=4.68u as=0.68p ps=4.68u w=2u l=0.13u
X809 VDD.t94 VBIAS.t33 ota_lv_gmid_comparator_0.ota_slow_gmid_common_0/ota_slow_gmid_pairs_0.tail.t2 VDD.t54 sg13_lv_pmos ad=0.19p pd=1.38u as=0.34p ps=2.68u w=1u l=0.5u
X810 two_stage_instrumentation_amplifier_0.vamp1.t15 two_stage_instrumentation_amplifier_0.ota_slow_gmid_1.ota_slow_gmid_buffer_0.ibiasn.t0 VSS.t952 VSS.t951 sg13_lv_nmos ad=0.1075p pd=1.34u as=0.1075p ps=1.34u w=0.25u l=0.5u
X811 a_2485_3315.t1 ota_lv_gmid_comparator_0.ota_slow_gmid_ctrl_buff_0.x.t7 VSS.t160 VDD.t48 sg13_lv_pmos ad=95f pd=0.88u as=95f ps=0.88u w=0.5u l=1u
X812 VSS.t61 VSS.t62 VSS.t60 rhigh l=3u w=0.5u
X813 VSS.t559 VSS.t557 VSS.t559 VSS.t563 sg13_lv_nmos ad=0.19p pd=1.38u as=0 ps=0 w=1u l=0.13u
X814 a_19302_7390.t1 a_19302_7916.t1 VSS.t27 rhigh l=0.96u w=0.5u
X815 VSS.t562 VSS.t496 VSS.t561 VSS.t514 sg13_lv_nmos ad=0.1075p pd=1.34u as=0 ps=0 w=0.25u l=0.5u
X816 SENSOR.t0 SEL_SENSOR.t0 ref_selector_0.I1MA.t0 VSS.t169 sg13_lv_nmos ad=1.7p pd=10.68u as=0.95p ps=5.38u w=5u l=0.13u
X817 a_14750_1527.t1 current_source_1mA_0.current_source_1mA_2_stage_0.vcp.t2 VSS.t924 rppd l=3.69u w=0.5u
X818 non_inverting_amplifier_hv_0.ota_hv_slow_gmid_0.vamp.t21 VBIASH.t19 IOVDD.t221 IOVDD.t3 sg13_hv_pmos ad=0.34p pd=2.68u as=0.19p ps=1.38u w=1u l=0.5u
X819 a_n16824_5507.t1 a_n17104_4821.t1 VSS.t925 rhigh l=3u w=0.5u
X820 VAMP.t0 VSS.t557 VSS.t559 VSS.t558 sg13_lv_nmos ad=0.19p pd=1.38u as=0.19p ps=1.38u w=1u l=0.13u
X821 IOVDD.t94 IOVDD.t92 IOVDD.t93 IOVDD.t3 sg13_hv_pmos ad=0.34p pd=2.68u as=0 ps=0 w=1u l=0.5u
X822 VSS.t162 ota_lv_gmid_comparator_0.ota_slow_gmid_ctrl_buff_0.x.t7 a_2485_3315.t0 VDD.t47 sg13_lv_pmos ad=0.17p pd=1.68u as=95f ps=0.88u w=0.5u l=1u
X823 two_stage_instrumentation_amplifier_0.ota_slow_gmid_0.ota_slow_gmid_buffer_0.ibiasn.t5 VBIAS.t34 VDD.t98 VDD.t55 sg13_lv_pmos ad=0.34p pd=2.68u as=0.19p ps=1.38u w=1u l=0.5u
X824 two_stage_instrumentation_amplifier_0.vamp1.t14 two_stage_instrumentation_amplifier_0.ota_slow_gmid_1.ota_slow_gmid_buffer_0.ibiasn.t0 VSS.t950 VSS.t935 sg13_lv_nmos ad=0.1075p pd=1.34u as=0.1075p ps=1.34u w=0.25u l=0.5u
X825 VSS.t556 VSS.t488 VSS.t555 VSS.t554 sg13_lv_nmos ad=0.1075p pd=1.34u as=0 ps=0 w=0.25u l=0.5u
X826 VSS.t949 two_stage_instrumentation_amplifier_0.ota_slow_gmid_1.ota_slow_gmid_buffer_0.ibiasn.t0 two_stage_instrumentation_amplifier_0.vamp1.t13 VSS.t932 sg13_lv_nmos ad=0.1075p pd=1.34u as=0.1075p ps=1.34u w=0.25u l=0.5u
X827 VSS.t260 VSS.t261 VSS.t247 rhigh l=0.96u w=0.5u
X828 ref_selector_0.I1MA.t2 current_source_1mA_0.current_source_1mA_2_stage_0.current_source_pass_element_0.iref.t4 IOVDD.t36 IOVDD.t31 sg13_hv_pmos ad=0.285p pd=1.88u as=0.285p ps=1.88u w=1.5u l=0.5u
X829 VSS.t325 two_stage_instrumentation_amplifier_0.ota_slow_gmid_0.ota_slow_gmid_buffer_0.ibiasn.t0 VAMP.t11 VSS.t309 sg13_lv_nmos ad=0.1075p pd=1.34u as=0.1075p ps=1.34u w=0.25u l=0.5u
X830 VSS.t406 VSS.t407 VSS.t405 rppd l=3.69u w=0.5u
X831 IOVDD.t91 IOVDD.t89 IOVDD.t90 IOVDD.t25 sg13_hv_pmos ad=0.9996p pd=6.56u as=0 ps=0 w=2.94u l=1u
X832 VDD.t243 ota_lv_gmid_comparator_0.ota_slow_gmid_ctrl_buff_1.y.t3 VBIAS.t26 VDD.t108 sg13_lv_pmos ad=0.4845p pd=3.53u as=0.27075p ps=1.805u w=1.425u l=0.13u
X833 ota_lv_gmid_comparator_0.ota_slow_gmid_mirror_0.vout1.t7 ota_lv_gmid_comparator_0.ota_slow_gmid_ctrl_buff_1.y.t2 VDD.t228 VDD.t27 sg13_lv_pmos ad=0.27075p pd=1.805u as=0.27075p ps=1.805u w=1.425u l=0.13u
X834 VSS.t207 current_source_1mA_0.ota_med_hv_gmid_0.ota_med_hv_gmid_mirror_0.vota.t6 current_source_1mA_0.current_source_1mA_2_stage_0.current_source_pass_element_0.vota.t2 VSS.t206 sg13_hv_nmos ad=0.646p pd=4.48u as=0.646p ps=4.48u w=1.9u l=2u
X835 VSS.t432 VSS.t433 VSS.t431 rppd l=3.69u w=0.5u
X836 VSS.t553 VSS.t550 VSS.t552 VSS.t551 sg13_hv_nmos ad=1.4535p pd=9.23u as=0 ps=0 w=4.275u l=4u
X837 non_inverting_amplifier_hv_0.ota_hv_slow_gmid_0.vota.t5 non_inverting_amplifier_hv_0.ota_hv_slow_gmid_0.vamp.t16 cap_cmim l=20u w=20u
X838 VSS.t461 VSS.t462 VSS.t247 rhigh l=1.6u w=0.5u
X839 VSS.t49 ref_selector_0.ref_selector_r_96_0.vcal.t0 VSS.t48 rppd l=1.43u w=0.5u
X840 VSS.t549 VSS.t547 VSS.t549 VSS.t548 sg13_lv_nmos ad=0.19p pd=1.38u as=0 ps=0 w=1u l=0.13u
X841 VSS.t546 VSS.t521 VSS.t545 VSS.t544 sg13_lv_nmos ad=0.1075p pd=1.34u as=0 ps=0 w=0.25u l=0.5u
X842 IOVDD.t71 IOVDD.t70 IOVDD.t71 IOVDD.t87 sg13_hv_pmos ad=0.5586p pd=3.32u as=0 ps=0 w=2.94u l=1u
X843 VDD.t124 VDD.t123 VDD.t124 VDD.t108 sg13_lv_pmos ad=0.475p pd=2.88u as=0 ps=0 w=2.5u l=2u
X844 a_9187_1259.t1 a_9593_1529.t1 VSS.t86 rhigh l=1.6u w=0.5u
X845 ref_selector_0.I1MA.t1 current_source_1mA_0.current_source_1mA_2_stage_0.current_source_pass_element_0.iref.t4 IOVDD.t35 IOVDD.t31 sg13_hv_pmos ad=0.285p pd=1.88u as=0.285p ps=1.88u w=1.5u l=0.5u
X846 two_stage_instrumentation_amplifier_0.vamp1.t12 two_stage_instrumentation_amplifier_0.ota_slow_gmid_1.ota_slow_gmid_buffer_0.ibiasn.t0 VSS.t948 VSS.t941 sg13_lv_nmos ad=0.1075p pd=1.34u as=0.1075p ps=1.34u w=0.25u l=0.5u
X847 non_inverting_amplifier_hv_0.ota_hv_slow_gmid_0.vref.t1 non_inverting_amplifier_hv_0.top_conditionning_gain_s3_0.vn3.t3 non_inverting_amplifier_hv_0.ota_hv_slow_gmid_0.ota_hv_slow_gmid_tail_0.tail.t1 IOVDD.t3 sg13_hv_pmos ad=0.6069p pd=4.25u as=0.33915p ps=2.165u w=1.785u l=3u
X848 VDD.t6 two_stage_instrumentation_amplifier_0.ota_slow_gmid_1.en.t2 VBIAS.t1 VDD.t5 sg13_lv_pmos ad=0.19p pd=1.38u as=0.19p ps=1.38u w=1u l=0.13u
X849 VBIASH.t1 top_conditionning_level_shifter_0.EN_HV.t2 IOVDD.t15 IOVDD.t18 sg13_hv_pmos ad=0.68p pd=4.68u as=0.38p ps=2.38u w=2u l=0.4u
X850 VSS.t93 VSS.t94 VSS.t0 rppd l=3.69u w=0.5u
X851 a_9187_1259.t0 a_9593_989.t0 VSS.t82 rhigh l=1.6u w=0.5u
X852 VSS.t543 VSS.t488 VSS.t542 VSS.t541 sg13_lv_nmos ad=0.1075p pd=1.34u as=0 ps=0 w=0.25u l=0.5u
X853 a_n9604_1483.t0 a_n9334_1205.t0 VSS.t188 rhigh l=0.96u w=0.5u
X854 non_inverting_amplifier_hv_0.ota_hv_slow_gmid_0.vamp.t4 non_inverting_amplifier_hv_0.ota_hv_slow_gmid_0.en_n.t4 VSS.t229 VSS.t226 sg13_hv_nmos ad=0.4218p pd=2.6u as=0.4218p ps=2.6u w=2.22u l=0.45u
X855 VSS.t947 two_stage_instrumentation_amplifier_0.ota_slow_gmid_1.ota_slow_gmid_buffer_0.ibiasn.t0 two_stage_instrumentation_amplifier_0.ota_slow_gmid_1.ota_slow_gmid_buffer_0.ibiasn.t2 VSS.t939 sg13_lv_nmos ad=0.1075p pd=1.34u as=0.1075p ps=1.34u w=0.25u l=0.5u
X856 VSS.t223 non_inverting_amplifier_hv_0.ota_hv_slow_gmid_0.en_n.t3 non_inverting_amplifier_hv_0.ota_hv_slow_gmid_0.vamp.t3 VSS.t222 sg13_hv_nmos ad=0.114p pd=0.98u as=0.204p ps=1.88u w=0.6u l=0.45u
X857 VSS.t324 two_stage_instrumentation_amplifier_0.ota_slow_gmid_0.ota_slow_gmid_buffer_0.ibiasn.t0 VAMP.t47 VSS.t323 sg13_lv_nmos ad=0.1075p pd=1.34u as=0.1075p ps=1.34u w=0.25u l=0.5u
X858 a_19302_8968.t0 a_19572_8164.t1 VSS.t27 rhigh l=0.96u w=0.5u
X859 VDD.t122 VDD.t118 VDD.t121 VDD.t0 sg13_lv_pmos ad=0.85p pd=5.68u as=0 ps=0 w=2.5u l=2u
X860 VAMP.t59 two_stage_instrumentation_amplifier_0.ota_slow_gmid_0.ota_slow_gmid_buffer_0.ibiasn.t0 VSS.t322 VSS.t321 sg13_lv_nmos ad=0.1075p pd=1.34u as=0.1075p ps=1.34u w=0.25u l=0.5u
X861 IOVDD.t17 top_conditionning_level_shifter_0.EN_HV.t2 VBIASH.t0 IOVDD.t0 sg13_hv_pmos ad=0.38p pd=2.38u as=0.38p ps=2.38u w=2u l=0.4u
X862 VSS.t540 VSS.t492 VSS.t539 VSS.t538 sg13_lv_nmos ad=0.1075p pd=1.34u as=0 ps=0 w=0.25u l=0.5u
X863 VSS.t463 VSS.t464 VSS.t424 rhigh l=0.96u w=0.5u
X864 ref_selector_0.I1MA.t3 current_source_1mA_0.current_source_1mA_2_stage_0.current_source_pass_element_0.iref.t4 IOVDD.t32 IOVDD.t31 sg13_hv_pmos ad=0.51p pd=3.68u as=0.285p ps=1.88u w=1.5u l=0.5u
X865 VSS.t267 two_stage_instrumentation_amplifier_0.ota_slow_gmid_0.en_n.t2 two_stage_instrumentation_amplifier_0.ota_slow_gmid_0.vout1.t7 VSS.t266 sg13_lv_nmos ad=0.228p pd=1.58u as=0.228p ps=1.58u w=1.2u l=0.13u
X866 VDD.t4 two_stage_instrumentation_amplifier_0.ota_slow_gmid_1.en.t2 VBIAS.t0 VDD.t0 sg13_lv_pmos ad=0.19p pd=1.38u as=0.19p ps=1.38u w=1u l=0.13u
X867 VBIAS.t8 two_stage_instrumentation_amplifier_0.ota_slow_gmid_1.en.t3 VDD.t19 VDD.t0 sg13_lv_pmos ad=0.19p pd=1.38u as=0.19p ps=1.38u w=1u l=0.13u
X868 ref_selector_0.ref_selector_r_96_0.vcal.t7 VSS.t452 VSS.t429 rppd l=1.43u w=0.5u
X869 VSS.t537 VSS.t507 VSS.t536 VSS.t508 sg13_lv_nmos ad=0.17p pd=1.68u as=0 ps=0 w=0.5u l=2u
X870 two_stage_instrumentation_amplifier_0.vamp1.t11 two_stage_instrumentation_amplifier_0.ota_slow_gmid_1.ota_slow_gmid_buffer_0.ibiasn.t0 VSS.t946 VSS.t945 sg13_lv_nmos ad=0.1075p pd=1.34u as=0.1075p ps=1.34u w=0.25u l=0.5u
X871 VBIAS.t25 ota_lv_gmid_comparator_0.ota_slow_gmid_ctrl_buff_1.y.t3 VDD.t242 VDD.t108 sg13_lv_pmos ad=0.27075p pd=1.805u as=0.27075p ps=1.805u w=1.425u l=0.13u
X872 two_stage_instrumentation_amplifier_0.ota_slow_gmid_1.vout1.t0 two_stage_instrumentation_amplifier_0.ota_slow_gmid_1.en_n.t3 VSS.t10 VSS.t9 sg13_lv_nmos ad=0.228p pd=1.58u as=0.228p ps=1.58u w=1.2u l=0.13u
X873 current_source_1mA_0.current_source_1mA_2_stage_0.current_source_pass_element_0.iref.t1 top_conditionning_level_shifter_0.EN_HV.t2 IOVDD.t12 IOVDD.t16 sg13_hv_pmos ad=0.38p pd=2.38u as=0.38p ps=2.38u w=2u l=0.4u
X874 ota_lv_gmid_comparator_0.ota_slow_gmid_common_0/ota_slow_gmid_tail_0.ibiasn.t1 VBIAS.t33 VDD.t93 VDD.t54 sg13_lv_pmos ad=0.34p pd=2.68u as=0.19p ps=1.38u w=1u l=0.5u
X875 VDD.t119 VDD.t118 VDD.t119 VDD.t0 sg13_lv_pmos ad=0.475p pd=2.88u as=0 ps=0 w=2.5u l=2u
X876 VSS.t248 VSS.t249 VSS.t247 rhigh l=1.6u w=0.5u
X877 VDD.t241 ota_lv_gmid_comparator_0.ota_slow_gmid_ctrl_buff_1.y.t3 VBIAS.t24 VDD.t108 sg13_lv_pmos ad=0.27075p pd=1.805u as=0.27075p ps=1.805u w=1.425u l=0.13u
X878 top_conditionning_level_shifter_0.top_conditionning_inverter_0.X.t1 EN.t2 VSS.t1028 VSS.t1027 sg13_hv_nmos ad=0.85p pd=5.68u as=0.475p ps=2.88u w=2.5u l=0.45u
X879 a_n5418_4249.t0 two_stage_instrumentation_amplifier_0.ota_slow_gmid_0.vout1.t0 VSS.t91 rhigh l=2.5u w=0.5u
X880 VBIASH.t0 top_conditionning_level_shifter_0.EN_HV.t2 IOVDD.t13 IOVDD.t0 sg13_hv_pmos ad=0.38p pd=2.38u as=0.38p ps=2.38u w=2u l=0.4u
X881 VSS.t1049 VSS.t1050 VSS.t1048 rhigh l=3u w=0.5u
X882 non_inverting_amplifier_hv_0.ota_hv_slow_gmid_0.vamp.t2 non_inverting_amplifier_hv_0.ota_hv_slow_gmid_0.en_n.t2 VSS.t213 VSS.t212 sg13_hv_nmos ad=0.4218p pd=2.6u as=0.4218p ps=2.6u w=2.22u l=0.45u
X883 VSS.t534 VSS.t531 VSS.t533 VSS.t532 sg13_hv_nmos ad=0.646p pd=4.48u as=0 ps=0 w=1.9u l=2u
X884 a_18762_8442.t1 a_18492_8164.t0 VSS.t192 rhigh l=0.96u w=0.5u
X885 a_19302_6864.t1 non_inverting_amplifier_hv_0.top_conditionning_gain_s3_0.vn3.t0 VSS.t27 rhigh l=0.96u w=0.5u
X886 IOVDD.t12 top_conditionning_level_shifter_0.EN_HV.t2 current_source_1mA_0.current_source_1mA_2_stage_0.current_source_pass_element_0.iref.t0 IOVDD.t11 sg13_hv_pmos ad=0.38p pd=2.38u as=0.38p ps=2.38u w=2u l=0.4u
X887 IOVDD.t86 IOVDD.t73 IOVDD.t85 IOVDD.t0 sg13_hv_pmos ad=0.34p pd=2.68u as=0 ps=0 w=1u l=0.5u
X888 IOVDD.t83 IOVDD.t79 IOVDD.t80 IOVDD.t3 sg13_hv_pmos ad=0.6069p pd=4.25u as=0 ps=0 w=1.785u l=3u
X889 VSS.t944 two_stage_instrumentation_amplifier_0.ota_slow_gmid_1.ota_slow_gmid_buffer_0.ibiasn.t0 two_stage_instrumentation_amplifier_0.vamp1.t10 VSS.t943 sg13_lv_nmos ad=0.1075p pd=1.34u as=0.1075p ps=1.34u w=0.25u l=0.5u
X890 VSS.t530 VSS.t521 VSS.t529 VSS.t522 sg13_lv_nmos ad=0.1075p pd=1.34u as=0 ps=0 w=0.25u l=0.5u
X891 IOVDD.t80 IOVDD.t79 IOVDD.t80 IOVDD.t3 sg13_hv_pmos ad=0.33915p pd=2.165u as=0 ps=0 w=1.785u l=3u
X892 two_stage_instrumentation_amplifier_0.vamp1.t9 two_stage_instrumentation_amplifier_0.ota_slow_gmid_1.ota_slow_gmid_buffer_0.ibiasn.t0 VSS.t942 VSS.t941 sg13_lv_nmos ad=0.1075p pd=1.34u as=0.1075p ps=1.34u w=0.25u l=0.5u
X893 VSS.t65 VSS.t66 VSS.t64 rppd l=1.43u w=0.5u
X894 two_stage_instrumentation_amplifier_0.ota_slow_gmid_1.ota_slow_gmid_buffer_0.ibiasn.t5 VBIAS.t32 VDD.t87 VDD.t0 sg13_lv_pmos ad=0.34p pd=2.68u as=0.19p ps=1.38u w=1u l=0.5u
X895 current_source_1mA_0.current_source_1mA_2_stage_0.vcp.t0 VSS.t525 VSS.t527 VSS.t526 sg13_hv_nmos ad=0.1425p pd=1.13u as=0.255p ps=2.18u w=0.75u l=0.5u
X896 IOVDD.t212 non_inverting_amplifier_hv_0.ota_hv_slow_gmid_0.en.t4 VBIASH.t5 IOVDD.t28 sg13_hv_pmos ad=0.1425p pd=1.13u as=0.255p ps=2.18u w=0.75u l=0.4u
X897 a_n9874_4739.t1 a_n9874_4085.t0 VSS.t185 rhigh l=1.6u w=0.5u
X898 a_2485_3315.t3 ota_lv_gmid_comparator_0.ota_slow_gmid_mirror_0.vout1.t15 ota_lv_gmid_comparator_0.ota_slow_gmid_ctrl_buff_0.x.t0 VDD.t54 sg13_lv_pmos ad=0.2375p pd=1.63u as=0.2375p ps=1.63u w=1.25u l=0.13u
X899 IOVDD.t222 VBIASH.t19 non_inverting_amplifier_hv_0.ota_hv_slow_gmid_0.ibiasn.t0 IOVDD.t3 sg13_hv_pmos ad=0.19p pd=1.38u as=0.34p ps=2.68u w=1u l=0.5u
X900 IOVDD.t203 non_inverting_amplifier_hv_0.ota_hv_slow_gmid_0.en.t3 VBIASH.t4 IOVDD.t3 sg13_hv_pmos ad=62.69999f pd=0.71u as=62.69999f ps=0.71u w=0.33u l=0.4u
X901 a_n9874_2535.t1 a_n9604_2257.t1 VSS.t63 rhigh l=0.96u w=0.5u
X902 ref_selector_0.VMIN.t8 VSS.t430 VSS.t429 rppd l=1.43u w=0.5u
X903 VSS.t940 two_stage_instrumentation_amplifier_0.ota_slow_gmid_1.ota_slow_gmid_buffer_0.ibiasn.t0 two_stage_instrumentation_amplifier_0.vamp1.t8 VSS.t939 sg13_lv_nmos ad=0.1075p pd=1.34u as=0.1075p ps=1.34u w=0.25u l=0.5u
X904 non_inverting_amplifier_hv_0.ota_hv_slow_gmid_0.vamp.t18 non_inverting_amplifier_hv_0.ota_hv_slow_gmid_0.vota.t6 VSS.t899 VSS.t900 sg13_hv_nmos ad=1.4535p pd=9.23u as=0.81225p ps=4.655u w=4.275u l=10u
X905 a_9187_719.t1 a_9593_989.t1 VSS.t82 rhigh l=1.6u w=0.5u
X906 VSS.t524 VSS.t521 VSS.t523 VSS.t522 sg13_lv_nmos ad=0.1075p pd=1.34u as=0 ps=0 w=0.25u l=0.5u
X907 VAMP.t27 two_stage_instrumentation_amplifier_0.ota_slow_gmid_0.ota_slow_gmid_buffer_0.ibiasn.t0 VSS.t320 VSS.t319 sg13_lv_nmos ad=0.1075p pd=1.34u as=0.1075p ps=1.34u w=0.25u l=0.5u
X908 a_7879_719.t0 a_8285_989.t1 VSS.t31 rhigh l=1.6u w=0.5u
X909 ota_lv_gmid_comparator_0.ota_slow_gmid_ctrl_buff_0.ota_slow_gmid_ctrl_inv_0.x.t1 ota_lv_gmid_comparator_0.ota_slow_gmid_ctrl_buff_0.x.t8 VDD.t50 VDD.t27 sg13_lv_pmos ad=0.68p pd=4.68u as=0.68p ps=4.68u w=2u l=0.13u
X910 a_17412_7948.t1 VSS.t906 VSS.t67 rhigh l=1.23u w=0.5u
X911 vref.t4 S1.t0 ref_selector_0.ref_selector_r_refs_0.R1.t1 VSS.t887 sg13_lv_nmos ad=1.02p pd=6.68u as=1.02p ps=6.68u w=3u l=0.13u
X912 VSS.t318 two_stage_instrumentation_amplifier_0.ota_slow_gmid_0.ota_slow_gmid_buffer_0.ibiasn.t0 VAMP.t58 VSS.t313 sg13_lv_nmos ad=0.1075p pd=1.34u as=0.1075p ps=1.34u w=0.25u l=0.5u
X913 VSS.t520 VSS.t517 VSS.t519 VSS.t518 sg13_hv_nmos ad=1.4535p pd=9.23u as=0 ps=0 w=4.275u l=4u
X914 VSS.t453 VSS.t454 VSS.t424 rhigh l=0.96u w=0.5u
X915 VDD.t92 VBIAS.t33 ota_lv_gmid_comparator_0.ota_slow_gmid_common_0/ota_slow_gmid_tail_0.ibiasn.t0 VDD.t54 sg13_lv_pmos ad=0.19p pd=1.38u as=0.34p ps=2.68u w=1u l=0.5u
X916 VSS.t193 VSS.t194 VSS.t28 rhigh l=0.96u w=0.5u
X917 VDD.t117 VDD.t115 VDD.t116 VDD.t55 sg13_lv_pmos ad=0.34p pd=2.68u as=0 ps=0 w=1u l=0.5u
X918 VSS.t938 two_stage_instrumentation_amplifier_0.ota_slow_gmid_1.ota_slow_gmid_buffer_0.ibiasn.t0 two_stage_instrumentation_amplifier_0.vamp1.t7 VSS.t937 sg13_lv_nmos ad=0.1075p pd=1.34u as=0.1075p ps=1.34u w=0.25u l=0.5u
X919 VSS.t516 VSS.t496 VSS.t515 VSS.t514 sg13_lv_nmos ad=0.1075p pd=1.34u as=0 ps=0 w=0.25u l=0.5u
X920 IOVDD.t5 non_inverting_amplifier_hv_0.ota_hv_slow_gmid_0.vamp.t23 VOUT.t2 VSS.t201 sg13_hv_nmos ad=0.19p pd=1.38u as=0.19p ps=1.38u w=1u l=1u
X921 two_stage_instrumentation_amplifier_0.vamp1.t6 two_stage_instrumentation_amplifier_0.ota_slow_gmid_1.ota_slow_gmid_buffer_0.ibiasn.t0 VSS.t936 VSS.t935 sg13_lv_nmos ad=0.1075p pd=1.34u as=0.1075p ps=1.34u w=0.25u l=0.5u
X922 VSS.t513 VSS.t496 VSS.t512 VSS.t511 sg13_lv_nmos ad=0.1075p pd=1.34u as=0 ps=0 w=0.25u l=0.5u
X923 IOVDD.t78 IOVDD.t61 IOVDD.t54 IOVDD.t31 sg13_hv_pmos ad=0.51p pd=3.68u as=0 ps=0 w=1.5u l=0.5u
X924 a_2485_3315.t0 ota_lv_gmid_comparator_0.ota_slow_gmid_ctrl_buff_0.x.t7 VSS.t161 VDD.t41 sg13_lv_pmos ad=95f pd=0.88u as=95f ps=0.88u w=0.5u l=1u
X925 IOVDD.t75 IOVDD.t73 IOVDD.t74 IOVDD.t0 sg13_hv_pmos ad=0.34p pd=2.68u as=0 ps=0 w=1u l=0.5u
X926 VDD.t83 a_875_5942# VDD.t82 VDD.t81 sg13_lv_pmos ad=1.02p pd=6.68u as=0 ps=0 w=3u l=3u
X927 VDD.t114 VDD.t113 VDD.t114 VDD.t11 sg13_lv_pmos ad=0.475p pd=2.88u as=0 ps=0 w=2.5u l=2u
X928 VSS.t1056 VSS.t1057 VSS.t54 rhigh l=1.6u w=0.5u
X929 VSS.t934 two_stage_instrumentation_amplifier_0.ota_slow_gmid_1.ota_slow_gmid_buffer_0.ibiasn.t0 two_stage_instrumentation_amplifier_0.vamp1.t5 VSS.t932 sg13_lv_nmos ad=0.1075p pd=1.34u as=0.1075p ps=1.34u w=0.25u l=0.5u
X930 VSS.t125 VSS.t126 VSS.t124 rhigh l=0.96u w=0.5u
X931 VSS.t127 VSS.t128 VSS.t54 rhigh l=1.6u w=0.5u
X932 VSS.t425 VSS.t426 VSS.t424 rhigh l=0.96u w=0.5u
X933 VSS.t265 two_stage_instrumentation_amplifier_0.ota_slow_gmid_0.en_n.t2 two_stage_instrumentation_amplifier_0.ota_slow_gmid_0.vout1.t6 VSS.t264 sg13_lv_nmos ad=0.228p pd=1.58u as=0.408p ps=3.08u w=1.2u l=0.13u
X934 VBIAS.t7 two_stage_instrumentation_amplifier_0.ota_slow_gmid_1.en.t3 VDD.t18 VDD.t0 sg13_lv_pmos ad=0.19p pd=1.38u as=0.19p ps=1.38u w=1u l=0.13u
X935 VAMP.t7 two_stage_instrumentation_amplifier_0.ota_slow_gmid_0.ota_slow_gmid_buffer_0.ibiasn.t0 VSS.t317 VSS.t316 sg13_lv_nmos ad=0.1075p pd=1.34u as=0.1075p ps=1.34u w=0.25u l=0.5u
X936 VSS.t510 VSS.t507 VSS.t509 VSS.t508 sg13_lv_nmos ad=0.17p pd=1.68u as=0 ps=0 w=0.5u l=2u
X937 IOVDD.t221 VBIASH.t19 non_inverting_amplifier_hv_0.ota_hv_slow_gmid_0.ota_hv_slow_gmid_tail_0.tail.t2 IOVDD.t3 sg13_hv_pmos ad=0.19p pd=1.38u as=0.34p ps=2.68u w=1u l=0.5u
X938 VAMP.t3 two_stage_instrumentation_amplifier_0.ota_slow_gmid_0.ota_slow_gmid_buffer_0.ibiasn.t0 VSS.t315 VSS.t311 sg13_lv_nmos ad=0.1075p pd=1.34u as=0.1075p ps=1.34u w=0.25u l=0.5u
X939 VDD.t29 a_5221_5436.t0 VSS.t102 rhigh l=2.5u w=0.5u
X940 VSS.t282 two_stage_instrumentation_amplifier_0.ota_slow_gmid_0.en_n.t4 two_stage_instrumentation_amplifier_0.ota_slow_gmid_0.vout1.t12 VSS.t281 sg13_lv_nmos ad=0.228p pd=1.58u as=0.408p ps=3.08u w=1.2u l=0.13u
X941 VDD.t112 VDD.t110 VDD.t111 VDD.t54 sg13_lv_pmos ad=0.34p pd=2.68u as=0 ps=0 w=1u l=0.5u
X942 VSS.t196 VSS.t197 VSS.t195 rhigh l=3u w=0.5u
X943 VDD.t17 two_stage_instrumentation_amplifier_0.ota_slow_gmid_1.en.t3 VBIAS.t6 VDD.t0 sg13_lv_pmos ad=0.19p pd=1.38u as=0.19p ps=1.38u w=1u l=0.13u
X944 VSS.t199 VSS.t200 VSS.t198 rppd l=1.43u w=0.5u
X945 VSS.t314 two_stage_instrumentation_amplifier_0.ota_slow_gmid_0.ota_slow_gmid_buffer_0.ibiasn.t0 VAMP.t4 VSS.t313 sg13_lv_nmos ad=0.1075p pd=1.34u as=0.1075p ps=1.34u w=0.25u l=0.5u
X946 a_n17989_4249.t0 dw_n18308_4910.t0 VSS.t168 rhigh l=2.5u w=0.5u
X947 VSS.t506 VSS.t492 VSS.t505 VSS.t493 sg13_lv_nmos ad=0.1075p pd=1.34u as=0 ps=0 w=0.25u l=0.5u
X948 VDD.t57 two_stage_instrumentation_amplifier_0.ota_slow_gmid_0.en.t2 VBIAS.t12 VDD.t55 sg13_lv_pmos ad=0.19p pd=1.38u as=0.19p ps=1.38u w=1u l=0.13u
X949 IOVDD.t33 current_source_1mA_0.current_source_1mA_2_stage_0.current_source_pass_element_0.iref.t4 ref_selector_0.I1MA.t2 IOVDD.t31 sg13_hv_pmos ad=0.285p pd=1.88u as=0.285p ps=1.88u w=1.5u l=0.5u
X950 two_stage_instrumentation_amplifier_0.ota_slow_gmid_0.vota.t0 two_stage_instrumentation_amplifier_0.VP.t3 two_stage_instrumentation_amplifier_0.ota_slow_gmid_0.ota_slow_gmid_common_0/ota_slow_gmid_pairs_0.tail.t0 VDD.t55 sg13_lv_pmos ad=0.85p pd=5.68u as=0.475p ps=2.88u w=2.5u l=5u
X951 VSS.t263 two_stage_instrumentation_amplifier_0.ota_slow_gmid_0.en_n.t2 two_stage_instrumentation_amplifier_0.ota_slow_gmid_0.vout1.t5 VSS.t262 sg13_lv_nmos ad=0.228p pd=1.58u as=0.228p ps=1.58u w=1.2u l=0.13u
X952 VSS.t503 VSS.t500 VSS.t502 VSS.t501 sg13_hv_nmos ad=0.34p pd=2.68u as=0 ps=0 w=1u l=1u
X953 VSS.t1041 VSS.t1042 VSS.t458 rhigh l=2.5u w=0.5u
X954 IOVDD.t72 IOVDD.t70 IOVDD.t71 IOVDD.t20 sg13_hv_pmos ad=0.9996p pd=6.56u as=0 ps=0 w=2.94u l=1u
X955 VSS.t899 non_inverting_amplifier_hv_0.ota_hv_slow_gmid_0.vota.t6 non_inverting_amplifier_hv_0.ota_hv_slow_gmid_0.vamp.t17 VSS.t898 sg13_hv_nmos ad=0.81225p pd=4.655u as=1.4535p ps=9.23u w=4.275u l=10u
X956 IOVDD.t69 IOVDD.t67 IOVDD.t68 IOVDD.t28 sg13_hv_pmos ad=0.6069p pd=4.25u as=0 ps=0 w=1.785u l=3u
X957 dw_n18308_4910.t3 two_stage_instrumentation_amplifier_0.ota_slow_gmid_1.vota.t8 dw_n18308_4910.t2 dw_n18308_4910.t1 sg13_lv_pmos ad=1.02p pd=6.68u as=0 ps=0 w=3u l=3u
X958 VSS.t499 VSS.t496 VSS.t498 VSS.t497 sg13_lv_nmos ad=0.1075p pd=1.34u as=0 ps=0 w=0.25u l=0.5u
X959 VSS.t1059 VSS.t1060 VSS.t1058 rhigh l=1.6u w=0.5u
X960 a_6571_1529.t1 a_6977_1799.t1 VSS.t96 rhigh l=1.6u w=0.5u
X961 two_stage_instrumentation_amplifier_0.ota_slow_gmid_0.vout1.t11 two_stage_instrumentation_amplifier_0.ota_slow_gmid_0.en_n.t4 VSS.t280 VSS.t279 sg13_lv_nmos ad=0.228p pd=1.58u as=0.228p ps=1.58u w=1.2u l=0.13u
X962 ref_selector_0.VMIN.t1 VSS.t135 VSS.t134 rppd l=1.43u w=0.5u
X963 VSS.t421 VSS.t422 VSS.t96 rhigh l=1.6u w=0.5u
X964 VSS.t933 two_stage_instrumentation_amplifier_0.ota_slow_gmid_1.ota_slow_gmid_buffer_0.ibiasn.t0 two_stage_instrumentation_amplifier_0.ota_slow_gmid_1.ota_slow_gmid_buffer_0.ibiasn.t1 VSS.t932 sg13_lv_nmos ad=0.1075p pd=1.34u as=0.1075p ps=1.34u w=0.25u l=0.5u
X965 VAMP.t5 two_stage_instrumentation_amplifier_0.ota_slow_gmid_0.ota_slow_gmid_buffer_0.ibiasn.t0 VSS.t312 VSS.t311 sg13_lv_nmos ad=0.1075p pd=1.34u as=0.1075p ps=1.34u w=0.25u l=0.5u
X966 two_stage_instrumentation_amplifier_0.vamp1.t4 two_stage_instrumentation_amplifier_0.ota_slow_gmid_1.ota_slow_gmid_buffer_0.ibiasn.t0 VSS.t931 VSS.t927 sg13_lv_nmos ad=0.1075p pd=1.34u as=0.1075p ps=1.34u w=0.25u l=0.5u
X967 VSS.t310 two_stage_instrumentation_amplifier_0.ota_slow_gmid_0.ota_slow_gmid_buffer_0.ibiasn.t0 VAMP.t6 VSS.t309 sg13_lv_nmos ad=0.1075p pd=1.34u as=0.1075p ps=1.34u w=0.25u l=0.5u
X968 IOVDD.t66 IOVDD.t64 IOVDD.t65 IOVDD.t16 sg13_hv_pmos ad=0.34p pd=2.68u as=0 ps=0 w=1u l=0.5u
X969 non_inverting_amplifier_hv_0.ota_hv_slow_gmid_0.vamp.t1 non_inverting_amplifier_hv_0.ota_hv_slow_gmid_0.en_n.t8 VSS.t234 VSS.t238 sg13_hv_nmos ad=0.7548p pd=5.12u as=0.4218p ps=2.6u w=2.22u l=0.45u
X970 VSS.t308 two_stage_instrumentation_amplifier_0.ota_slow_gmid_0.ota_slow_gmid_buffer_0.ibiasn.t0 VAMP.t1 VSS.t307 sg13_lv_nmos ad=0.1075p pd=1.34u as=0.1075p ps=1.34u w=0.25u l=0.5u
X971 a_19302_8442.t0 a_19572_8164.t0 VSS.t27 rhigh l=0.96u w=0.5u
X972 VSS.t29 VSS.t30 VSS.t28 rhigh l=0.96u w=0.5u
X973 two_stage_instrumentation_amplifier_0.ota_slow_gmid_0.ota_slow_gmid_common_0/ota_slow_gmid_pairs_0.tail.t0 two_stage_instrumentation_amplifier_0.top_conditionning_gain_s2_0.vn2.t3 two_stage_instrumentation_amplifier_0.ota_slow_gmid_0.ota_slow_gmid_mirror_0.vref.t1 VDD.t55 sg13_lv_pmos ad=0.475p pd=2.88u as=0.85p ps=5.68u w=2.5u l=5u
X974 VSS.t495 VSS.t492 VSS.t494 VSS.t493 sg13_lv_nmos ad=0.1075p pd=1.34u as=0 ps=0 w=0.25u l=0.5u
X975 VSS.t491 VSS.t488 VSS.t490 VSS.t489 sg13_lv_nmos ad=0.1075p pd=1.34u as=0 ps=0 w=0.25u l=0.5u
X976 VSS.t487 VSS.t484 VSS.t486 VSS.t485 sg13_lv_nmos ad=0.17p pd=1.68u as=0 ps=0 w=0.5u l=2u
X977 IOVDD.t32 current_source_1mA_0.current_source_1mA_2_stage_0.current_source_pass_element_0.iref.t4 ref_selector_0.I1MA.t1 IOVDD.t31 sg13_hv_pmos ad=0.285p pd=1.88u as=0.285p ps=1.88u w=1.5u l=0.5u
X978 VSS.t483 VSS.t481 VSS.t483 VSS.t482 sg13_lv_nmos ad=0.19p pd=1.38u as=0 ps=0 w=1u l=0.13u
X979 IOVDD.t63 IOVDD.t61 IOVDD.t51 IOVDD.t31 sg13_hv_pmos ad=0.51p pd=3.68u as=0 ps=0 w=1.5u l=0.5u
X980 current_source_1mA_0.current_source_1mA_2_stage_0.current_source_pass_element_0.iref.t7 current_source_1mA_0.current_source_1mA_2_stage_0.current_source_pass_element_0.vota.t6 current_source_1mA_0.current_source_1mA_2_stage_0.vcp.t3 VSS.t1064 sg13_hv_nmos ad=0.1425p pd=1.13u as=0.1425p ps=1.13u w=0.75u l=0.5u
X981 two_stage_instrumentation_amplifier_0.ota_slow_gmid_1.vout1.t12 VBIAS.t32 VDD.t86 VDD.t0 sg13_lv_pmos ad=0.34p pd=2.68u as=0.19p ps=1.38u w=1u l=0.5u
X982 ref_selector_0.ref_selector_r_96_0.vcal.t2 VSS.t250 VSS.t134 rppd l=1.43u w=0.5u
X983 VSS.t435 current_source_1mA_0.ota_med_hv_gmid_0.ota_med_hv_gmid_mirror_0.Iref.t0 current_source_1mA_0.ota_med_hv_gmid_0.ota_med_hv_gmid_mirror_0.vota.t0 VSS.t434 sg13_hv_nmos ad=0.646p pd=4.48u as=0.646p ps=4.48u w=1.9u l=2u
X984 a_2285_1463.t10 ota_lv_gmid_comparator_0.ota_slow_gmid_mirror_0.vout1.t15 ota_lv_gmid_comparator_0.ota_slow_gmid_ctrl_buff_0.x.t3 VSS.t253 sg13_lv_nmos ad=0.38p pd=2.38u as=0.38p ps=2.38u w=2u l=0.13u
X985 IOVDD.t60 IOVDD.t59 IOVDD.t60 IOVDD.t3 sg13_hv_pmos ad=0.19p pd=1.38u as=0 ps=0 w=1u l=0.5u
X986 VSS.t904 VSS.t905 VSS.t144 rppd l=1.43u w=0.5u
X987 non_inverting_amplifier_hv_0.ota_hv_slow_gmid_0.vamp.t0 non_inverting_amplifier_hv_0.ota_hv_slow_gmid_0.en_n.t4 VSS.t228 VSS.t227 sg13_hv_nmos ad=0.4218p pd=2.6u as=0.4218p ps=2.6u w=2.22u l=0.45u
X988 a_6571_2609.t1 a_6977_2339.t1 VSS.t96 rhigh l=1.6u w=0.5u
X989 VSS.t930 two_stage_instrumentation_amplifier_0.ota_slow_gmid_1.ota_slow_gmid_buffer_0.ibiasn.t0 two_stage_instrumentation_amplifier_0.vamp1.t3 VSS.t929 sg13_lv_nmos ad=0.1075p pd=1.34u as=0.1075p ps=1.34u w=0.25u l=0.5u
X990 VDD.t30 ota_lv_gmid_comparator_0.ota_slow_gmid_ctrl_buff_0.x.t6 a_2285_1463.t0 VSS.t103 sg13_lv_nmos ad=55.85f pd=0.74u as=55.85f ps=0.74u w=0.155u l=0.5u
X991 ota_lv_gmid_comparator_0.ota_slow_gmid_mirror_0.vout1.t6 ota_lv_gmid_comparator_0.ota_slow_gmid_ctrl_buff_1.y.t2 VDD.t227 VDD.t27 sg13_lv_pmos ad=0.27075p pd=1.805u as=0.27075p ps=1.805u w=1.425u l=0.13u
X992 a_6571_2069.t1 a_6977_2339.t0 VSS.t96 rhigh l=1.6u w=0.5u
X993 VSS.t480 VSS.t477 VSS.t479 VSS.t478 sg13_lv_nmos ad=0.17p pd=1.68u as=0 ps=0 w=0.5u l=2u
X994 IOVDD.t58 IOVDD.t56 IOVDD.t57 IOVDD.t18 sg13_hv_pmos ad=0.34p pd=2.68u as=0 ps=0 w=1u l=0.5u
X995 two_stage_instrumentation_amplifier_0.vamp1.t2 two_stage_instrumentation_amplifier_0.ota_slow_gmid_1.ota_slow_gmid_buffer_0.ibiasn.t0 VSS.t928 VSS.t927 sg13_lv_nmos ad=0.1075p pd=1.34u as=0.1075p ps=1.34u w=0.25u l=0.5u
X996 two_stage_instrumentation_amplifier_0.ota_slow_gmid_1.en_n.t0 EN.t3 VSS.t1031 VSS.t1030 sg13_lv_nmos ad=0.68p pd=4.68u as=0.68p ps=4.68u w=2u l=0.13u
X997 VSS.t883 two_stage_instrumentation_amplifier_0.ota_slow_gmid_1.vota.t4 two_stage_instrumentation_amplifier_0.ota_slow_gmid_1.vout1.t14 VSS.t100 sg13_lv_nmos ad=95f pd=0.88u as=0.17p ps=1.68u w=0.5u l=10u
X998 VSS.t306 two_stage_instrumentation_amplifier_0.ota_slow_gmid_0.ota_slow_gmid_buffer_0.ibiasn.t0 VAMP.t2 VSS.t305 sg13_lv_nmos ad=0.1075p pd=1.34u as=0.1075p ps=1.34u w=0.25u l=0.5u
X999 a_6571_2069.t0 a_6977_1799.t0 VSS.t96 rhigh l=1.6u w=0.5u
C0 ota_lv_gmid_comparator_0.ota_slow_gmid_common_0/ota_slow_gmid_tail_0.ibiasn VBIAS 0.0909f
C1 top_conditionning_level_shifter_0.top_conditionning_inverter_0.X IOVDD 0.55734f
C2 a_12007_246# a_12277_246# 0.0202f
C3 ref_selector_0.VMIN a_11467_2208# 0.01811f
C4 a_7311_2339# a_7311_2069# 0.0226f
C5 two_stage_instrumentation_amplifier_0.ota_slow_gmid_0.vota a_n1531_4529# 0.04873f
C6 a_8619_1529# a_8619_1259# 0.0226f
C7 a_14614_530# SENSOR 0.01607f
C8 ref_selector_0.VMIN a_12007_1554# 0.04475f
C9 a_18492_7198# a_18762_7198# 0.01356f
C10 a_8619_2339# a_8619_2069# 0.0226f
C11 ref_selector_0.ref_selector_r_refs_0.R1 ref_selector_0.ref_selector_r_refs_0.R0 0.35757f
C12 rmod a_19302_7198# 0.01035f
C13 ref_selector_0.VMIN a_11467_900# 0.01482f
C14 current_source_1mA_0.current_source_1mA_2_stage_0.current_source_pass_element_0.vota current_source_1mA_0.ota_med_hv_gmid_0.ota_med_hv_gmid_tail_0.tail 1.16514f
C15 a_19032_7198# a_19302_7198# 0.01356f
C16 VDD VBIAS 20.9289f
C17 a_17412_6672# a_17682_6672# 0.01356f
C18 ref_selector_0.VMIN two_stage_instrumentation_amplifier_0.VP 0.06475f
C19 ref_selector_0.ref_selector_r_refs_0.R3 S1 0.03662f
C20 ota_lv_gmid_comparator_0.ota_slow_gmid_mirror_0.vout1 ref_selector_0.VMIN 0.08307f
C21 ota_lv_gmid_comparator_0.ota_slow_gmid_mirror_0.vota ota_lv_gmid_comparator_0.ota_slow_gmid_ctrl_buff_1.ota_slow_gmid_ctrl_inv_0.x 0.01623f
C22 a_14614_1176# a_15014_1176# 0.02572f
C23 ota_lv_gmid_comparator_0.ota_slow_gmid_ctrl_buff_1.y VBIAS 0.4475f
C24 a_8619_2069# a_8619_1799# 0.0226f
C25 IOVDD VDD 0.02062f
C26 a_n17104_4907# a_n16824_4907# 0.03996f
C27 current_source_1mA_0.ota_med_hv_gmid_0.ota_med_hv_gmid_mirror_0.Iref current_source_1mA_0.ota_med_hv_gmid_0.ota_med_hv_gmid_mirror_0.vota 2.56157f
C28 a_17682_8776# a_17952_8776# 0.01356f
C29 a_n5332_4249# VDD 0.14107f
C30 a_n14781_4907# VDD 0.08846f
C31 two_stage_instrumentation_amplifier_0.ota_slow_gmid_0.ota_slow_gmid_common_0/ota_slow_gmid_pairs_0.tail VBIAS 0.24683f
C32 a_7311_1799# a_7311_1529# 0.0226f
C33 S2 S3 24.3927f
C34 a_19302_6672# a_19572_6672# 0.01356f
C35 a_1999_6094# VBIAS 0.01704f
C36 VBIASH COMPARATOR_RES 0.02584f
C37 a_n9874_1817# a_n9604_1817# 0.01356f
C38 ota_lv_gmid_comparator_0.ota_slow_gmid_common_0/ota_slow_gmid_pairs_0.tail ota_lv_gmid_comparator_0.ota_slow_gmid_mirror_0.vota 0.07368f
C39 ref_selector_0.ref_selector_r_96_0.vcal a_10657_2208# 0.01246f
C40 ref_selector_0.ref_selector_r_96_0.vcal a_11197_1554# 0.01768f
C41 S3 COMPARATOR_RES 0.02607f
C42 a_n16824_4907# VBIAS 0.01692f
C43 a_17682_8250# a_17952_8250# 0.01356f
C44 VDD VBG 0.70636f
C45 ref_selector_0.ref_selector_r_96_0.vcal a_10657_900# 0.01568f
C46 a_7311_3434# a_7311_3164# 0.0226f
C47 ref_selector_0.ref_selector_r_96_0.vcal a_11737_2862# 0.02322f
C48 ota_lv_gmid_comparator_0.ota_slow_gmid_mirror_0.vout1 ota_lv_gmid_comparator_0.ota_slow_gmid_ctrl_buff_0.ota_slow_gmid_ctrl_inv_0.x 0.02822f
C49 two_stage_instrumentation_amplifier_0.ota_slow_gmid_0.ota_slow_gmid_mirror_0.vref VDD 1.78017f
C50 ref_selector_0.VMIN ota_lv_gmid_comparator_0.ota_slow_gmid_ctrl_buff_0.x 0.01105f
C51 two_stage_instrumentation_amplifier_0.ota_slow_gmid_0.ota_slow_gmid_buffer_0.ibiasn VDD 1.17067f
C52 a_n9604_1291# a_n9334_1291# 0.01356f
C53 ref_selector_0.VMIN EN 0.034f
C54 a_18492_8250# a_18762_8250# 0.01356f
C55 a_n4533_4907# two_stage_instrumentation_amplifier_0.ota_slow_gmid_0.vout1 0.01187f
C56 a_10387_2208# a_10657_2208# 0.0202f
C57 ref_selector_0.ref_selector_r_96_0.vcal a_12007_246# 0.02138f
C58 ref_selector_0.I1MA current_source_1mA_0.ota_med_hv_gmid_0.ota_med_hv_gmid_mirror_0.vota 0.03187f
C59 ref_selector_0.ref_selector_r_refs_0.R2 S2 0.06929f
C60 two_stage_instrumentation_amplifier_0.ota_slow_gmid_0.vota two_stage_instrumentation_amplifier_0.VP 0.54678f
C61 S3 SEL_SENSOR 0.05043f
C62 a_19572_8250# a_19842_8250# 0.01356f
C63 S2 S0 0.0472f
C64 S3 S1 0.60503f
C65 a_10927_1554# a_11197_1554# 0.0202f
C66 two_stage_instrumentation_amplifier_0.ota_slow_gmid_0.ota_slow_gmid_buffer_0.ibiasn two_stage_instrumentation_amplifier_0.ota_slow_gmid_0.ota_slow_gmid_common_0/ota_slow_gmid_pairs_0.tail 0.40234f
C67 a_12277_2208# a_12547_2208# 0.0202f
C68 two_stage_instrumentation_amplifier_0.ota_slow_gmid_0.ota_slow_gmid_common_0/ota_slow_gmid_pairs_0.tail two_stage_instrumentation_amplifier_0.ota_slow_gmid_0.ota_slow_gmid_mirror_0.vref 0.04038f
C69 two_stage_instrumentation_amplifier_0.ota_slow_gmid_1.ota_slow_gmid_buffer_0.ibiasn a_n14501_4907# 0.01612f
C70 a_4666_5942# VDD 1.6017f
C71 a_10387_900# a_10657_900# 0.0202f
C72 a_11467_2862# a_11737_2862# 0.0202f
C73 a_n9334_3765# a_n9064_3765# 0.0226f
C74 S0 COMPARATOR_RES 0.02294f
C75 a_4721_5436# VDD 0.19516f
C76 current_source_1mA_0.current_source_1mA_2_stage_0.current_source_pass_element_0.iref current_source_1mA_0.ota_med_hv_gmid_0.ota_med_hv_gmid_mirror_0.vota 0.1981f
C77 a_12277_900# a_12547_900# 0.0202f
C78 a_7965_2609# a_7965_2339# 0.0226f
C79 ref_selector_0.ref_selector_r_refs_0.R3 a_7965_2339# 0.03233f
C80 ota_lv_gmid_comparator_0.ota_slow_gmid_ctrl_buff_0.x ota_lv_gmid_comparator_0.ota_slow_gmid_ctrl_buff_0.ota_slow_gmid_ctrl_inv_0.x 0.06925f
C81 ref_selector_0.VMIN a_9273_719# 0.02071f
C82 two_stage_instrumentation_amplifier_0.ota_slow_gmid_0.vota a_n1930_4907# 0.0192f
C83 a_9273_2609# a_9273_2339# 0.0226f
C84 ota_lv_gmid_comparator_0.ota_slow_gmid_mirror_0.vout1 two_stage_instrumentation_amplifier_0.VP 0.16223f
C85 a_19032_7724# a_19302_7724# 0.01356f
C86 a_11737_246# a_12007_246# 0.0202f
C87 a_920_5436# VDD 0.1949f
C88 current_source_1mA_0.current_source_1mA_2_stage_0.vcp a_15014_1822# 0.02605f
C89 a_4322_6094# two_stage_instrumentation_amplifier_0.VP 0.01484f
C90 ref_selector_0.VMIN a_11467_1554# 0.01683f
C91 a_14214_530# SENSOR 0.03476f
C92 ota_lv_gmid_comparator_0.ota_slow_gmid_mirror_0.vout1 a_4322_6094# 0.01538f
C93 ota_lv_gmid_comparator_0.ota_slow_gmid_common_0/ota_slow_gmid_pairs_0.tail ota_lv_gmid_comparator_0.ota_slow_gmid_mirror_0.vref 0.04038f
C94 ref_selector_0.VMIN a_8619_719# 0.0406f
C95 rmod a_19032_7198# 0.01879f
C96 ref_selector_0.VMIN a_10927_900# 0.02201f
C97 a_14214_1822# a_14614_1822# 0.02572f
C98 S1 S0 26.9164f
C99 ref_selector_0.VMIN a_12007_2862# 0.02179f
C100 a_n14781_4907# a_n14501_4907# 0.03996f
C101 S0 SEL_SENSOR 0.04287f
C102 S3 SEL_CAL 25.4823f
C103 a_9273_434# a_9273_164# 0.0226f
C104 a_19572_7198# a_19842_7198# 0.01356f
C105 two_stage_instrumentation_amplifier_0.ota_slow_gmid_0.vota EN 0.20342f
C106 ref_selector_0.VMIN a_7965_719# 0.03947f
C107 a_7965_1259# a_7965_989# 0.0226f
C108 a_18222_6672# a_18492_6672# 0.01356f
C109 a_7965_1529# a_7965_1259# 0.0226f
C110 a_9273_2069# a_9273_1799# 0.0226f
C111 ref_selector_0.VMIN a_7311_719# 0.02011f
C112 current_source_1mA_0.ota_med_hv_gmid_0.ota_med_hv_gmid_mirror_0.vota SENSOR 3.34398f
C113 a_13814_530# a_14214_530# 0.02572f
C114 current_source_1mA_0.ota_med_hv_gmid_0.ota_med_hv_gmid_tail_0.tail current_source_1mA_0.ota_med_hv_gmid_0.ota_med_hv_gmid_mirror_0.Iref 0.16202f
C115 ota_lv_gmid_comparator_0.ota_slow_gmid_common_0/ota_slow_gmid_pairs_0.tail ref_selector_0.VMIN 0.22789f
C116 two_stage_instrumentation_amplifier_0.ota_slow_gmid_0.vout1 two_stage_instrumentation_amplifier_0.top_conditionning_gain_s2_0.vn2 0.93392f
C117 a_8619_434# a_8619_164# 0.0226f
C118 VBIAS VBIASH 0.02577f
C119 a_18492_8776# a_18762_8776# 0.01356f
C120 ota_lv_gmid_comparator_0.ota_slow_gmid_common_0/ota_slow_gmid_tail_0.ibiasn VDD 1.13005f
C121 a_n14102_4249# VDD 0.14107f
C122 ref_selector_0.VMIN a_6657_719# 0.03962f
C123 IOVDD VBIASH 11.4424f
C124 non_inverting_amplifier_hv_0.top_conditionning_gain_s3_0.vn3 rmod 0.19078f
C125 ota_lv_gmid_comparator_0.ota_slow_gmid_mirror_0.vout1 ota_lv_gmid_comparator_0.ota_slow_gmid_ctrl_buff_0.x 0.45106f
C126 VBIAS S3 0.02395f
C127 two_stage_instrumentation_amplifier_0.VP EN 20.9539f
C128 ota_lv_gmid_comparator_0.ota_slow_gmid_mirror_0.vref COMPARATOR_RES 0.08853f
C129 two_stage_instrumentation_amplifier_0.ota_slow_gmid_1.vout1 two_stage_instrumentation_amplifier_0.ota_slow_gmid_1.ota_slow_gmid_mirror_0.vref 3.42932f
C130 ref_selector_0.VMIN a_9273_989# 0.0125f
C131 a_17142_8250# a_17412_8250# 0.01356f
C132 ref_selector_0.VMIN ref_selector_0.I1MA 0.02214f
C133 ref_selector_0.VMIN S2 0.26039f
C134 ref_selector_0.ref_selector_r_96_0.vcal a_10657_1554# 0.01796f
C135 a_n9334_1817# a_n9064_1817# 0.01356f
C136 ref_selector_0.ref_selector_r_96_0.vcal a_12007_2208# 0.03973f
C137 a_7965_434# a_7965_164# 0.0226f
C138 S0 SEL_CAL 0.18995f
C139 ref_selector_0.VMIN a_8619_1259# 0.01173f
C140 IOVDD VOUT 7.06875f
C141 ref_selector_0.ref_selector_r_96_0.vcal a_11197_2862# 0.02547f
C142 a_6657_3434# a_6657_3164# 0.0226f
C143 ota_lv_gmid_comparator_0.ota_slow_gmid_ctrl_buff_1.y VDD 4.69242f
C144 two_stage_instrumentation_amplifier_0.ota_slow_gmid_1.vout1 EN 0.51677f
C145 ref_selector_0.ref_selector_r_96_0.vcal a_12007_900# 0.03613f
C146 current_source_1mA_0.current_source_1mA_2_stage_0.current_source_pass_element_0.vota current_source_1mA_0.ota_med_hv_gmid_0.ota_med_hv_gmid_mirror_0.Iref 0.09531f
C147 a_n4533_4907# two_stage_instrumentation_amplifier_0.ota_slow_gmid_0.ota_slow_gmid_buffer_0.ibiasn 0.01612f
C148 ref_selector_0.ref_selector_r_96_0.vcal a_11467_246# 0.02177f
C149 a_n2210_4907# VBIAS 0.01663f
C150 two_stage_instrumentation_amplifier_0.ota_slow_gmid_0.ota_slow_gmid_common_0/ota_slow_gmid_pairs_0.tail VDD 0.56886f
C151 ref_selector_0.VMIN a_8619_989# 0.01436f
C152 ref_selector_0.VMIN COMPARATOR_RES 0.68716f
C153 a_19302_8250# a_19572_8250# 0.01356f
C154 VBIASH VBG 33.1523f
C155 a_7311_434# a_7311_164# 0.0226f
C156 a_10657_1554# a_10927_1554# 0.0202f
C157 ota_lv_gmid_comparator_0.ota_slow_gmid_mirror_0.vota VBIAS 0.57304f
C158 a_12007_2208# a_12277_2208# 0.0202f
C159 a_6657_2879# a_6657_2609# 0.0226f
C160 a_1999_6094# VDD 0.14322f
C161 a_4042_6094# VDD 0.13092f
C162 VBIAS S0 0.02747f
C163 ref_selector_0.VMIN ref_selector_0.ref_selector_r_96_0.vcal 3.23855f
C164 a_8619_2879# a_8619_2609# 0.0226f
C165 current_source_1mA_0.ota_med_hv_gmid_0.ota_med_hv_gmid_mirror_0.vota IOVDD 3.80507f
C166 a_11197_2862# a_11467_2862# 0.0202f
C167 ref_selector_0.VMIN a_7965_989# 0.01794f
C168 ref_selector_0.VMIN a_7965_1529# 0.03053f
C169 ref_selector_0.VMIN SEL_SENSOR 0.01603f
C170 a_n16824_4907# VDD 0.10076f
C171 ref_selector_0.VMIN S1 0.05292f
C172 a_17952_7724# a_18222_7724# 0.01356f
C173 ref_selector_0.ref_selector_r_refs_0.R1 a_8619_2879# 0.02407f
C174 a_6657_434# a_6657_164# 0.0226f
C175 a_12007_900# a_12277_900# 0.0202f
C176 a_4666_5942# a_4721_5716# 0.04855f
C177 a_n9334_3765# two_stage_instrumentation_amplifier_0.top_conditionning_gain_s2_0.vn2 0.01569f
C178 ref_selector_0.ref_selector_r_refs_0.R3 ref_selector_0.ref_selector_r_refs_0.R1 0.24207f
C179 a_1719_6094# two_stage_instrumentation_amplifier_0.VP 0.01457f
C180 ref_selector_0.ref_selector_r_refs_0.R0 S0 0.06821f
C181 a_9273_1529# a_9273_1259# 0.0226f
C182 a_14214_1176# SENSOR 0.01022f
C183 a_11467_246# a_11737_246# 0.0202f
C184 ref_selector_0.I1MA current_source_1mA_0.current_source_1mA_2_stage_0.current_source_pass_element_0.vota 0.07045f
C185 current_source_1mA_0.current_source_1mA_2_stage_0.vcp a_14614_1822# 0.0102f
C186 a_4721_5716# a_4721_5436# 0.0333f
C187 ref_selector_0.VMIN a_12277_2208# 0.01201f
C188 ref_selector_0.VMIN a_10927_1554# 0.01498f
C189 a_18222_7198# a_18492_7198# 0.01356f
C190 a_7965_2339# a_7965_2069# 0.0226f
C191 ref_selector_0.VMIN a_7311_989# 0.01319f
C192 ota_lv_gmid_comparator_0.ota_slow_gmid_ctrl_buff_0.ota_slow_gmid_ctrl_inv_0.x COMPARATOR_RES 0.0678f
C193 ref_selector_0.VMIN SENSOR 0.05414f
C194 a_875_5942# two_stage_instrumentation_amplifier_0.VP 0.08653f
C195 a_18762_7198# a_19032_7198# 0.01356f
C196 a_9273_719# a_9273_434# 0.02072f
C197 ref_selector_0.VMIN a_12277_900# 0.01201f
C198 a_17142_6672# a_17412_6672# 0.01356f
C199 ota_lv_gmid_comparator_0.ota_slow_gmid_mirror_0.vout1 ota_lv_gmid_comparator_0.ota_slow_gmid_common_0/ota_slow_gmid_pairs_0.tail 0.09425f
C200 a_19302_7198# a_19572_7198# 0.01356f
C201 current_source_1mA_0.ota_med_hv_gmid_0.ota_med_hv_gmid_mirror_0.vota VBG 0.73609f
C202 a_17412_8776# VOUT 0.01284f
C203 ref_selector_0.VMIN a_11737_246# 0.02105f
C204 a_7965_2069# a_7965_1799# 0.0226f
C205 a_17412_8776# a_17682_8776# 0.01356f
C206 current_source_1mA_0.current_source_1mA_2_stage_0.current_source_pass_element_0.iref current_source_1mA_0.current_source_1mA_2_stage_0.current_source_pass_element_0.vota 0.52811f
C207 ref_selector_0.VMIN SEL_CAL 0.01776f
C208 two_stage_instrumentation_amplifier_0.VP ref_selector_0.I1MA 0.20121f
C209 ota_lv_gmid_comparator_0.ota_slow_gmid_ctrl_buff_1.ota_slow_gmid_ctrl_inv_0.x EN 0.06346f
C210 a_6657_1799# a_6657_1529# 0.0226f
C211 two_stage_instrumentation_amplifier_0.ota_slow_gmid_0.ota_slow_gmid_buffer_0.ibiasn two_stage_instrumentation_amplifier_0.top_conditionning_gain_s2_0.vn2 0.91819f
C212 a_8619_719# a_8619_434# 0.02072f
C213 two_stage_instrumentation_amplifier_0.top_conditionning_gain_s2_0.vn2 two_stage_instrumentation_amplifier_0.ota_slow_gmid_0.ota_slow_gmid_mirror_0.vref 0.53272f
C214 two_stage_instrumentation_amplifier_0.VP S2 0.03033f
C215 a_19032_6672# a_19302_6672# 0.01356f
C216 current_source_1mA_0.current_source_1mA_2_stage_0.vcp current_source_1mA_0.ota_med_hv_gmid_0.ota_med_hv_gmid_mirror_0.vota 0.43576f
C217 a_7311_1529# a_7311_1259# 0.0226f
C218 two_stage_instrumentation_amplifier_0.ota_slow_gmid_1.vout1 two_stage_instrumentation_amplifier_0.ota_slow_gmid_1.ota_slow_gmid_common_0/ota_slow_gmid_pairs_0.tail 0.09805f
C219 ref_selector_0.VMIN a_6657_989# 0.01205f
C220 a_n9334_4419# a_n9064_4419# 0.0226f
C221 a_9273_1799# a_9273_1529# 0.0226f
C222 a_n9334_2343# a_n9064_2343# 0.01356f
C223 a_19302_8776# a_19572_8776# 0.01356f
C224 non_inverting_amplifier_hv_0.top_conditionning_gain_s3_0.vn3 non_inverting_amplifier_hv_0.ota_hv_slow_gmid_0.ota_hv_slow_gmid_tail_0.tail 0.18605f
C225 two_stage_instrumentation_amplifier_0.ota_slow_gmid_1.vout1 two_stage_instrumentation_amplifier_0.ota_slow_gmid_1.VN 0.93391f
C226 a_n9604_1817# a_n9334_1817# 0.01356f
C227 two_stage_instrumentation_amplifier_0.VP COMPARATOR_RES 0.02806f
C228 ref_selector_0.ref_selector_r_96_0.vcal a_11467_2208# 0.02267f
C229 a_7965_719# a_7965_434# 0.02072f
C230 two_stage_instrumentation_amplifier_0.ota_slow_gmid_1.ota_slow_gmid_common_0/ota_slow_gmid_pairs_0.tail two_stage_instrumentation_amplifier_0.ota_slow_gmid_1.ota_slow_gmid_mirror_0.vref 0.04038f
C231 ota_lv_gmid_comparator_0.ota_slow_gmid_mirror_0.vout1 COMPARATOR_RES 2.14051f
C232 ref_selector_0.ref_selector_r_96_0.vcal a_12007_1554# 0.01347f
C233 ref_selector_0.ref_selector_r_96_0.vcal a_10657_2862# 0.01019f
C234 non_inverting_amplifier_hv_0.top_conditionning_gain_s3_0.vn3 a_19572_6672# 0.02403f
C235 two_stage_instrumentation_amplifier_0.ota_slow_gmid_0.vota two_stage_instrumentation_amplifier_0.ota_slow_gmid_0.vout1 4.02515f
C236 a_n9874_1291# a_n9604_1291# 0.01356f
C237 ref_selector_0.VMIN VBIAS 1.03875f
C238 ref_selector_0.ref_selector_r_96_0.vcal a_11467_900# 0.06711f
C239 a_18222_8250# a_18492_8250# 0.01356f
C240 current_source_1mA_0.current_source_1mA_2_stage_0.current_source_pass_element_0.vota SENSOR 0.45823f
C241 ref_selector_0.ref_selector_r_96_0.vcal a_10927_246# 0.02187f
C242 a_n9334_1291# a_n9064_1291# 0.01356f
C243 a_4721_5716# VDD 0.04863f
C244 two_stage_instrumentation_amplifier_0.ota_slow_gmid_1.VN two_stage_instrumentation_amplifier_0.ota_slow_gmid_1.ota_slow_gmid_mirror_0.vref 0.53272f
C245 two_stage_instrumentation_amplifier_0.VP ref_selector_0.ref_selector_r_96_0.vcal 0.94055f
C246 a_n4253_4907# two_stage_instrumentation_amplifier_0.ota_slow_gmid_0.vout1 0.01234f
C247 VDD VBIASH 0.60496f
C248 a_7965_3164# a_7965_2879# 0.02072f
C249 two_stage_instrumentation_amplifier_0.VP SEL_SENSOR 1.12824f
C250 a_7311_719# a_7311_434# 0.02072f
C251 two_stage_instrumentation_amplifier_0.VP S1 0.03261f
C252 a_10387_1554# a_10657_1554# 0.0202f
C253 a_11737_2208# a_12007_2208# 0.0202f
C254 EN S2 0.02012f
C255 ref_selector_0.VMIN ref_selector_0.ref_selector_r_refs_0.R0 0.01011f
C256 VDD S3 0.55656f
C257 a_7311_2879# a_7311_2609# 0.0226f
C258 a_12277_1554# a_12547_1554# 0.0202f
C259 a_6657_1259# a_6657_989# 0.0226f
C260 a_10927_2862# a_11197_2862# 0.0202f
C261 two_stage_instrumentation_amplifier_0.VP SENSOR 1.10497f
C262 current_source_1mA_0.ota_med_hv_gmid_0.ota_med_hv_gmid_tail_0.tail IOVDD 1.00839f
C263 a_11737_900# a_12007_900# 0.0202f
C264 a_6657_719# a_6657_434# 0.02072f
C265 a_n9604_3111# a_n9334_3111# 0.0226f
C266 a_7311_2609# a_7311_2339# 0.0226f
C267 a_n9604_3765# a_n9334_3765# 0.0226f
C268 ref_selector_0.ref_selector_r_refs_0.R1 S0 0.04639f
C269 EN COMPARATOR_RES 2.13231f
C270 a_8619_2609# a_8619_2339# 0.0226f
C271 a_18762_7724# a_19032_7724# 0.01356f
C272 a_n2210_4907# VDD 0.08728f
C273 a_11197_246# a_11467_246# 0.0202f
C274 ref_selector_0.VMIN a_11737_2208# 0.01895f
C275 ref_selector_0.VMIN a_12277_1554# 0.01201f
C276 a_15014_530# SENSOR 0.03223f
C277 ota_lv_gmid_comparator_0.ota_slow_gmid_mirror_0.vota VDD 3.35631f
C278 two_stage_instrumentation_amplifier_0.VP SEL_CAL 0.12643f
C279 ref_selector_0.VMIN a_10927_2862# 0.02117f
C280 a_9273_989# a_9273_719# 0.0226f
C281 a_14614_1822# a_15014_1822# 0.02572f
C282 two_stage_instrumentation_amplifier_0.ota_slow_gmid_0.vota VBIAS 3.85468f
C283 EN SEL_SENSOR 0.0246f
C284 ota_lv_gmid_comparator_0.ota_slow_gmid_mirror_0.vota ota_lv_gmid_comparator_0.ota_slow_gmid_ctrl_buff_1.y 0.08907f
C285 EN S1 0.01995f
C286 VDD S0 0.71683f
C287 ref_selector_0.VMIN a_11197_246# 0.02078f
C288 a_13814_1176# a_14214_1176# 0.02572f
C289 current_source_1mA_0.current_source_1mA_2_stage_0.current_source_pass_element_0.vota IOVDD 4.73066f
C290 current_source_1mA_0.ota_med_hv_gmid_0.ota_med_hv_gmid_tail_0.tail VBG 0.32372f
C291 a_17952_6672# a_18222_6672# 0.01356f
C292 two_stage_instrumentation_amplifier_0.top_conditionning_gain_s2_0.vn2 VDD 4.25058f
C293 a_n14102_4529# a_n14102_4249# 0.0333f
C294 a_n1531_4249# VDD 0.14107f
C295 two_stage_instrumentation_amplifier_0.ota_slow_gmid_0.vout1 EN 0.51677f
C296 a_18222_8776# a_18492_8776# 0.01356f
C297 a_14214_530# a_14614_530# 0.02572f
C298 a_n9874_4419# a_n9604_4419# 0.0226f
C299 a_n9874_2343# a_n9604_2343# 0.01356f
C300 two_stage_instrumentation_amplifier_0.ota_slow_gmid_1.vout1 two_stage_instrumentation_amplifier_0.ota_slow_gmid_1.ota_slow_gmid_buffer_0.ibiasn 1.32313f
C301 current_source_1mA_0.ota_med_hv_gmid_0.ota_med_hv_gmid_tail_0.tail current_source_1mA_0.current_source_1mA_2_stage_0.vcp 0.1878f
C302 two_stage_instrumentation_amplifier_0.ota_slow_gmid_0.ota_slow_gmid_common_0/ota_slow_gmid_pairs_0.tail two_stage_instrumentation_amplifier_0.top_conditionning_gain_s2_0.vn2 0.22787f
C303 a_8619_989# a_8619_719# 0.0226f
C304 two_stage_instrumentation_amplifier_0.VP VBIAS 0.52413f
C305 ota_lv_gmid_comparator_0.ota_slow_gmid_mirror_0.vout1 VBIAS 0.22861f
C306 two_stage_instrumentation_amplifier_0.VP IOVDD 0.28672f
C307 ref_selector_0.ref_selector_r_refs_0.R3 S3 0.06902f
C308 ref_selector_0.ref_selector_r_96_0.vcal a_10927_2208# 0.05357f
C309 current_source_1mA_0.current_source_1mA_2_stage_0.current_source_pass_element_0.vota VBG 0.07966f
C310 two_stage_instrumentation_amplifier_0.ota_slow_gmid_1.ota_slow_gmid_buffer_0.ibiasn two_stage_instrumentation_amplifier_0.ota_slow_gmid_1.ota_slow_gmid_mirror_0.vref 0.03366f
C311 a_n9064_1817# a_n8794_1817# 0.01356f
C312 ref_selector_0.ref_selector_r_96_0.vcal a_11467_1554# 0.02322f
C313 two_stage_instrumentation_amplifier_0.ota_slow_gmid_1.vout1 VBIAS 0.24054f
C314 EN SEL_CAL 0.02081f
C315 two_stage_instrumentation_amplifier_0.ota_slow_gmid_1.ota_slow_gmid_common_0/ota_slow_gmid_pairs_0.tail two_stage_instrumentation_amplifier_0.ota_slow_gmid_1.VN 0.22787f
C316 two_stage_instrumentation_amplifier_0.ota_slow_gmid_0.vota two_stage_instrumentation_amplifier_0.ota_slow_gmid_0.ota_slow_gmid_buffer_0.ibiasn 0.78367f
C317 two_stage_instrumentation_amplifier_0.ota_slow_gmid_0.vota two_stage_instrumentation_amplifier_0.ota_slow_gmid_0.ota_slow_gmid_mirror_0.vref 4.5582f
C318 ref_selector_0.ref_selector_r_96_0.vcal a_10927_900# 0.06559f
C319 a_n4253_4907# two_stage_instrumentation_amplifier_0.ota_slow_gmid_0.ota_slow_gmid_buffer_0.ibiasn 0.01666f
C320 a_n1930_4907# VBIAS 0.01633f
C321 ota_lv_gmid_comparator_0.ota_slow_gmid_mirror_0.vref VDD 2.31937f
C322 current_source_1mA_0.current_source_1mA_2_stage_0.current_source_pass_element_0.vota current_source_1mA_0.current_source_1mA_2_stage_0.vcp 2.94596f
C323 a_19032_8250# a_19302_8250# 0.01356f
C324 two_stage_instrumentation_amplifier_0.ota_slow_gmid_1.vout1 a_n14781_4907# 0.01195f
C325 ref_selector_0.VMIN ref_selector_0.ref_selector_r_refs_0.R1 0.06078f
C326 a_7965_989# a_7965_719# 0.0226f
C327 a_11467_2208# a_11737_2208# 0.0202f
C328 two_stage_instrumentation_amplifier_0.ota_slow_gmid_1.ota_slow_gmid_mirror_0.vref VBIAS 0.43634f
C329 a_9273_3164# a_9273_2879# 0.02072f
C330 ota_lv_gmid_comparator_0.ota_slow_gmid_mirror_0.vref ota_lv_gmid_comparator_0.ota_slow_gmid_ctrl_buff_1.y 0.71076f
C331 two_stage_instrumentation_amplifier_0.VP VBG 0.01296f
C332 current_source_1mA_0.ota_med_hv_gmid_0.ota_med_hv_gmid_mirror_0.Iref SENSOR 0.30951f
C333 a_12007_1554# a_12277_1554# 0.0202f
C334 a_7965_2879# a_7965_2609# 0.0226f
C335 two_stage_instrumentation_amplifier_0.VP two_stage_instrumentation_amplifier_0.ota_slow_gmid_0.ota_slow_gmid_mirror_0.vref 0.19476f
C336 a_10657_2862# a_10927_2862# 0.0202f
C337 S2 COMPARATOR_RES 0.04086f
C338 ref_selector_0.ref_selector_r_refs_0.R2 ref_selector_0.ref_selector_r_refs_0.R3 0.98953f
C339 EN VBIAS 37.1376f
C340 current_source_1mA_0.current_source_1mA_2_stage_0.current_source_pass_element_0.iref ref_selector_0.I1MA 3.07797f
C341 a_8619_1259# a_8619_989# 0.0226f
C342 non_inverting_amplifier_hv_0.top_conditionning_gain_s3_0.vn3 IOVDD 4.33569f
C343 a_17682_7724# a_17952_7724# 0.01356f
C344 a_11467_900# a_11737_900# 0.0202f
C345 two_stage_instrumentation_amplifier_0.top_conditionning_gain_s2_0.vn2 a_n9064_3765# 0.01564f
C346 a_18222_7724# a_18492_7724# 0.01356f
C347 IOVDD EN 0.5763f
C348 ref_selector_0.VMIN VDD 5.18851f
C349 ref_selector_0.I1MA ref_selector_0.ref_selector_r_96_0.vcal 1.61998f
C350 ref_selector_0.ref_selector_r_refs_0.R0 a_9273_2879# 0.02277f
C351 a_10927_246# a_11197_246# 0.0202f
C352 VOUT VBIASH 0.01402f
C353 a_7311_989# a_7311_719# 0.0226f
C354 ref_selector_0.I1MA SEL_SENSOR 0.52407f
C355 ref_selector_0.ref_selector_r_refs_0.R3 a_7965_2069# 0.04789f
C356 ref_selector_0.VMIN a_11197_2208# 0.01895f
C357 S2 S1 24.2473f
C358 S2 SEL_SENSOR 0.04511f
C359 a_17952_7198# a_18222_7198# 0.01356f
C360 two_stage_instrumentation_amplifier_0.ota_slow_gmid_0.vota a_n5332_4529# 0.04873f
C361 a_4666_5942# two_stage_instrumentation_amplifier_0.VP 0.0881f
C362 ref_selector_0.VMIN a_11737_1554# 0.01951f
C363 a_875_5942# a_920_5716# 0.04856f
C364 ota_lv_gmid_comparator_0.ota_slow_gmid_mirror_0.vout1 a_4666_5942# 0.10845f
C365 a_7311_2069# a_7311_1799# 0.0226f
C366 ref_selector_0.I1MA SENSOR 1.68242f
C367 a_17142_8776# a_17412_8776# 0.01356f
C368 a_n17903_4529# a_n17903_4249# 0.0333f
C369 SEL_SENSOR COMPARATOR_RES 0.0271f
C370 S1 COMPARATOR_RES 0.023f
C371 EN VBG 0.02499f
C372 current_source_1mA_0.ota_med_hv_gmid_0.ota_med_hv_gmid_mirror_0.vota VBIASH 0.45526f
C373 a_18762_6672# a_19032_6672# 0.01356f
C374 a_6657_1529# a_6657_1259# 0.0226f
C375 ota_lv_gmid_comparator_0.ota_slow_gmid_ctrl_buff_0.ota_slow_gmid_ctrl_inv_0.x VDD 0.57045f
C376 ref_selector_0.ref_selector_r_96_0.vcal SEL_SENSOR 0.0214f
C377 a_15014_530# a_15414_530# 0.02572f
C378 current_source_1mA_0.ota_med_hv_gmid_0.ota_med_hv_gmid_mirror_0.Iref IOVDD 1.54429f
C379 a_n9604_4419# a_n9334_4419# 0.0226f
C380 a_8619_1799# a_8619_1529# 0.0226f
C381 a_n9604_2343# a_n9334_2343# 0.01356f
C382 a_19032_8776# a_19302_8776# 0.01356f
C383 a_6657_989# a_6657_719# 0.0226f
C384 a_n9064_4419# a_n8794_4419# 0.0226f
C385 ref_selector_0.ref_selector_r_refs_0.R2 S3 0.03333f
C386 a_1719_6094# VBIAS 0.01629f
C387 ref_selector_0.I1MA SEL_CAL 0.14422f
C388 S1 SEL_SENSOR 0.04602f
C389 a_n9064_2343# a_n8794_2343# 0.01356f
C390 S2 SEL_CAL 0.02286f
C391 S3 S0 0.04695f
C392 two_stage_instrumentation_amplifier_0.ota_slow_gmid_1.ota_slow_gmid_buffer_0.ibiasn two_stage_instrumentation_amplifier_0.ota_slow_gmid_1.ota_slow_gmid_common_0/ota_slow_gmid_pairs_0.tail 0.40234f
C393 a_19572_8776# a_19842_8776# 0.01356f
C394 two_stage_instrumentation_amplifier_0.ota_slow_gmid_0.vota VDD 3.77303f
C395 a_875_5942# VBIAS 0.11249f
C396 ref_selector_0.ref_selector_r_96_0.vcal a_10927_1554# 0.04118f
C397 non_inverting_amplifier_hv_0.ota_hv_slow_gmid_0.ota_hv_slow_gmid_tail_0.tail IOVDD 0.6089f
C398 two_stage_instrumentation_amplifier_0.ota_slow_gmid_1.ota_slow_gmid_buffer_0.ibiasn two_stage_instrumentation_amplifier_0.ota_slow_gmid_1.VN 0.91903f
C399 ref_selector_0.ref_selector_r_96_0.vcal SENSOR 0.66612f
C400 ota_lv_gmid_comparator_0.ota_slow_gmid_common_0/ota_slow_gmid_pairs_0.tail VBIAS 0.24683f
C401 a_n10144_1291# a_n9874_1291# 0.01356f
C402 ref_selector_0.ref_selector_r_96_0.vcal a_11467_2862# 0.02403f
C403 a_17952_8250# a_18222_8250# 0.01356f
C404 a_n4253_4907# VDD 0.10197f
C405 ota_lv_gmid_comparator_0.ota_slow_gmid_common_0/ota_slow_gmid_tail_0.ibiasn two_stage_instrumentation_amplifier_0.VP 0.17177f
C406 a_9273_3434# a_9273_3164# 0.0226f
C407 ota_lv_gmid_comparator_0.ota_slow_gmid_mirror_0.vout1 ota_lv_gmid_comparator_0.ota_slow_gmid_common_0/ota_slow_gmid_tail_0.ibiasn 0.42214f
C408 SEL_CAL COMPARATOR_RES 0.02408f
C409 SENSOR SEL_SENSOR 0.24445f
C410 ref_selector_0.VMIN ref_selector_0.ref_selector_r_refs_0.R3 0.2159f
C411 two_stage_instrumentation_amplifier_0.ota_slow_gmid_1.ota_slow_gmid_common_0/ota_slow_gmid_pairs_0.tail VBIAS 0.24683f
C412 two_stage_instrumentation_amplifier_0.ota_slow_gmid_0.vota two_stage_instrumentation_amplifier_0.ota_slow_gmid_0.ota_slow_gmid_common_0/ota_slow_gmid_pairs_0.tail 0.08059f
C413 a_n9064_1291# a_n8794_1291# 0.01356f
C414 a_7311_3164# a_7311_2879# 0.02072f
C415 current_source_1mA_0.ota_med_hv_gmid_0.ota_med_hv_gmid_mirror_0.Iref VBG 0.02828f
C416 a_11197_2208# a_11467_2208# 0.0202f
C417 a_8619_3164# a_8619_2879# 0.02072f
C418 VBIAS S2 0.02389f
C419 two_stage_instrumentation_amplifier_0.VP VDD 23.8409f
C420 ref_selector_0.ref_selector_r_96_0.vcal SEL_CAL 0.48242f
C421 two_stage_instrumentation_amplifier_0.ota_slow_gmid_1.VN VBIAS 0.05512f
C422 ota_lv_gmid_comparator_0.ota_slow_gmid_mirror_0.vout1 VDD 5.06138f
C423 ref_selector_0.ref_selector_r_refs_0.R2 a_7965_2879# 0.0249f
C424 two_stage_instrumentation_amplifier_0.ota_slow_gmid_1.vout1 a_n14102_4249# 0.05411f
C425 ref_selector_0.I1MA IOVDD 3.27296f
C426 a_11737_1554# a_12007_1554# 0.0202f
C427 a_4322_6094# VDD 0.12401f
C428 a_10387_2862# a_10657_2862# 0.0202f
C429 SEL_CAL SEL_SENSOR 30.2392f
C430 S1 SEL_CAL 0.26306f
C431 a_n7265_4534# a_n7265_4254# 0.0333f
C432 ota_lv_gmid_comparator_0.ota_slow_gmid_mirror_0.vout1 ota_lv_gmid_comparator_0.ota_slow_gmid_ctrl_buff_1.y 0.8386f
C433 current_source_1mA_0.current_source_1mA_2_stage_0.vcp current_source_1mA_0.ota_med_hv_gmid_0.ota_med_hv_gmid_mirror_0.Iref 0.1969f
C434 a_11197_900# a_11467_900# 0.0202f
C435 a_n9874_3111# a_n9604_3111# 0.0226f
C436 a_6657_2609# a_6657_2339# 0.0226f
C437 two_stage_instrumentation_amplifier_0.ota_slow_gmid_1.vout1 VDD 1.78015f
C438 a_n9874_3765# a_n9604_3765# 0.0226f
C439 two_stage_instrumentation_amplifier_0.ota_slow_gmid_0.ota_slow_gmid_common_0/ota_slow_gmid_pairs_0.tail two_stage_instrumentation_amplifier_0.VP 0.2743f
C440 a_12277_2862# a_12547_2862# 0.0202f
C441 VBIAS COMPARATOR_RES 14.83f
C442 a_n9334_3111# a_n9064_3111# 0.0226f
C443 a_19574_7702# a_19842_7724# 0.01372f
C444 a_18492_7724# a_18762_7724# 0.01356f
C445 a_10657_246# a_10927_246# 0.0202f
C446 a_17412_7198# a_17682_7198# 0.01356f
C447 a_1999_6094# two_stage_instrumentation_amplifier_0.VP 0.01406f
C448 top_conditionning_level_shifter_0.top_conditionning_inverter_0.X EN 0.1974f
C449 two_stage_instrumentation_amplifier_0.ota_slow_gmid_0.vota a_n7265_4534# 0.04807f
C450 current_source_1mA_0.current_source_1mA_2_stage_0.current_source_pass_element_0.iref IOVDD 11.4363f
C451 a_4042_6094# two_stage_instrumentation_amplifier_0.VP 0.01432f
C452 a_19574_7702# rmod 0.01572f
C453 ref_selector_0.VMIN a_11197_1554# 0.01577f
C454 two_stage_instrumentation_amplifier_0.ota_slow_gmid_1.ota_slow_gmid_mirror_0.vref VDD 1.78017f
C455 ota_lv_gmid_comparator_0.ota_slow_gmid_mirror_0.vout1 a_4042_6094# 0.01546f
C456 two_stage_instrumentation_amplifier_0.ota_slow_gmid_1.VN a_n9604_1817# 0.01287f
C457 ref_selector_0.I1MA VBG 0.06372f
C458 a_4042_6094# a_4322_6094# 0.03996f
C459 a_9273_2339# a_9273_2069# 0.0226f
C460 VBIAS SEL_SENSOR 0.02712f
C461 VBIAS S1 0.02387f
C462 a_15014_1822# a_15414_1822# 0.02572f
C463 ota_lv_gmid_comparator_0.ota_slow_gmid_ctrl_buff_0.x VDD 2.94508f
C464 a_n11370_4912# a_n11090_4912# 0.03996f
C465 IOVDD SEL_SENSOR 0.07827f
C466 ref_selector_0.VMIN S3 0.04758f
C467 VDD EN 2.61937f
C468 a_17682_6672# a_17952_6672# 0.01356f
C469 a_14214_1176# a_14614_1176# 0.02572f
C470 ota_lv_gmid_comparator_0.ota_slow_gmid_ctrl_buff_1.y ota_lv_gmid_comparator_0.ota_slow_gmid_ctrl_buff_0.x 0.0786f
C471 two_stage_instrumentation_amplifier_0.ota_slow_gmid_0.vout1 VBIAS 0.24054f
C472 a_n12169_4534# a_n12169_4254# 0.0333f
C473 ota_lv_gmid_comparator_0.ota_slow_gmid_mirror_0.vota ota_lv_gmid_comparator_0.ota_slow_gmid_mirror_0.vref 4.5582f
C474 ref_selector_0.I1MA current_source_1mA_0.current_source_1mA_2_stage_0.vcp 0.02466f
C475 a_17952_8776# a_18222_8776# 0.01356f
C476 a_n10144_4419# a_n9874_4419# 0.0226f
C477 COMPARATOR_RES VBG 0.02782f
C478 a_n10144_2343# a_n9874_2343# 0.01356f
C479 a_14614_530# a_15014_530# 0.02572f
C480 current_source_1mA_0.ota_med_hv_gmid_0.ota_med_hv_gmid_tail_0.tail VBIASH 0.16893f
C481 current_source_1mA_0.current_source_1mA_2_stage_0.current_source_pass_element_0.iref VBG 0.0847f
C482 a_7965_1799# a_7965_1529# 0.0226f
C483 two_stage_instrumentation_amplifier_0.ota_slow_gmid_0.vout1 a_n5332_4249# 0.05411f
C484 a_n17903_4249# VDD 0.14107f
C485 IOVDD SENSOR 0.12631f
C486 non_inverting_amplifier_hv_0.top_conditionning_gain_s3_0.vn3 a_19574_7702# 0.0248f
C487 a_n7944_4912# a_n7664_4912# 0.03996f
C488 a_n10144_1817# a_n9874_1817# 0.01356f
C489 ref_selector_0.ref_selector_r_96_0.vcal a_11737_2208# 0.03896f
C490 SEL_SENSOR VBG 10.8495f
C491 current_source_1mA_0.current_source_1mA_2_stage_0.current_source_pass_element_0.iref current_source_1mA_0.current_source_1mA_2_stage_0.vcp 0.67246f
C492 ref_selector_0.VMIN ota_lv_gmid_comparator_0.ota_slow_gmid_mirror_0.vota 0.4051f
C493 VBIAS SEL_CAL 0.02406f
C494 a_n17104_4907# VBIAS 0.01619f
C495 a_7311_1259# a_7311_989# 0.0226f
C496 two_stage_instrumentation_amplifier_0.ota_slow_gmid_0.vota a_n4533_4907# 0.01386f
C497 ref_selector_0.ref_selector_r_96_0.vcal a_10927_2862# 0.01327f
C498 ref_selector_0.VMIN ref_selector_0.ref_selector_r_refs_0.R2 0.27937f
C499 ref_selector_0.VMIN S0 5.68042f
C500 ref_selector_0.ref_selector_r_96_0.vcal a_11737_900# 0.05971f
C501 ota_lv_gmid_comparator_0.ota_slow_gmid_ctrl_buff_1.ota_slow_gmid_ctrl_inv_0.x VDD 0.57146f
C502 a_8619_3434# a_8619_3164# 0.0226f
C503 two_stage_instrumentation_amplifier_0.ota_slow_gmid_1.ota_slow_gmid_buffer_0.ibiasn VBIAS 0.09185f
C504 a_n4533_4907# a_n4253_4907# 0.03996f
C505 current_source_1mA_0.current_source_1mA_2_stage_0.current_source_pass_element_0.vota VBIASH 0.14097f
C506 a_18762_8250# a_19032_8250# 0.01356f
C507 ota_lv_gmid_comparator_0.ota_slow_gmid_ctrl_buff_1.y ota_lv_gmid_comparator_0.ota_slow_gmid_ctrl_buff_1.ota_slow_gmid_ctrl_inv_0.x 0.06653f
C508 two_stage_instrumentation_amplifier_0.ota_slow_gmid_0.ota_slow_gmid_buffer_0.ibiasn two_stage_instrumentation_amplifier_0.ota_slow_gmid_0.vout1 1.32313f
C509 two_stage_instrumentation_amplifier_0.ota_slow_gmid_0.vout1 two_stage_instrumentation_amplifier_0.ota_slow_gmid_0.ota_slow_gmid_mirror_0.vref 3.42932f
C510 a_10927_2208# a_11197_2208# 0.0202f
C511 two_stage_instrumentation_amplifier_0.ota_slow_gmid_1.vout1 a_n14501_4907# 0.01187f
C512 ref_selector_0.VMIN a_7965_1259# 0.01584f
C513 ota_lv_gmid_comparator_0.ota_slow_gmid_common_0/ota_slow_gmid_tail_0.ibiasn ota_lv_gmid_comparator_0.ota_slow_gmid_common_0/ota_slow_gmid_pairs_0.tail 0.40234f
C514 a_1719_6094# VDD 0.1236f
C515 two_stage_instrumentation_amplifier_0.ota_slow_gmid_1.ota_slow_gmid_buffer_0.ibiasn a_n14781_4907# 0.01621f
C516 a_11467_1554# a_11737_1554# 0.0202f
C517 current_source_1mA_0.ota_med_hv_gmid_0.ota_med_hv_gmid_tail_0.tail current_source_1mA_0.ota_med_hv_gmid_0.ota_med_hv_gmid_mirror_0.vota 0.37808f
C518 a_17412_7702# a_17682_7724# 0.01356f
C519 a_875_5942# VDD 1.59248f
C520 a_n1531_4529# a_n1531_4249# 0.0333f
C521 a_10927_900# a_11197_900# 0.0202f
C522 current_source_1mA_0.current_source_1mA_2_stage_0.vcp SENSOR 0.03f
C523 a_n9064_3765# a_n8794_3765# 0.0226f
C524 a_12007_2862# a_12277_2862# 0.0202f
C525 ota_lv_gmid_comparator_0.ota_slow_gmid_common_0/ota_slow_gmid_pairs_0.tail VDD 0.57351f
C526 a_10387_246# a_10657_246# 0.0202f
C527 two_stage_instrumentation_amplifier_0.ota_slow_gmid_1.ota_slow_gmid_common_0/ota_slow_gmid_pairs_0.tail VDD 0.56886f
C528 two_stage_instrumentation_amplifier_0.ota_slow_gmid_0.vota a_n2210_4907# 0.01478f
C529 a_1719_6094# a_1999_6094# 0.03996f
C530 two_stage_instrumentation_amplifier_0.VP S3 0.03127f
C531 current_source_1mA_0.current_source_1mA_2_stage_0.vcp a_14214_1822# 0.01015f
C532 a_17682_7198# a_17952_7198# 0.01356f
C533 a_6657_2339# a_6657_2069# 0.0226f
C534 a_19302_7724# a_19574_7702# 0.0134f
C535 ref_selector_0.VMIN a_12007_2208# 0.03356f
C536 a_12277_246# a_12547_246# 0.0202f
C537 two_stage_instrumentation_amplifier_0.ota_slow_gmid_0.vota ota_lv_gmid_comparator_0.ota_slow_gmid_mirror_0.vota 0.02465f
C538 two_stage_instrumentation_amplifier_0.ota_slow_gmid_1.VN a_n9874_1817# 0.01294f
C539 VDD S2 0.57557f
C540 current_source_1mA_0.current_source_1mA_2_stage_0.current_source_pass_element_0.vota current_source_1mA_0.ota_med_hv_gmid_0.ota_med_hv_gmid_mirror_0.vota 24.8128f
C541 two_stage_instrumentation_amplifier_0.ota_slow_gmid_1.VN VDD 4.25058f
C542 a_13814_1822# a_14214_1822# 0.02572f
C543 ref_selector_0.VMIN ota_lv_gmid_comparator_0.ota_slow_gmid_mirror_0.vref 0.66374f
C544 ref_selector_0.VMIN a_12007_900# 0.04403f
C545 a_6657_2069# a_6657_1799# 0.0226f
C546 two_stage_instrumentation_amplifier_0.ota_slow_gmid_0.vout1 a_n5332_4529# 0.0197f
C547 VBIAS VBG 0.02774f
C548 two_stage_instrumentation_amplifier_0.ota_slow_gmid_0.vota two_stage_instrumentation_amplifier_0.top_conditionning_gain_s2_0.vn2 0.37546f
C549 a_920_5716# a_920_5436# 0.0333f
C550 ref_selector_0.ref_selector_r_refs_0.R1 S1 0.06886f
C551 a_15014_1176# a_15414_1176# 0.02572f
C552 two_stage_instrumentation_amplifier_0.ota_slow_gmid_0.ota_slow_gmid_buffer_0.ibiasn VBIAS 0.09185f
C553 two_stage_instrumentation_amplifier_0.ota_slow_gmid_0.ota_slow_gmid_mirror_0.vref VBIAS 0.43634f
C554 VDD COMPARATOR_RES 8.66687f
C555 IOVDD VBG 2.46138f
C556 a_18492_6672# a_18762_6672# 0.01356f
C557 a_17142_7724# a_17412_7702# 0.01356f
C558 non_inverting_amplifier_hv_0.top_conditionning_gain_s3_0.vn3 VBIASH 0.02877f
C559 ota_lv_gmid_comparator_0.ota_slow_gmid_mirror_0.vout1 ota_lv_gmid_comparator_0.ota_slow_gmid_mirror_0.vota 4.01324f
C560 a_18762_8776# a_19032_8776# 0.01356f
C561 EN VBIASH 3.03473f
C562 a_19572_6672# a_19842_6672# 0.01356f
C563 two_stage_instrumentation_amplifier_0.VP S0 0.03181f
C564 current_source_1mA_0.current_source_1mA_2_stage_0.vcp IOVDD 1.41215f
C565 non_inverting_amplifier_hv_0.top_conditionning_gain_s3_0.vn3 VOUT 0.35634f
C566 EN S3 0.02039f
C567 two_stage_instrumentation_amplifier_0.top_conditionning_gain_s2_0.vn2 two_stage_instrumentation_amplifier_0.VP 1.55984f
C568 VDD S1 0.57411f
C569 VDD SEL_SENSOR 0.71075f
C570 ref_selector_0.ref_selector_r_96_0.vcal a_11197_2208# 0.04683f
C571 a_17412_8250# a_17682_8250# 0.01356f
C572 a_n2210_4907# a_n1930_4907# 0.03996f
C573 ref_selector_0.ref_selector_r_96_0.vcal a_11737_1554# 0.02308f
C574 a_9273_1259# a_9273_989# 0.0226f
C575 ref_selector_0.ref_selector_r_96_0.vcal a_11197_900# 0.05689f
C576 a_7965_3434# a_7965_3164# 0.0226f
C577 two_stage_instrumentation_amplifier_0.ota_slow_gmid_0.vout1 VDD 1.78015f
C578 a_6657_3164# a_6657_2879# 0.02072f
C579 two_stage_instrumentation_amplifier_0.ota_slow_gmid_0.ota_slow_gmid_buffer_0.ibiasn two_stage_instrumentation_amplifier_0.ota_slow_gmid_0.ota_slow_gmid_mirror_0.vref 0.03366f
C580 a_10657_2208# a_10927_2208# 0.0202f
C581 a_920_5716# VDD 0.04843f
C582 two_stage_instrumentation_amplifier_0.ota_slow_gmid_1.vout1 a_n14102_4529# 0.0197f
C583 ota_lv_gmid_comparator_0.ota_slow_gmid_mirror_0.vota ota_lv_gmid_comparator_0.ota_slow_gmid_ctrl_buff_0.x 0.04676f
C584 current_source_1mA_0.current_source_1mA_2_stage_0.vcp VBG 0.61383f
C585 a_11197_1554# a_11467_1554# 0.0202f
C586 two_stage_instrumentation_amplifier_0.ota_slow_gmid_0.vout1 two_stage_instrumentation_amplifier_0.ota_slow_gmid_0.ota_slow_gmid_common_0/ota_slow_gmid_pairs_0.tail 0.09805f
C587 ota_lv_gmid_comparator_0.ota_slow_gmid_mirror_0.vota EN 0.17089f
C588 a_n5332_4529# a_n5332_4249# 0.0333f
C589 a_10657_900# a_10927_900# 0.0202f
C590 EN S0 0.02364f
C591 a_n10144_3111# a_n9874_3111# 0.0226f
C592 VDD SEL_CAL 0.55342f
C593 a_9273_2879# a_9273_2609# 0.0226f
C594 a_11737_2862# a_12007_2862# 0.0202f
C595 a_n10144_3765# a_n9874_3765# 0.0226f
C596 ota_lv_gmid_comparator_0.ota_slow_gmid_mirror_0.vout1 ota_lv_gmid_comparator_0.ota_slow_gmid_mirror_0.vref 5.20163f
C597 a_n9064_3111# a_n8794_3111# 0.0226f
C598 a_17142_7198# a_17412_7198# 0.01356f
C599 two_stage_instrumentation_amplifier_0.ota_slow_gmid_1.ota_slow_gmid_buffer_0.ibiasn VDD 1.17068f
C600 non_inverting_amplifier_hv_0.ota_hv_slow_gmid_0.ota_hv_slow_gmid_tail_0.tail VBIASH 0.29367f
R0 VAMP.n38 non_inverting_amplifier_hv_0.ota_hv_slow_gmid_0.ota_hv_slow_gmid_pairs_0.vp 49.4775
R1 VAMP.n39 VAMP.n38 20.3485
R2 two_stage_instrumentation_amplifier_0.top_conditionning_gain_s2_0.vamp VAMP.t61 18.992
R3 VAMP.n6 VAMP.t31 17.2374
R4 VAMP.n6 VAMP.t58 17.0005
R5 VAMP.n7 VAMP.t19 17.0005
R6 VAMP.n17 VAMP.t22 17.0005
R7 VAMP.n17 VAMP.t43 17.0005
R8 VAMP.n16 VAMP.t1 17.0005
R9 VAMP.n16 VAMP.t46 17.0005
R10 VAMP.n15 VAMP.t37 17.0005
R11 VAMP.n15 VAMP.t5 17.0005
R12 VAMP.n14 VAMP.t8 17.0005
R13 VAMP.n14 VAMP.t36 17.0005
R14 VAMP.n13 VAMP.t56 17.0005
R15 VAMP.n13 VAMP.t18 17.0005
R16 VAMP.n12 VAMP.t44 17.0005
R17 VAMP.n12 VAMP.t40 17.0005
R18 VAMP.n11 VAMP.t4 17.0005
R19 VAMP.n11 VAMP.t21 17.0005
R20 VAMP.n10 VAMP.t35 17.0005
R21 VAMP.n10 VAMP.t7 17.0005
R22 VAMP.n9 VAMP.t16 17.0005
R23 VAMP.n9 VAMP.t33 17.0005
R24 VAMP.n8 VAMP.t54 17.0005
R25 VAMP.n8 VAMP.t14 17.0005
R26 VAMP.n18 VAMP.t26 17.0005
R27 VAMP.n21 VAMP.t34 17.0005
R28 VAMP.n21 VAMP.t42 17.0005
R29 VAMP.n20 VAMP.t15 17.0005
R30 VAMP.n20 VAMP.t41 17.0005
R31 VAMP.n19 VAMP.t52 17.0005
R32 VAMP.n19 VAMP.t3 17.0005
R33 VAMP.n22 VAMP.t50 17.0005
R34 VAMP.n23 VAMP.t38 17.0005
R35 VAMP.n24 VAMP.t9 17.0005
R36 VAMP.n25 VAMP.t51 17.0005
R37 VAMP.n25 VAMP.t39 17.0005
R38 VAMP.n26 VAMP.t24 17.0005
R39 VAMP.n26 VAMP.t20 17.0005
R40 VAMP.n27 VAMP.t28 17.0005
R41 VAMP.n27 VAMP.t48 17.0005
R42 VAMP.n28 VAMP.t47 17.0005
R43 VAMP.n28 VAMP.t57 17.0005
R44 VAMP.n29 VAMP.t60 17.0005
R45 VAMP.n29 VAMP.t30 17.0005
R46 VAMP.n30 VAMP.t12 17.0005
R47 VAMP.n30 VAMP.t27 17.0005
R48 VAMP.n31 VAMP.t2 17.0005
R49 VAMP.n31 VAMP.t32 17.0005
R50 VAMP.n32 VAMP.t25 17.0005
R51 VAMP.n32 VAMP.t17 17.0005
R52 VAMP.n5 VAMP.t11 17.0005
R53 VAMP.n5 VAMP.t55 17.0005
R54 VAMP.n4 VAMP.t45 17.0005
R55 VAMP.n4 VAMP.t29 17.0005
R56 VAMP.n3 VAMP.t59 17.0005
R57 VAMP.n2 VAMP.t6 17.0005
R58 VAMP.n2 VAMP.t49 17.0005
R59 VAMP.n1 VAMP.t23 17.0005
R60 VAMP.n1 VAMP.t13 17.0005
R61 VAMP.n0 VAMP.t10 17.0005
R62 VAMP.n0 VAMP.t53 17.0005
R63 VAMP.n39 two_stage_instrumentation_amplifier_0.VOUT 16.305
R64 VAMP.n0 VAMP.t0 15.7739
R65 VAMP.n38 VAMP.n37 11.8692
R66 VAMP.n34 VAMP.t62 9.94663
R67 non_inverting_amplifier_hv_0.ota_hv_slow_gmid_0.ota_hv_slow_gmid_pairs_0.vp VAMP.n34 6.8007
R68 VAMP.n35 VAMP.t65 6.66783
R69 VAMP.n34 VAMP.t63 6.61335
R70 two_stage_instrumentation_amplifier_0.ota_slow_gmid_0.ota_slow_gmid_buffer_0.vout VAMP.n40 5.51509
R71 VAMP.n37 ota_lv_gmid_comparator_0.VN 4.92618
R72 VAMP.n35 VAMP.t64 4.87123
R73 VAMP.n40 VAMP.n39 4.47791
R74 ota_lv_gmid_comparator_0.ota_slow_gmid_common_0/ota_slow_gmid_pairs_0.vp VAMP.n35 3.9033
R75 VAMP.n40 two_stage_instrumentation_amplifier_0.top_conditionning_gain_s2_0.vamp 3.7595
R76 two_stage_instrumentation_amplifier_0.ota_slow_gmid_0.VOUT VAMP.n33 2.79653
R77 VAMP.n22 VAMP.n21 1.64354
R78 VAMP.n36 ota_lv_gmid_comparator_0.ota_slow_gmid_common_0/ota_slow_gmid_pairs_0.vp 0.7419
R79 VAMP.n8 VAMP.n7 0.618486
R80 VAMP.n18 VAMP.n17 0.618486
R81 VAMP.n19 VAMP.n18 0.618486
R82 VAMP.n25 VAMP.n24 0.618486
R83 VAMP.n4 VAMP.n3 0.618486
R84 VAMP.n3 VAMP.n2 0.618486
R85 VAMP.n7 VAMP.n6 0.598625
R86 VAMP.n24 VAMP.n23 0.598625
R87 VAMP.n37 VAMP.n36 0.171868
R88 VAMP.n9 VAMP.n8 0.153278
R89 VAMP.n10 VAMP.n9 0.153278
R90 VAMP.n11 VAMP.n10 0.153278
R91 VAMP.n12 VAMP.n11 0.153278
R92 VAMP.n13 VAMP.n12 0.153278
R93 VAMP.n14 VAMP.n13 0.153278
R94 VAMP.n15 VAMP.n14 0.153278
R95 VAMP.n16 VAMP.n15 0.153278
R96 VAMP.n17 VAMP.n16 0.153278
R97 VAMP.n20 VAMP.n19 0.153278
R98 VAMP.n21 VAMP.n20 0.153278
R99 VAMP.n5 VAMP.n4 0.153278
R100 VAMP.n32 VAMP.n31 0.153278
R101 VAMP.n31 VAMP.n30 0.153278
R102 VAMP.n30 VAMP.n29 0.153278
R103 VAMP.n29 VAMP.n28 0.153278
R104 VAMP.n28 VAMP.n27 0.153278
R105 VAMP.n27 VAMP.n26 0.153278
R106 VAMP.n26 VAMP.n25 0.153278
R107 VAMP.n1 VAMP.n0 0.153278
R108 VAMP.n2 VAMP.n1 0.153278
R109 VAMP.n23 VAMP.n22 0.101484
R110 VAMP.n33 VAMP.n5 0.0807083
R111 VAMP.n33 VAMP.n32 0.0730694
R112 VAMP.n36 ota_lv_gmid_comparator_0.VN 0.0423
R113 two_stage_instrumentation_amplifier_0.ota_slow_gmid_0.ota_slow_gmid_buffer_0.vout two_stage_instrumentation_amplifier_0.ota_slow_gmid_0.VOUT 0.00194262
R114 non_inverting_amplifier_hv_0.ota_hv_slow_gmid_0.ota_hv_slow_gmid_tail_0.tail.n0 non_inverting_amplifier_hv_0.ota_hv_slow_gmid_0.ota_hv_slow_gmid_tail_0.tail.t3 11.6061
R115 non_inverting_amplifier_hv_0.ota_hv_slow_gmid_0.ota_hv_slow_gmid_tail_0.tail.n0 non_inverting_amplifier_hv_0.ota_hv_slow_gmid_0.ota_hv_slow_gmid_tail_0.tail.t2 10.2126
R116 non_inverting_amplifier_hv_0.ota_hv_slow_gmid_0.ota_hv_slow_gmid_tail_0.tail.n2 non_inverting_amplifier_hv_0.ota_hv_slow_gmid_0.ota_hv_slow_gmid_tail_0.tail.n1 5.49511
R117 non_inverting_amplifier_hv_0.ota_hv_slow_gmid_0.ota_hv_slow_gmid_tail_0.tail.n1 non_inverting_amplifier_hv_0.ota_hv_slow_gmid_0.ota_hv_slow_gmid_tail_0.tail.t1 5.19352
R118 non_inverting_amplifier_hv_0.ota_hv_slow_gmid_0.ota_hv_slow_gmid_tail_0.tail.n1 non_inverting_amplifier_hv_0.ota_hv_slow_gmid_0.ota_hv_slow_gmid_tail_0.tail.t0 3.25614
R119 non_inverting_amplifier_hv_0.ota_hv_slow_gmid_0.ota_hv_slow_gmid_tail_0.tail.n3 non_inverting_amplifier_hv_0.ota_hv_slow_gmid_0.ota_hv_slow_gmid_tail_0.tail.n0 0.8563
R120 non_inverting_amplifier_hv_0.ota_hv_slow_gmid_0.ota_hv_slow_gmid_tail_0.tail.n3 non_inverting_amplifier_hv_0.ota_hv_slow_gmid_0.ota_hv_slow_gmid_tail_0.tail.n2 0.224964
R121 non_inverting_amplifier_hv_0.ota_hv_slow_gmid_0.ota_hv_slow_gmid_tail_0.tail.n2 non_inverting_amplifier_hv_0.ota_hv_slow_gmid_0.ota_hv_slow_gmid_tail_0.tail 0.1303
R122 non_inverting_amplifier_hv_0.ota_hv_slow_gmid_0.ota_hv_slow_gmid_tail_0.tail non_inverting_amplifier_hv_0.ota_hv_slow_gmid_0.ota_hv_slow_gmid_tail_0.tail.n3 0.0260072
R123 non_inverting_amplifier_hv_0.ota_hv_slow_gmid_0.vota.n3 non_inverting_amplifier_hv_0.ota_hv_slow_gmid_0.vota.t2 12.3227
R124 non_inverting_amplifier_hv_0.ota_hv_slow_gmid_0.ota_hv_slow_gmid_pairs_0.vota non_inverting_amplifier_hv_0.ota_hv_slow_gmid_0.vota.n6 12.0106
R125 non_inverting_amplifier_hv_0.ota_hv_slow_gmid_0.vota.n2 non_inverting_amplifier_hv_0.ota_hv_slow_gmid_0.vota.t4 6.99939
R126 non_inverting_amplifier_hv_0.ota_hv_slow_gmid_0.vota.n0 non_inverting_amplifier_hv_0.ota_hv_slow_gmid_0.vota.t1 6.57417
R127 non_inverting_amplifier_hv_0.ota_hv_slow_gmid_0.vota.n0 non_inverting_amplifier_hv_0.ota_hv_slow_gmid_0.vota.t0 6.0645
R128 non_inverting_amplifier_hv_0.ota_hv_slow_gmid_0.vota.n4 non_inverting_amplifier_hv_0.ota_hv_slow_gmid_0.vota.n3 5.10422
R129 non_inverting_amplifier_hv_0.ota_hv_slow_gmid_0.vota.n6 non_inverting_amplifier_hv_0.ota_hv_slow_gmid_0.vota.t5 5.06253
R130 non_inverting_amplifier_hv_0.ota_hv_slow_gmid_0.vota.n1 non_inverting_amplifier_hv_0.ota_hv_slow_gmid_0.vota.n0 4.97067
R131 non_inverting_amplifier_hv_0.ota_hv_slow_gmid_0.vota.n6 non_inverting_amplifier_hv_0.ota_hv_slow_gmid_0.ota_hv_slow_gmid_mirror_0.vota 4.42744
R132 non_inverting_amplifier_hv_0.ota_hv_slow_gmid_0.vota.n3 non_inverting_amplifier_hv_0.ota_hv_slow_gmid_0.vota.n2 3.06546
R133 non_inverting_amplifier_hv_0.ota_hv_slow_gmid_0.vota.n5 non_inverting_amplifier_hv_0.ota_hv_slow_gmid_0.vota.n4 1.98112
R134 non_inverting_amplifier_hv_0.ota_hv_slow_gmid_0.vota.n2 non_inverting_amplifier_hv_0.ota_hv_slow_gmid_0.vota.t3 1.66622
R135 non_inverting_amplifier_hv_0.ota_hv_slow_gmid_0.vota.n1 non_inverting_amplifier_hv_0.ota_hv_slow_gmid_0.ota_hv_slow_gmid_pairs_0.vota 0.251929
R136 non_inverting_amplifier_hv_0.ota_hv_slow_gmid_0.vota.n5 non_inverting_amplifier_hv_0.ota_hv_slow_gmid_0.ota_hv_slow_gmid_mirror_0.vota 0.0973
R137 non_inverting_amplifier_hv_0.ota_hv_slow_gmid_0.vota.n4 non_inverting_amplifier_hv_0.ota_hv_slow_gmid_0.vota.t6 0.0547552
R138 non_inverting_amplifier_hv_0.ota_hv_slow_gmid_0.ota_hv_slow_gmid_mirror_0.vota non_inverting_amplifier_hv_0.ota_hv_slow_gmid_0.vota.n5 0.0364184
R139 non_inverting_amplifier_hv_0.ota_hv_slow_gmid_0.ota_hv_slow_gmid_pairs_0.vota non_inverting_amplifier_hv_0.ota_hv_slow_gmid_0.vota.n1 0.0350098
R140 IOVDD.n37 IOVDD.t195 18.2777
R141 IOVDD.n173 IOVDD.t210 18.2777
R142 IOVDD.n169 IOVDD.t214 18.266
R143 IOVDD.n71 IOVDD.t212 18.266
R144 IOVDD.n2 IOVDD.t216 17.9767
R145 IOVDD.n40 IOVDD.t202 17.2377
R146 IOVDD.n39 IOVDD.t198 17.2377
R147 IOVDD.n38 IOVDD.t194 17.2377
R148 IOVDD.n37 IOVDD.t199 17.2377
R149 IOVDD.n173 IOVDD.t205 17.2377
R150 IOVDD.n174 IOVDD.t203 17.2377
R151 IOVDD.n175 IOVDD.t207 17.2377
R152 IOVDD.n176 IOVDD.t204 17.2377
R153 IOVDD.t51 IOVDD.n556 17.1081
R154 IOVDD.t1 IOVDD.n3 17.0024
R155 IOVDD.t72 IOVDD.n447 17.0005
R156 IOVDD.t72 IOVDD.n378 17.0005
R157 IOVDD.t72 IOVDD.n376 17.0005
R158 IOVDD.t72 IOVDD.n374 17.0005
R159 IOVDD.t72 IOVDD.n372 17.0005
R160 IOVDD.t72 IOVDD.n370 17.0005
R161 IOVDD.n448 IOVDD.t72 17.0005
R162 IOVDD.t72 IOVDD.n444 17.0005
R163 IOVDD.t134 IOVDD.n439 17.0005
R164 IOVDD.t134 IOVDD.n388 17.0005
R165 IOVDD.t134 IOVDD.n386 17.0005
R166 IOVDD.t134 IOVDD.n384 17.0005
R167 IOVDD.t134 IOVDD.n382 17.0005
R168 IOVDD.t134 IOVDD.n380 17.0005
R169 IOVDD.n440 IOVDD.t134 17.0005
R170 IOVDD.t134 IOVDD.n436 17.0005
R171 IOVDD.n467 IOVDD.t156 17.0005
R172 IOVDD.n465 IOVDD.t156 17.0005
R173 IOVDD.n468 IOVDD.t156 17.0005
R174 IOVDD.n467 IOVDD.t193 17.0005
R175 IOVDD.n465 IOVDD.t193 17.0005
R176 IOVDD.n468 IOVDD.t193 17.0005
R177 IOVDD.n474 IOVDD.t66 17.0005
R178 IOVDD.n472 IOVDD.t66 17.0005
R179 IOVDD.n475 IOVDD.t66 17.0005
R180 IOVDD.t163 IOVDD.n474 17.0005
R181 IOVDD.t163 IOVDD.n472 17.0005
R182 IOVDD.n475 IOVDD.t163 17.0005
R183 IOVDD.n430 IOVDD.t91 17.0005
R184 IOVDD.n426 IOVDD.t91 17.0005
R185 IOVDD.n424 IOVDD.t91 17.0005
R186 IOVDD.n391 IOVDD.t91 17.0005
R187 IOVDD.n433 IOVDD.t91 17.0005
R188 IOVDD.n390 IOVDD.t91 17.0005
R189 IOVDD.n434 IOVDD.t91 17.0005
R190 IOVDD.n422 IOVDD.t91 17.0005
R191 IOVDD.t90 IOVDD.n430 17.0005
R192 IOVDD.t90 IOVDD.n426 17.0005
R193 IOVDD.t90 IOVDD.n422 17.0005
R194 IOVDD.n430 IOVDD.n429 17.0005
R195 IOVDD.n429 IOVDD.n426 17.0005
R196 IOVDD.n429 IOVDD.n422 17.0005
R197 IOVDD.n414 IOVDD.t126 17.0005
R198 IOVDD.n410 IOVDD.t126 17.0005
R199 IOVDD.n408 IOVDD.t126 17.0005
R200 IOVDD.n395 IOVDD.t126 17.0005
R201 IOVDD.n417 IOVDD.t126 17.0005
R202 IOVDD.n394 IOVDD.t126 17.0005
R203 IOVDD.n418 IOVDD.t126 17.0005
R204 IOVDD.n406 IOVDD.t126 17.0005
R205 IOVDD.t114 IOVDD.n414 17.0005
R206 IOVDD.t114 IOVDD.n410 17.0005
R207 IOVDD.t114 IOVDD.n406 17.0005
R208 IOVDD.n414 IOVDD.n413 17.0005
R209 IOVDD.n413 IOVDD.n410 17.0005
R210 IOVDD.n413 IOVDD.n406 17.0005
R211 IOVDD.t154 IOVDD.n296 17.0005
R212 IOVDD.t26 IOVDD.n296 17.0005
R213 IOVDD.n354 IOVDD.n296 17.0005
R214 IOVDD.t11 IOVDD.n296 17.0005
R215 IOVDD.t87 IOVDD.n296 17.0005
R216 IOVDD.n310 IOVDD.n296 17.0005
R217 IOVDD.n314 IOVDD.n296 17.0005
R218 IOVDD.n317 IOVDD.n296 17.0005
R219 IOVDD.n316 IOVDD.n296 17.0005
R220 IOVDD.n323 IOVDD.n296 17.0005
R221 IOVDD.n495 IOVDD.n315 17.0005
R222 IOVDD.n495 IOVDD.n313 17.0005
R223 IOVDD.n495 IOVDD.n318 17.0005
R224 IOVDD.n495 IOVDD.n312 17.0005
R225 IOVDD.n495 IOVDD.n327 17.0005
R226 IOVDD.n495 IOVDD.n328 17.0005
R227 IOVDD.n495 IOVDD.n343 17.0005
R228 IOVDD.n495 IOVDD.n344 17.0005
R229 IOVDD.n495 IOVDD.n345 17.0005
R230 IOVDD.n462 IOVDD.n311 17.0005
R231 IOVDD.n473 IOVDD.n311 17.0005
R232 IOVDD.n471 IOVDD.n311 17.0005
R233 IOVDD.n469 IOVDD.n311 17.0005
R234 IOVDD.n463 IOVDD.n311 17.0005
R235 IOVDD.n466 IOVDD.n311 17.0005
R236 IOVDD.n411 IOVDD.n311 17.0005
R237 IOVDD.n412 IOVDD.n311 17.0005
R238 IOVDD.n409 IOVDD.n311 17.0005
R239 IOVDD.n407 IOVDD.n311 17.0005
R240 IOVDD.n415 IOVDD.n311 17.0005
R241 IOVDD.n416 IOVDD.n311 17.0005
R242 IOVDD.n393 IOVDD.n311 17.0005
R243 IOVDD.n427 IOVDD.n311 17.0005
R244 IOVDD.n428 IOVDD.n311 17.0005
R245 IOVDD.n425 IOVDD.n311 17.0005
R246 IOVDD.n423 IOVDD.n311 17.0005
R247 IOVDD.n431 IOVDD.n311 17.0005
R248 IOVDD.n432 IOVDD.n311 17.0005
R249 IOVDD.n389 IOVDD.n311 17.0005
R250 IOVDD.n438 IOVDD.n311 17.0005
R251 IOVDD.n437 IOVDD.n311 17.0005
R252 IOVDD.n387 IOVDD.n311 17.0005
R253 IOVDD.n385 IOVDD.n311 17.0005
R254 IOVDD.n383 IOVDD.n311 17.0005
R255 IOVDD.n381 IOVDD.n311 17.0005
R256 IOVDD.n379 IOVDD.n311 17.0005
R257 IOVDD.n446 IOVDD.n311 17.0005
R258 IOVDD.n445 IOVDD.n311 17.0005
R259 IOVDD.n377 IOVDD.n311 17.0005
R260 IOVDD.n375 IOVDD.n311 17.0005
R261 IOVDD.n373 IOVDD.n311 17.0005
R262 IOVDD.n371 IOVDD.n311 17.0005
R263 IOVDD.n369 IOVDD.n311 17.0005
R264 IOVDD.n495 IOVDD.t154 17.0005
R265 IOVDD.n495 IOVDD.t26 17.0005
R266 IOVDD.n495 IOVDD.n354 17.0005
R267 IOVDD.n495 IOVDD.t11 17.0005
R268 IOVDD.n495 IOVDD.t87 17.0005
R269 IOVDD.n559 IOVDD.n516 17.0005
R270 IOVDD.n559 IOVDD.n503 17.0005
R271 IOVDD.n559 IOVDD.n307 17.0005
R272 IOVDD.n559 IOVDD.n306 17.0005
R273 IOVDD.n559 IOVDD.n305 17.0005
R274 IOVDD.n548 IOVDD.t35 17.0005
R275 IOVDD.n551 IOVDD.t35 17.0005
R276 IOVDD.n546 IOVDD.t35 17.0005
R277 IOVDD.t108 IOVDD.n548 17.0005
R278 IOVDD.t108 IOVDD.n551 17.0005
R279 IOVDD.t108 IOVDD.n546 17.0005
R280 IOVDD.n547 IOVDD.n282 17.0005
R281 IOVDD.n550 IOVDD.n282 17.0005
R282 IOVDD.n549 IOVDD.n282 17.0005
R283 IOVDD.n543 IOVDD.t54 17.0005
R284 IOVDD.t54 IOVDD.n540 17.0005
R285 IOVDD.n537 IOVDD.t46 17.0005
R286 IOVDD.t46 IOVDD.n533 17.0005
R287 IOVDD.n552 IOVDD.t35 17.0005
R288 IOVDD.n552 IOVDD.t108 17.0005
R289 IOVDD.n555 IOVDD.t63 17.0005
R290 IOVDD.n559 IOVDD.n302 17.0005
R291 IOVDD.n570 IOVDD.n282 17.0005
R292 IOVDD.n269 IOVDD.n67 17.0005
R293 IOVDD.n182 IOVDD.n81 17.0005
R294 IOVDD.n234 IOVDD.t129 17.0005
R295 IOVDD.n238 IOVDD.t141 17.0005
R296 IOVDD.t141 IOVDD.n78 17.0005
R297 IOVDD.t141 IOVDD.n237 17.0005
R298 IOVDD.t172 IOVDD.n228 17.0005
R299 IOVDD.n229 IOVDD.t172 17.0005
R300 IOVDD.t172 IOVDD.n226 17.0005
R301 IOVDD.n212 IOVDD.n81 17.0005
R302 IOVDD.n94 IOVDD.n81 17.0005
R303 IOVDD.n111 IOVDD.n81 17.0005
R304 IOVDD.n106 IOVDD.n81 17.0005
R305 IOVDD.n108 IOVDD.n81 17.0005
R306 IOVDD.n103 IOVDD.n81 17.0005
R307 IOVDD.n89 IOVDD.n81 17.0005
R308 IOVDD.n85 IOVDD.n81 17.0005
R309 IOVDD.n269 IOVDD.n24 17.0005
R310 IOVDD.n269 IOVDD.n23 17.0005
R311 IOVDD.n269 IOVDD.n22 17.0005
R312 IOVDD.n166 IOVDD.n81 17.0005
R313 IOVDD.n196 IOVDD.n81 17.0005
R314 IOVDD.n210 IOVDD.n93 17.0005
R315 IOVDD.n210 IOVDD.n88 17.0005
R316 IOVDD.n81 IOVDD.n24 17.0005
R317 IOVDD.n269 IOVDD.n56 17.0005
R318 IOVDD.n210 IOVDD.n111 17.0005
R319 IOVDD.n269 IOVDD.n43 17.0005
R320 IOVDD.n270 IOVDD.n269 17.0005
R321 IOVDD.n269 IOVDD.n268 17.0005
R322 IOVDD.n269 IOVDD.n75 17.0005
R323 IOVDD.n269 IOVDD.n74 17.0005
R324 IOVDD.n213 IOVDD.t222 15.8723
R325 IOVDD.n217 IOVDD.t225 15.4283
R326 IOVDD.t73 IOVDD.n334 15.0005
R327 IOVDD.n335 IOVDD.t73 15.0005
R328 IOVDD.t73 IOVDD.n332 15.0005
R329 IOVDD.t56 IOVDD.n399 15.0005
R330 IOVDD.n400 IOVDD.t56 15.0005
R331 IOVDD.t56 IOVDD.n398 15.0005
R332 IOVDD.n514 IOVDD.t120 15.0005
R333 IOVDD.t120 IOVDD.n505 15.0005
R334 IOVDD.t120 IOVDD.n513 15.0005
R335 IOVDD.t61 IOVDD.n553 15.0005
R336 IOVDD.t61 IOVDD.n538 15.0005
R337 IOVDD.n554 IOVDD.t61 15.0005
R338 IOVDD.n66 IOVDD.n65 10.2855
R339 IOVDD.n194 IOVDD.n164 10.2855
R340 IOVDD.n65 IOVDD.n4 9.1305
R341 IOVDD.n195 IOVDD.n194 9.1305
R342 IOVDD.n67 IOVDD.n66 9.09567
R343 IOVDD.n166 IOVDD.n164 9.09567
R344 IOVDD.t1 IOVDD.n1 8.50176
R345 IOVDD.n510 IOVDD.n509 8.50175
R346 IOVDD.n424 IOVDD.n392 8.501
R347 IOVDD.n408 IOVDD.n396 8.501
R348 IOVDD.n478 IOVDD.n461 8.501
R349 IOVDD.n478 IOVDD.n460 8.501
R350 IOVDD.n478 IOVDD.n459 8.501
R351 IOVDD.n479 IOVDD.n478 8.501
R352 IOVDD.n478 IOVDD.n362 8.501
R353 IOVDD.n478 IOVDD.n363 8.501
R354 IOVDD.n512 IOVDD.n510 8.501
R355 IOVDD.n293 IOVDD.n292 8.501
R356 IOVDD.n300 IOVDD.n292 8.501
R357 IOVDD.n298 IOVDD.n292 8.501
R358 IOVDD.n303 IOVDD.n292 8.501
R359 IOVDD.n565 IOVDD.n564 8.501
R360 IOVDD.n563 IOVDD.n562 8.501
R361 IOVDD.n294 IOVDD.n289 8.501
R362 IOVDD.n562 IOVDD.n290 8.501
R363 IOVDD.n287 IOVDD.n284 8.501
R364 IOVDD.n566 IOVDD.n285 8.501
R365 IOVDD.n209 IOVDD.n208 8.501
R366 IOVDD.n128 IOVDD.n25 8.501
R367 IOVDD.n97 IOVDD.n55 8.501
R368 IOVDD.n100 IOVDD.n97 8.501
R369 IOVDD.n210 IOVDD.n84 8.50082
R370 IOVDD.n211 IOVDD.n210 8.50061
R371 IOVDD.n210 IOVDD.n91 8.50061
R372 IOVDD.n210 IOVDD.n95 8.50061
R373 IOVDD.n210 IOVDD.n92 8.50061
R374 IOVDD.n374 IOVDD.t71 8.5005
R375 IOVDD.n372 IOVDD.t71 8.5005
R376 IOVDD.n370 IOVDD.t71 8.5005
R377 IOVDD.n448 IOVDD.t71 8.5005
R378 IOVDD.n447 IOVDD.t71 8.5005
R379 IOVDD.n378 IOVDD.t71 8.5005
R380 IOVDD.n376 IOVDD.t71 8.5005
R381 IOVDD.n444 IOVDD.t71 8.5005
R382 IOVDD.n384 IOVDD.t133 8.5005
R383 IOVDD.n382 IOVDD.t133 8.5005
R384 IOVDD.n380 IOVDD.t133 8.5005
R385 IOVDD.n440 IOVDD.t133 8.5005
R386 IOVDD.n439 IOVDD.t133 8.5005
R387 IOVDD.n388 IOVDD.t133 8.5005
R388 IOVDD.n386 IOVDD.t133 8.5005
R389 IOVDD.n436 IOVDD.t133 8.5005
R390 IOVDD.n465 IOVDD.t136 8.5005
R391 IOVDD.n467 IOVDD.t136 8.5005
R392 IOVDD.n468 IOVDD.t136 8.5005
R393 IOVDD.t167 IOVDD.n467 8.5005
R394 IOVDD.t167 IOVDD.n465 8.5005
R395 IOVDD.n468 IOVDD.t167 8.5005
R396 IOVDD.n472 IOVDD.t143 8.5005
R397 IOVDD.n474 IOVDD.t143 8.5005
R398 IOVDD.n475 IOVDD.t143 8.5005
R399 IOVDD.n472 IOVDD.t65 8.5005
R400 IOVDD.n474 IOVDD.t65 8.5005
R401 IOVDD.n475 IOVDD.t65 8.5005
R402 IOVDD.t90 IOVDD.n391 8.5005
R403 IOVDD.t90 IOVDD.n433 8.5005
R404 IOVDD.t90 IOVDD.n390 8.5005
R405 IOVDD.n434 IOVDD.t90 8.5005
R406 IOVDD.t114 IOVDD.n395 8.5005
R407 IOVDD.t114 IOVDD.n417 8.5005
R408 IOVDD.t114 IOVDD.n394 8.5005
R409 IOVDD.n418 IOVDD.t114 8.5005
R410 IOVDD.t4 IOVDD.n296 8.5005
R411 IOVDD.t0 IOVDD.n296 8.5005
R412 IOVDD.n481 IOVDD.n452 8.5005
R413 IOVDD.n481 IOVDD.n454 8.5005
R414 IOVDD.n481 IOVDD.n456 8.5005
R415 IOVDD.n481 IOVDD.n458 8.5005
R416 IOVDD.n481 IOVDD.n480 8.5005
R417 IOVDD.n482 IOVDD.n481 8.5005
R418 IOVDD.n364 IOVDD.n311 8.5005
R419 IOVDD.n333 IOVDD.n311 8.5005
R420 IOVDD.n327 IOVDD.n311 8.5005
R421 IOVDD.n328 IOVDD.n311 8.5005
R422 IOVDD.n331 IOVDD.n311 8.5005
R423 IOVDD.n330 IOVDD.n311 8.5005
R424 IOVDD.n338 IOVDD.n311 8.5005
R425 IOVDD.n340 IOVDD.n311 8.5005
R426 IOVDD.n343 IOVDD.n311 8.5005
R427 IOVDD.n344 IOVDD.n311 8.5005
R428 IOVDD.n345 IOVDD.n311 8.5005
R429 IOVDD.n397 IOVDD.n311 8.5005
R430 IOVDD.n401 IOVDD.n311 8.5005
R431 IOVDD.t33 IOVDD.n507 8.5005
R432 IOVDD.t33 IOVDD.n508 8.5005
R433 IOVDD.t31 IOVDD.n301 8.5005
R434 IOVDD.t31 IOVDD.n299 8.5005
R435 IOVDD.t31 IOVDD.n297 8.5005
R436 IOVDD.n570 IOVDD.n281 8.5005
R437 IOVDD.n570 IOVDD.n280 8.5005
R438 IOVDD.n232 IOVDD.t128 8.5005
R439 IOVDD.t140 IOVDD.n78 8.5005
R440 IOVDD.n193 IOVDD.n81 8.5005
R441 IOVDD.n177 IOVDD.n81 8.5005
R442 IOVDD.n99 IOVDD.n56 8.5005
R443 IOVDD.n101 IOVDD.n56 8.5005
R444 IOVDD.n210 IOVDD.n56 8.5005
R445 IOVDD.n269 IOVDD.n52 8.5005
R446 IOVDD.n269 IOVDD.n60 8.5005
R447 IOVDD.n269 IOVDD.n58 8.5005
R448 IOVDD.n495 IOVDD.n326 8.49948
R449 IOVDD.n495 IOVDD.n329 8.49948
R450 IOVDD.n495 IOVDD.n339 8.49948
R451 IOVDD.n495 IOVDD.n346 8.49948
R452 IOVDD.n419 IOVDD.n311 8.49902
R453 IOVDD.n421 IOVDD.n311 8.49902
R454 IOVDD.n441 IOVDD.n311 8.49902
R455 IOVDD.n443 IOVDD.n311 8.49902
R456 IOVDD.n559 IOVDD.n558 8.49829
R457 IOVDD.t129 IOVDD.n233 8.49701
R458 IOVDD.n356 IOVDD.n296 8.49347
R459 IOVDD.n541 IOVDD.t78 8.49044
R460 IOVDD.t78 IOVDD.n539 8.49044
R461 IOVDD.t54 IOVDD.n542 8.49044
R462 IOVDD.n535 IOVDD.t179 8.49044
R463 IOVDD.t179 IOVDD.n534 8.49044
R464 IOVDD.t46 IOVDD.n536 8.49044
R465 IOVDD.n196 IOVDD.n195 8.05955
R466 IOVDD.n271 IOVDD.n4 8.058
R467 IOVDD.n220 IOVDD.t5 7.76227
R468 IOVDD.n221 IOVDD.t10 7.76227
R469 IOVDD.t92 IOVDD.n107 7.50125
R470 IOVDD.t67 IOVDD.n52 7.5005
R471 IOVDD.t67 IOVDD.n254 7.5005
R472 IOVDD.t67 IOVDD.n253 7.5005
R473 IOVDD.t92 IOVDD.n83 7.5005
R474 IOVDD.n110 IOVDD.t92 7.5005
R475 IOVDD.t92 IOVDD.n109 7.5005
R476 IOVDD.n207 IOVDD.t79 7.5005
R477 IOVDD.t79 IOVDD.n127 7.5005
R478 IOVDD.t79 IOVDD.n125 7.5005
R479 IOVDD.t79 IOVDD.n130 7.5005
R480 IOVDD.t79 IOVDD.n123 7.5005
R481 IOVDD.t79 IOVDD.n133 7.5005
R482 IOVDD.t79 IOVDD.n122 7.5005
R483 IOVDD.t79 IOVDD.n136 7.5005
R484 IOVDD.t79 IOVDD.n121 7.5005
R485 IOVDD.t79 IOVDD.n138 7.5005
R486 IOVDD.t79 IOVDD.n120 7.5005
R487 IOVDD.t79 IOVDD.n141 7.5005
R488 IOVDD.t79 IOVDD.n119 7.5005
R489 IOVDD.t79 IOVDD.n144 7.5005
R490 IOVDD.t79 IOVDD.n118 7.5005
R491 IOVDD.t79 IOVDD.n147 7.5005
R492 IOVDD.t79 IOVDD.n117 7.5005
R493 IOVDD.t79 IOVDD.n150 7.5005
R494 IOVDD.t79 IOVDD.n116 7.5005
R495 IOVDD.t79 IOVDD.n152 7.5005
R496 IOVDD.t79 IOVDD.n115 7.5005
R497 IOVDD.t79 IOVDD.n155 7.5005
R498 IOVDD.t79 IOVDD.n114 7.5005
R499 IOVDD.t79 IOVDD.n158 7.5005
R500 IOVDD.t79 IOVDD.n113 7.5005
R501 IOVDD.t79 IOVDD.n161 7.5005
R502 IOVDD.t79 IOVDD.n112 7.5005
R503 IOVDD.t79 IOVDD.n206 7.5005
R504 IOVDD.t67 IOVDD.n252 7.5005
R505 IOVDD.t67 IOVDD.n250 7.5005
R506 IOVDD.t67 IOVDD.n249 7.5005
R507 IOVDD.t67 IOVDD.n248 7.5005
R508 IOVDD.t67 IOVDD.n247 7.5005
R509 IOVDD.t67 IOVDD.n246 7.5005
R510 IOVDD.t67 IOVDD.n245 7.5005
R511 IOVDD.t67 IOVDD.n76 7.5005
R512 IOVDD.t67 IOVDD.n244 7.5005
R513 IOVDD.t67 IOVDD.n243 7.5005
R514 IOVDD.t67 IOVDD.n242 7.5005
R515 IOVDD.t67 IOVDD.n241 7.5005
R516 IOVDD.t67 IOVDD.n58 7.5005
R517 IOVDD.t67 IOVDD.n255 7.5005
R518 IOVDD.t67 IOVDD.n256 7.5005
R519 IOVDD.n265 IOVDD.t67 7.5005
R520 IOVDD.t67 IOVDD.n257 7.5005
R521 IOVDD.t67 IOVDD.n258 7.5005
R522 IOVDD.t67 IOVDD.n259 7.5005
R523 IOVDD.t67 IOVDD.n260 7.5005
R524 IOVDD.t67 IOVDD.n77 7.5005
R525 IOVDD.t67 IOVDD.n261 7.5005
R526 IOVDD.t67 IOVDD.n262 7.5005
R527 IOVDD.t67 IOVDD.n263 7.5005
R528 IOVDD.t67 IOVDD.n264 7.5005
R529 IOVDD.n231 IOVDD.t221 7.27343
R530 IOVDD.n322 IOVDD.t218 6.79488
R531 IOVDD.n220 IOVDD.t6 6.02741
R532 IOVDD.n221 IOVDD.t9 6.02741
R533 IOVDD.n222 IOVDD.t8 5.74697
R534 IOVDD.n562 IOVDD.n288 5.66778
R535 IOVDD.n102 IOVDD.n97 5.66778
R536 IOVDD.n205 IOVDD.n81 5.66772
R537 IOVDD.n159 IOVDD.n81 5.66772
R538 IOVDD.n160 IOVDD.n81 5.66772
R539 IOVDD.n156 IOVDD.n81 5.66772
R540 IOVDD.n157 IOVDD.n81 5.66772
R541 IOVDD.n153 IOVDD.n81 5.66772
R542 IOVDD.n154 IOVDD.n81 5.66772
R543 IOVDD.n151 IOVDD.n81 5.66772
R544 IOVDD.n199 IOVDD.n81 5.66772
R545 IOVDD.n148 IOVDD.n81 5.66772
R546 IOVDD.n149 IOVDD.n81 5.66772
R547 IOVDD.n145 IOVDD.n81 5.66772
R548 IOVDD.n146 IOVDD.n81 5.66772
R549 IOVDD.n142 IOVDD.n81 5.66772
R550 IOVDD.n143 IOVDD.n81 5.66772
R551 IOVDD.n139 IOVDD.n81 5.66772
R552 IOVDD.n140 IOVDD.n81 5.66772
R553 IOVDD.n137 IOVDD.n81 5.66772
R554 IOVDD.n201 IOVDD.n81 5.66772
R555 IOVDD.n134 IOVDD.n81 5.66772
R556 IOVDD.n135 IOVDD.n81 5.66772
R557 IOVDD.n131 IOVDD.n81 5.66772
R558 IOVDD.n132 IOVDD.n81 5.66772
R559 IOVDD.n365 IOVDD.t86 5.66717
R560 IOVDD.n336 IOVDD.t85 5.66717
R561 IOVDD.n337 IOVDD.t85 5.66717
R562 IOVDD.n341 IOVDD.t58 5.66717
R563 IOVDD.n403 IOVDD.t57 5.66717
R564 IOVDD.n402 IOVDD.t57 5.66717
R565 IOVDD.n365 IOVDD.t75 5.66717
R566 IOVDD.t74 IOVDD.n336 5.66717
R567 IOVDD.n337 IOVDD.t74 5.66717
R568 IOVDD.n341 IOVDD.t188 5.66717
R569 IOVDD.n403 IOVDD.t165 5.66717
R570 IOVDD.t165 IOVDD.n402 5.66717
R571 IOVDD.t20 IOVDD.n296 5.66717
R572 IOVDD.n495 IOVDD.t20 5.66717
R573 IOVDD.t63 IOVDD.n531 5.66717
R574 IOVDD.n557 IOVDD.t51 5.66717
R575 IOVDD.n214 IOVDD.t117 5.66717
R576 IOVDD.n105 IOVDD.t116 5.66717
R577 IOVDD.n104 IOVDD.t116 5.66717
R578 IOVDD.n214 IOVDD.t100 5.66717
R579 IOVDD.n105 IOVDD.t99 5.66717
R580 IOVDD.n104 IOVDD.t99 5.66717
R581 IOVDD.n214 IOVDD.t94 5.66717
R582 IOVDD.n105 IOVDD.t93 5.66717
R583 IOVDD.t93 IOVDD.n104 5.66717
R584 IOVDD.n269 IOVDD.n26 5.66693
R585 IOVDD.n269 IOVDD.n17 5.66693
R586 IOVDD.n269 IOVDD.n27 5.66693
R587 IOVDD.n269 IOVDD.n15 5.66693
R588 IOVDD.n269 IOVDD.n28 5.66693
R589 IOVDD.n269 IOVDD.n13 5.66693
R590 IOVDD.n269 IOVDD.n29 5.66693
R591 IOVDD.n269 IOVDD.n12 5.66693
R592 IOVDD.n269 IOVDD.n30 5.66693
R593 IOVDD.n269 IOVDD.n10 5.66693
R594 IOVDD.n269 IOVDD.n31 5.66693
R595 IOVDD.n269 IOVDD.n9 5.66693
R596 IOVDD.n269 IOVDD.n32 5.66693
R597 IOVDD.n269 IOVDD.n8 5.66693
R598 IOVDD.n269 IOVDD.n33 5.66693
R599 IOVDD.n269 IOVDD.n7 5.66693
R600 IOVDD.n210 IOVDD.n90 5.66671
R601 IOVDD.n227 IOVDD.t60 5.66423
R602 IOVDD.t60 IOVDD.n80 5.66412
R603 IOVDD.n269 IOVDD.n51 5.61907
R604 IOVDD.n223 IOVDD.t7 5.61849
R605 IOVDD.n163 IOVDD.n81 5.60892
R606 IOVDD.n269 IOVDD.n59 5.60892
R607 IOVDD.n322 IOVDD.t217 5.56245
R608 IOVDD.n526 IOVDD.t32 5.50932
R609 IOVDD.n521 IOVDD.t36 5.50932
R610 IOVDD.n470 IOVDD.t64 5.0005
R611 IOVDD.n470 IOVDD.t135 5.0005
R612 IOVDD.n225 IOVDD 4.9805
R613 IOVDD IOVDD.n224 4.8465
R614 IOVDD.n359 IOVDD.n311 4.251
R615 IOVDD.n360 IOVDD.n311 4.251
R616 IOVDD.n452 IOVDD.n451 4.251
R617 IOVDD.n454 IOVDD.n453 4.251
R618 IOVDD.n456 IOVDD.n455 4.251
R619 IOVDD.n458 IOVDD.n457 4.251
R620 IOVDD.n480 IOVDD.n361 4.251
R621 IOVDD.n478 IOVDD.n477 4.251
R622 IOVDD.n450 IOVDD.n355 4.251
R623 IOVDD.n99 IOVDD.n98 4.251
R624 IOVDD.t16 IOVDD.n482 4.2505
R625 IOVDD.t154 IOVDD.n311 4.2505
R626 IOVDD.t20 IOVDD.n311 4.2505
R627 IOVDD.n518 IOVDD.t45 4.2505
R628 IOVDD.t45 IOVDD.n517 4.2505
R629 IOVDD.n101 IOVDD.t3 4.2505
R630 IOVDD.n269 IOVDD.n35 4.25043
R631 IOVDD.t128 IOVDD.n230 4.24713
R632 IOVDD.n79 IOVDD.t140 4.24713
R633 IOVDD.n464 IOVDD.n311 4.24691
R634 IOVDD.n405 IOVDD.n311 4.24623
R635 IOVDD.n449 IOVDD.n311 4.24604
R636 IOVDD.n559 IOVDD.n304 4.24178
R637 IOVDD.n291 IOVDD.n282 4.24178
R638 IOVDD.n277 IOVDD.n276 4.23953
R639 IOVDD.n573 IOVDD.n572 4.23934
R640 IOVDD.n495 IOVDD.n358 4.2324
R641 IOVDD.n495 IOVDD.n351 4.2324
R642 IOVDD.n495 IOVDD.n488 4.2324
R643 IOVDD.n495 IOVDD.n491 4.2324
R644 IOVDD.n181 IOVDD.n81 4.18441
R645 IOVDD.n188 IOVDD.n81 4.18291
R646 IOVDD.n269 IOVDD.n62 4.16888
R647 IOVDD.n191 IOVDD.n81 4.16875
R648 IOVDD.n165 IOVDD.n81 4.16875
R649 IOVDD.n162 IOVDD.n81 4.16875
R650 IOVDD.n269 IOVDD.n64 4.16875
R651 IOVDD.n269 IOVDD.n73 4.16875
R652 IOVDD.n526 IOVDD.t47 4.08428
R653 IOVDD.n527 IOVDD.t41 4.08428
R654 IOVDD.n528 IOVDD.t43 4.08428
R655 IOVDD.n521 IOVDD.t39 4.08428
R656 IOVDD.n522 IOVDD.t37 4.08428
R657 IOVDD.n523 IOVDD.t38 4.08428
R658 IOVDD.n185 IOVDD.t30 4.05283
R659 IOVDD.n47 IOVDD.t29 4.05283
R660 IOVDD.n275 IOVDD.t2 4.01845
R661 IOVDD.n236 IOVDD.t59 3.75125
R662 IOVDD.t59 IOVDD.n235 3.7505
R663 IOVDD.n357 IOVDD.t21 3.40658
R664 IOVDD.n352 IOVDD.t12 3.40658
R665 IOVDD.n485 IOVDD.t22 3.40658
R666 IOVDD.n487 IOVDD.t13 3.40658
R667 IOVDD.n489 IOVDD.t17 3.40658
R668 IOVDD.n490 IOVDD.t19 3.40658
R669 IOVDD.n348 IOVDD.t15 3.40658
R670 IOVDD.n567 IOVDD.n566 3.40124
R671 IOVDD.n481 IOVDD.n311 3.4005
R672 IOVDD.n495 IOVDD.t4 3.4005
R673 IOVDD.n240 IOVDD.t96 3.4005
R674 IOVDD.t68 IOVDD.n240 3.4005
R675 IOVDD.n86 IOVDD.t83 3.4005
R676 IOVDD.n86 IOVDD.t105 3.4005
R677 IOVDD.n202 IOVDD.t80 3.4005
R678 IOVDD.n200 IOVDD.t80 3.4005
R679 IOVDD.n203 IOVDD.t80 3.4005
R680 IOVDD.t102 IOVDD.n202 3.4005
R681 IOVDD.t102 IOVDD.n200 3.4005
R682 IOVDD.n203 IOVDD.t102 3.4005
R683 IOVDD.n267 IOVDD.t96 3.4005
R684 IOVDD.n266 IOVDD.t96 3.4005
R685 IOVDD.n34 IOVDD.t97 3.4005
R686 IOVDD.n267 IOVDD.t68 3.4005
R687 IOVDD.t68 IOVDD.n266 3.4005
R688 IOVDD.n34 IOVDD.t69 3.4005
R689 IOVDD.n269 IOVDD.n16 3.40017
R690 IOVDD.n269 IOVDD.n14 3.40017
R691 IOVDD.n269 IOVDD.n11 3.40017
R692 IOVDD.n269 IOVDD.n18 3.40017
R693 IOVDD.n476 IOVDD.n311 3.39567
R694 IOVDD.n569 IOVDD.n568 3.39397
R695 IOVDD.n559 IOVDD.n530 3.38767
R696 IOVDD.n559 IOVDD.n520 3.38767
R697 IOVDD.n277 IOVDD.n274 3.38635
R698 IOVDD.n574 IOVDD.n573 3.38599
R699 IOVDD.n495 IOVDD.n353 3.37726
R700 IOVDD.n495 IOVDD.n486 3.37726
R701 IOVDD.n495 IOVDD.n349 3.37726
R702 IOVDD.n269 IOVDD.n42 3.32037
R703 IOVDD.n269 IOVDD.n69 3.30348
R704 IOVDD.n168 IOVDD.n81 3.30348
R705 IOVDD.n571 IOVDD.n279 2.98668
R706 IOVDD.n575 IOVDD.n1 2.98568
R707 IOVDD.n492 IOVDD.n311 2.83433
R708 IOVDD.n204 IOVDD.n81 2.83332
R709 IOVDD.n269 IOVDD.n36 2.71716
R710 IOVDD.n218 IOVDD.n81 2.71714
R711 IOVDD.n216 IOVDD.n81 2.71714
R712 IOVDD.n179 IOVDD.n81 2.71657
R713 IOVDD.n278 IOVDD.n0 2.60501
R714 IOVDD.n273 IOVDD.n3 2.6035
R715 IOVDD.n187 IOVDD.n171 2.46905
R716 IOVDD.n272 IOVDD.n271 2.45906
R717 IOVDD.n219 IOVDD.n54 2.42957
R718 IOVDD.n495 IOVDD.t25 2.42907
R719 IOVDD.n269 IOVDD.n53 2.42879
R720 IOVDD.n559 IOVDD.n525 2.40646
R721 IOVDD.n183 IOVDD.n172 2.16139
R722 IOVDD.n45 IOVDD.n44 2.16138
R723 IOVDD.n50 IOVDD.n49 2.15839
R724 IOVDD.n504 IOVDD.t42 2.09932
R725 IOVDD.n506 IOVDD.t49 2.09932
R726 IOVDD.n495 IOVDD.n325 2.09481
R727 IOVDD.n184 IOVDD.n81 2.09091
R728 IOVDD.n269 IOVDD.n46 2.0905
R729 IOVDD.n495 IOVDD.n320 2.02588
R730 IOVDD.t28 IOVDD.n50 1.89036
R731 IOVDD.n171 IOVDD.t3 1.89034
R732 IOVDD.n350 IOVDD.n311 1.88989
R733 IOVDD.n495 IOVDD.t14 1.88939
R734 IOVDD.n222 IOVDD.n221 1.85911
R735 IOVDD.n223 IOVDD.n222 1.81986
R736 IOVDD.n224 IOVDD.n220 1.4965
R737 IOVDD.n269 IOVDD.n48 1.49598
R738 IOVDD.n528 IOVDD.n527 1.42554
R739 IOVDD.n527 IOVDD.n526 1.42554
R740 IOVDD.n523 IOVDD.n522 1.42554
R741 IOVDD.n522 IOVDD.n521 1.42554
R742 IOVDD.n493 IOVDD.n311 1.41785
R743 IOVDD.t16 IOVDD.n321 1.41772
R744 IOVDD.n559 IOVDD.n502 1.4117
R745 IOVDD.n186 IOVDD.n81 1.36201
R746 IOVDD.n269 IOVDD.n21 1.25728
R747 IOVDD.n269 IOVDD.n20 1.25728
R748 IOVDD.n219 IOVDD 1.25083
R749 IOVDD.n442 IOVDD.t70 1.24932
R750 IOVDD.n420 IOVDD.t89 1.24905
R751 IOVDD.n483 IOVDD.n311 1.13429
R752 IOVDD.n324 IOVDD.n322 1.11206
R753 IOVDD.n272 IOVDD 1.09291
R754 IOVDD.t31 IOVDD.n296 1.063
R755 IOVDD.n40 IOVDD.n39 1.0405
R756 IOVDD.n39 IOVDD.n38 1.0405
R757 IOVDD.n38 IOVDD.n37 1.0405
R758 IOVDD.n174 IOVDD.n173 1.0405
R759 IOVDD.n175 IOVDD.n174 1.0405
R760 IOVDD.n176 IOVDD.n175 1.0405
R761 IOVDD.n544 IOVDD.n283 1.01176
R762 IOVDD.n497 IOVDD.n496 1.001
R763 IOVDD.n367 IOVDD.n311 0.996985
R764 IOVDD.n561 IOVDD.n292 0.973103
R765 IOVDD.n560 IOVDD.t31 0.944944
R766 IOVDD.n342 IOVDD.n319 0.906269
R767 IOVDD.n279 IOVDD.t1 0.895684
R768 IOVDD.n269 IOVDD.n72 0.872024
R769 IOVDD.n170 IOVDD.n169 0.869804
R770 IOVDD.n72 IOVDD.n70 0.868873
R771 IOVDD.n559 IOVDD.n308 0.866136
R772 IOVDD.n545 IOVDD.n544 0.85453
R773 IOVDD.n562 IOVDD.n561 0.851653
R774 IOVDD.n500 IOVDD 0.849183
R775 IOVDD.n41 IOVDD.n40 0.847167
R776 IOVDD.n180 IOVDD.n176 0.847167
R777 IOVDD.n72 IOVDD.n71 0.829544
R778 IOVDD.n501 IOVDD.n308 0.814051
R779 IOVDD.n511 IOVDD.n308 0.813858
R780 IOVDD.n170 IOVDD.n81 0.791953
R781 IOVDD.n189 IOVDD.n170 0.789138
R782 IOVDD.n544 IOVDD.n282 0.788717
R783 IOVDD.t1 IOVDD.n278 0.773686
R784 IOVDD.n126 IOVDD.n81 0.77366
R785 IOVDD.n561 IOVDD.n560 0.773119
R786 IOVDD.n499 IOVDD.n498 0.746184
R787 IOVDD.n368 IOVDD 0.744375
R788 IOVDD.n269 IOVDD.n19 0.709597
R789 IOVDD.n495 IOVDD.t0 0.708833
R790 IOVDD.n402 IOVDD.n347 0.677264
R791 IOVDD.n190 IOVDD.n81 0.646966
R792 IOVDD.n566 IOVDD.n286 0.63063
R793 IOVDD.n484 IOVDD.n311 0.630574
R794 IOVDD.n529 IOVDD.n528 0.630521
R795 IOVDD.n524 IOVDD.n523 0.630521
R796 IOVDD.n348 IOVDD.n319 0.619378
R797 IOVDD.n269 IOVDD.n61 0.612436
R798 IOVDD.n210 IOVDD.n82 0.600421
R799 IOVDD.n224 IOVDD.n223 0.59255
R800 IOVDD.n198 IOVDD.n81 0.548611
R801 IOVDD.n269 IOVDD.n6 0.548367
R802 IOVDD.n498 IOVDD.n497 0.497916
R803 IOVDD.n436 IOVDD.n435 0.486742
R804 IOVDD.n497 IOVDD 0.4845
R805 IOVDD.n435 IOVDD.n434 0.473892
R806 IOVDD.n269 IOVDD.t3 0.45996
R807 IOVDD.n169 IOVDD.n168 0.423624
R808 IOVDD.n71 IOVDD.n69 0.423001
R809 IOVDD.n494 IOVDD.n311 0.38912
R810 IOVDD.n217 IOVDD.n216 0.38286
R811 IOVDD.n210 IOVDD.t3 0.378278
R812 IOVDD.n218 IOVDD.n217 0.377459
R813 IOVDD.n495 IOVDD.n319 0.374302
R814 IOVDD.n500 IOVDD 0.370037
R815 IOVDD.n69 IOVDD.n68 0.368624
R816 IOVDD.n168 IOVDD.n167 0.368001
R817 IOVDD.n219 IOVDD.n218 0.359027
R818 IOVDD.n216 IOVDD.n215 0.357293
R819 IOVDD.n180 IOVDD.n179 0.347973
R820 IOVDD.n239 IOVDD 0.347643
R821 IOVDD.n41 IOVDD.n36 0.347134
R822 IOVDD.n495 IOVDD.n494 0.341432
R823 IOVDD.n498 IOVDD.n296 0.341324
R824 IOVDD.n271 IOVDD 0.334484
R825 IOVDD.n42 IOVDD.n41 0.329739
R826 IOVDD.n366 IOVDD.n320 0.328003
R827 IOVDD.n96 IOVDD.n82 0.323154
R828 IOVDD.n215 IOVDD.n82 0.322216
R829 IOVDD.n63 IOVDD.n61 0.32141
R830 IOVDD.n311 IOVDD.n295 0.315674
R831 IOVDD.n66 IOVDD.n64 0.311717
R832 IOVDD.n191 IOVDD.n164 0.311717
R833 IOVDD.n165 IOVDD.n164 0.311717
R834 IOVDD.n66 IOVDD.n62 0.311584
R835 IOVDD.n190 IOVDD.n189 0.311459
R836 IOVDD.n192 IOVDD.n190 0.31098
R837 IOVDD.t31 IOVDD.n559 0.304071
R838 IOVDD.n342 IOVDD.n320 0.300574
R839 IOVDD.n59 IOVDD.n4 0.297232
R840 IOVDD.n195 IOVDD.n163 0.296892
R841 IOVDD.n70 IOVDD.n61 0.29597
R842 IOVDD.n181 IOVDD.n180 0.292894
R843 IOVDD.n68 IOVDD.n62 0.274525
R844 IOVDD.n64 IOVDD.n63 0.274396
R845 IOVDD.n197 IOVDD.n162 0.274396
R846 IOVDD.n192 IOVDD.n191 0.274396
R847 IOVDD.n167 IOVDD.n165 0.274396
R848 IOVDD.n73 IOVDD.n5 0.274396
R849 IOVDD.n251 IOVDD.n36 0.271789
R850 IOVDD.n179 IOVDD.n178 0.270896
R851 IOVDD.n519 IOVDD 0.234885
R852 IOVDD.n195 IOVDD.n162 0.229217
R853 IOVDD.n73 IOVDD.n4 0.229217
R854 IOVDD IOVDD.n181 0.220962
R855 IOVDD.n368 IOVDD.n367 0.210187
R856 IOVDD.n186 IOVDD.n185 0.209136
R857 IOVDD.n192 IOVDD.n163 0.208839
R858 IOVDD.n63 IOVDD.n59 0.208499
R859 IOVDD.n367 IOVDD.n366 0.207427
R860 IOVDD.n49 IOVDD.n42 0.20702
R861 IOVDD.n51 IOVDD 0.205876
R862 IOVDD.n48 IOVDD.n47 0.190775
R863 IOVDD.n49 IOVDD.n48 0.184316
R864 IOVDD.n124 IOVDD 0.183132
R865 IOVDD.n129 IOVDD 0.182089
R866 IOVDD.n188 IOVDD.n187 0.174637
R867 IOVDD IOVDD.n20 0.17205
R868 IOVDD.n21 IOVDD 0.170137
R869 IOVDD.n187 IOVDD.n186 0.165272
R870 IOVDD.n189 IOVDD.n188 0.163917
R871 IOVDD.n87 IOVDD.n21 0.154193
R872 IOVDD.n239 IOVDD.n20 0.15228
R873 IOVDD.n184 IOVDD.n183 0.141369
R874 IOVDD.n46 IOVDD.n45 0.13808
R875 IOVDD.n435 IOVDD.n311 0.131642
R876 IOVDD.n325 IOVDD.n324 0.127133
R877 IOVDD.n532 IOVDD 0.123915
R878 IOVDD.n514 IOVDD.n504 0.116954
R879 IOVDD.n366 IOVDD 0.11677
R880 IOVDD.n506 IOVDD.n505 0.114839
R881 IOVDD.n505 IOVDD.n504 0.114163
R882 IOVDD.n513 IOVDD.n506 0.113106
R883 IOVDD.n70 IOVDD.n51 0.109186
R884 IOVDD.n556 IOVDD.n555 0.108056
R885 IOVDD.n215 IOVDD 0.106128
R886 IOVDD.n47 IOVDD.n46 0.10114
R887 IOVDD.n366 IOVDD.n325 0.0979804
R888 IOVDD.n185 IOVDD.n184 0.0978611
R889 IOVDD.n358 IOVDD.n356 0.0932114
R890 IOVDD.n488 IOVDD.n487 0.0847409
R891 IOVDD.n357 IOVDD.n353 0.0791218
R892 IOVDD.n349 IOVDD.n348 0.0779121
R893 IOVDD.n352 IOVDD.n351 0.0758699
R894 IOVDD.n491 IOVDD.n490 0.0751152
R895 IOVDD.n555 IOVDD.n283 0.0750556
R896 IOVDD.n486 IOVDD.n485 0.0737992
R897 IOVDD.n275 IOVDD.n274 0.070646
R898 IOVDD.n574 IOVDD.n2 0.0700405
R899 IOVDD.t28 IOVDD.n44 0.0694593
R900 IOVDD.n487 IOVDD.n486 0.0690411
R901 IOVDD.n491 IOVDD.n489 0.0669989
R902 IOVDD.n87 IOVDD 0.066943
R903 IOVDD.n172 IOVDD.t3 0.0662995
R904 IOVDD.n485 IOVDD.n351 0.0662442
R905 IOVDD.n490 IOVDD.n349 0.0649282
R906 IOVDD.n226 IOVDD.n225 0.0644004
R907 IOVDD.n353 IOVDD.n352 0.0637185
R908 IOVDD.n529 IOVDD.n525 0.0635586
R909 IOVDD.n358 IOVDD.n357 0.0609217
R910 IOVDD.n525 IOVDD.n524 0.060776
R911 IOVDD.n575 IOVDD.n574 0.0584921
R912 IOVDD.n274 IOVDD.n273 0.05789
R913 IOVDD.n489 IOVDD.n488 0.0573733
R914 IOVDD.n530 IOVDD.n529 0.0511951
R915 IOVDD.n524 IOVDD.n520 0.0511936
R916 IOVDD.n554 IOVDD.n533 0.0507404
R917 IOVDD.n513 IOVDD.n512 0.0496827
R918 IOVDD.n553 IOVDD.n552 0.0496827
R919 IOVDD.n276 IOVDD.n0 0.0490732
R920 IOVDD.n572 IOVDD.n571 0.0486964
R921 IOVDD.n540 IOVDD.n538 0.048625
R922 IOVDD.n538 IOVDD.n537 0.0475673
R923 IOVDD IOVDD.n575 0.04725
R924 IOVDD.n553 IOVDD.n543 0.0465096
R925 IOVDD.n231 IOVDD.n56 0.0461432
R926 IOVDD.n536 IOVDD.n535 0.0437551
R927 IOVDD.n536 IOVDD.n534 0.0437551
R928 IOVDD.n542 IOVDD.n541 0.0437551
R929 IOVDD.n542 IOVDD.n539 0.0437551
R930 IOVDD.n57 IOVDD 0.0419511
R931 IOVDD.n304 IOVDD.n292 0.0389227
R932 IOVDD.n562 IOVDD.n291 0.0389227
R933 IOVDD.n520 IOVDD.n519 0.0355853
R934 IOVDD.n532 IOVDD.n530 0.0355839
R935 IOVDD.n517 IOVDD.n502 0.0350424
R936 IOVDD.n572 IOVDD.n2 0.0332964
R937 IOVDD.n515 IOVDD.n514 0.0332885
R938 IOVDD.n556 IOVDD.n554 0.0332885
R939 IOVDD.n356 IOVDD.n309 0.0329221
R940 IOVDD.n276 IOVDD.n275 0.0329203
R941 IOVDD.n323 IOVDD.n312 0.0317258
R942 IOVDD.n318 IOVDD.n316 0.0317258
R943 IOVDD.n317 IOVDD.n313 0.0317258
R944 IOVDD.n315 IOVDD.n314 0.0317258
R945 IOVDD.n508 IOVDD.n304 0.0306618
R946 IOVDD.n546 IOVDD.n291 0.0306618
R947 IOVDD.n309 IOVDD 0.0271129
R948 IOVDD.n235 IOVDD.n234 0.0256037
R949 IOVDD.n235 IOVDD.n78 0.0256037
R950 IOVDD.n237 IOVDD.n236 0.0256037
R951 IOVDD.n236 IOVDD.n229 0.0256037
R952 IOVDD.n569 IOVDD.n283 0.025011
R953 IOVDD.n182 IOVDD 0.0226642
R954 IOVDD.n537 IOVDD.n534 0.0221276
R955 IOVDD.n543 IOVDD.n539 0.0221276
R956 IOVDD.n541 IOVDD.n540 0.0221276
R957 IOVDD.n535 IOVDD.n533 0.0221276
R958 IOVDD.n232 IOVDD.n231 0.0196701
R959 IOVDD.n194 IOVDD.n193 0.0195667
R960 IOVDD.n65 IOVDD.n60 0.0195667
R961 IOVDD.n34 IOVDD.n6 0.0189738
R962 IOVDD.n405 IOVDD.n404 0.0187137
R963 IOVDD IOVDD.n449 0.018338
R964 IOVDD.n233 IOVDD.n230 0.0183378
R965 IOVDD.n203 IOVDD.n198 0.0181567
R966 IOVDD.n316 IOVDD.n312 0.0175323
R967 IOVDD.n318 IOVDD.n317 0.0175323
R968 IOVDD.n314 IOVDD.n313 0.0175323
R969 IOVDD.n315 IOVDD.n310 0.0175323
R970 IOVDD.n476 IOVDD.n475 0.0167406
R971 IOVDD IOVDD.n43 0.016097
R972 IOVDD.n478 IOVDD.n476 0.0155853
R973 IOVDD.n570 IOVDD.n569 0.0154869
R974 IOVDD.n464 IOVDD 0.015478
R975 IOVDD.n558 IOVDD.n531 0.0153461
R976 IOVDD.n449 IOVDD.n448 0.0153019
R977 IOVDD.n406 IOVDD.n405 0.0149264
R978 IOVDD.n442 IOVDD.n441 0.0147758
R979 IOVDD.n558 IOVDD.n557 0.0147084
R980 IOVDD.n497 IOVDD.n310 0.0146935
R981 IOVDD.n421 IOVDD.n420 0.0144441
R982 IOVDD.n443 IOVDD.n442 0.0140934
R983 IOVDD.n420 IOVDD.n419 0.0134257
R984 IOVDD.n465 IOVDD.n464 0.0129736
R985 IOVDD.n228 IOVDD.n227 0.01231
R986 IOVDD.n499 IOVDD.n309 0.0122438
R987 IOVDD IOVDD.n499 0.0122438
R988 IOVDD.n509 IOVDD.n306 0.0122391
R989 IOVDD.n551 IOVDD.n550 0.0122391
R990 IOVDD.n511 IOVDD.n307 0.0120217
R991 IOVDD.n549 IOVDD.n545 0.0120217
R992 IOVDD.n324 IOVDD.n323 0.0118548
R993 IOVDD.n228 IOVDD.n80 0.0116434
R994 IOVDD.n234 IOVDD.n230 0.0101046
R995 IOVDD.n238 IOVDD.n79 0.0101046
R996 IOVDD.n502 IOVDD.n501 0.00987896
R997 IOVDD.n237 IOVDD.n79 0.00985405
R998 IOVDD.n507 IOVDD.n305 0.00963044
R999 IOVDD.n548 IOVDD.n547 0.00963044
R1000 IOVDD.n45 IOVDD.n43 0.00952985
R1001 IOVDD.n233 IOVDD.n232 0.0089838
R1002 IOVDD.n508 IOVDD.n305 0.00876087
R1003 IOVDD.n547 IOVDD.n546 0.00876087
R1004 IOVDD.n273 IOVDD.n272 0.00875
R1005 IOVDD IOVDD.n0 0.00875
R1006 IOVDD.n571 IOVDD 0.00875
R1007 IOVDD.n97 IOVDD.n96 0.00871577
R1008 IOVDD.n96 IOVDD.n56 0.00871577
R1009 IOVDD.n239 IOVDD.n238 0.00871577
R1010 IOVDD.n517 IOVDD.n503 0.00839744
R1011 IOVDD.n302 IOVDD.n283 0.00831159
R1012 IOVDD.n239 IOVDD.n78 0.00825934
R1013 IOVDD.n446 IOVDD.n444 0.00797346
R1014 IOVDD.n440 IOVDD.n379 0.00797346
R1015 IOVDD.n418 IOVDD.n393 0.00797346
R1016 IOVDD.n427 IOVDD.n422 0.00797346
R1017 IOVDD.n518 IOVDD.n516 0.00783333
R1018 IOVDD.n512 IOVDD.n511 0.007375
R1019 IOVDD.n552 IOVDD.n545 0.007375
R1020 IOVDD.n219 IOVDD 0.00734647
R1021 IOVDD.n447 IOVDD.n445 0.00715605
R1022 IOVDD.n416 IOVDD.n394 0.00715605
R1023 IOVDD.n448 IOVDD.n369 0.00703928
R1024 IOVDD.n381 IOVDD.n380 0.00703928
R1025 IOVDD.n438 IOVDD.n436 0.00703928
R1026 IOVDD.n411 IOVDD.n406 0.00703928
R1027 IOVDD.n430 IOVDD.n428 0.00703928
R1028 IOVDD.n434 IOVDD.n389 0.00703928
R1029 IOVDD.n227 IOVDD.n226 0.00665476
R1030 IOVDD.n378 IOVDD.n377 0.00633864
R1031 IOVDD.n417 IOVDD.n415 0.00633864
R1032 IOVDD.n229 IOVDD.n80 0.0063217
R1033 IOVDD.n6 IOVDD.n5 0.00630737
R1034 IOVDD.n338 IOVDD.n337 0.0062329
R1035 IOVDD.n383 IOVDD.n382 0.00622187
R1036 IOVDD.n439 IOVDD.n437 0.00622187
R1037 IOVDD.n426 IOVDD.n425 0.00622187
R1038 IOVDD.n432 IOVDD.n390 0.00622187
R1039 IOVDD.n507 IOVDD.n306 0.00615217
R1040 IOVDD.n550 IOVDD.n548 0.00615217
R1041 IOVDD.n198 IOVDD.n197 0.00613075
R1042 IOVDD.n371 IOVDD.n370 0.0061051
R1043 IOVDD.n414 IOVDD.n412 0.0061051
R1044 IOVDD.n470 IOVDD.n469 0.00608669
R1045 IOVDD.n471 IOVDD.n470 0.00608669
R1046 IOVDD.n204 IOVDD.n203 0.00605897
R1047 IOVDD.n466 IOVDD.n465 0.00589405
R1048 IOVDD.n475 IOVDD.n462 0.00589405
R1049 IOVDD.n206 IOVDD.n204 0.00588394
R1050 IOVDD.n467 IOVDD.n463 0.0057014
R1051 IOVDD.n474 IOVDD.n473 0.0057014
R1052 IOVDD.n398 IOVDD.n345 0.00560586
R1053 IOVDD.n399 IOVDD.n343 0.00560586
R1054 IOVDD.n516 IOVDD.n515 0.00557692
R1055 IOVDD.n264 IOVDD.n35 0.00552582
R1056 IOVDD.n469 IOVDD.n468 0.00550876
R1057 IOVDD.n472 IOVDD.n471 0.00550876
R1058 IOVDD.n444 IOVDD.n443 0.00543644
R1059 IOVDD.n441 IOVDD.n440 0.00543644
R1060 IOVDD.n419 IOVDD.n418 0.00543644
R1061 IOVDD.n422 IOVDD.n421 0.00543644
R1062 IOVDD.n376 IOVDD.n375 0.00540446
R1063 IOVDD.n388 IOVDD.n387 0.00540446
R1064 IOVDD.n407 IOVDD.n395 0.00540446
R1065 IOVDD.n433 IOVDD.n431 0.00540446
R1066 IOVDD.n478 IOVDD.n368 0.00531611
R1067 IOVDD.n481 IOVDD.n368 0.00531611
R1068 IOVDD.n373 IOVDD.n372 0.00528769
R1069 IOVDD.n385 IOVDD.n384 0.00528769
R1070 IOVDD.n410 IOVDD.n409 0.00528769
R1071 IOVDD.n424 IOVDD.n423 0.00528769
R1072 IOVDD IOVDD.n570 0.00528261
R1073 IOVDD.n255 IOVDD.n18 0.00507734
R1074 IOVDD.n515 IOVDD.n503 0.00501282
R1075 IOVDD.n240 IOVDD.n53 0.00489737
R1076 IOVDD.n248 IOVDD.n16 0.00487706
R1077 IOVDD.n246 IOVDD.n14 0.00487706
R1078 IOVDD.n244 IOVDD.n11 0.00487706
R1079 IOVDD.n501 IOVDD.n500 0.00473077
R1080 IOVDD.n254 IOVDD.n53 0.00472498
R1081 IOVDD.n133 IOVDD.n132 0.00467928
R1082 IOVDD.n131 IOVDD.n122 0.00467928
R1083 IOVDD.n136 IOVDD.n135 0.00467928
R1084 IOVDD.n134 IOVDD.n121 0.00467928
R1085 IOVDD.n137 IOVDD.n120 0.00467928
R1086 IOVDD.n141 IOVDD.n140 0.00467928
R1087 IOVDD.n139 IOVDD.n119 0.00467928
R1088 IOVDD.n144 IOVDD.n143 0.00467928
R1089 IOVDD.n142 IOVDD.n118 0.00467928
R1090 IOVDD.n147 IOVDD.n146 0.00467928
R1091 IOVDD.n145 IOVDD.n117 0.00467928
R1092 IOVDD.n150 IOVDD.n149 0.00467928
R1093 IOVDD.n148 IOVDD.n116 0.00467928
R1094 IOVDD.n151 IOVDD.n115 0.00467928
R1095 IOVDD.n155 IOVDD.n154 0.00467928
R1096 IOVDD.n153 IOVDD.n114 0.00467928
R1097 IOVDD.n158 IOVDD.n157 0.00467928
R1098 IOVDD.n156 IOVDD.n113 0.00467928
R1099 IOVDD.n161 IOVDD.n160 0.00467928
R1100 IOVDD.n159 IOVDD.n112 0.00467928
R1101 IOVDD.n206 IOVDD.n205 0.00467928
R1102 IOVDD.n374 IOVDD.n373 0.00458705
R1103 IOVDD.n409 IOVDD.n408 0.00458705
R1104 IOVDD.n386 IOVDD.n385 0.00447028
R1105 IOVDD.n387 IOVDD.n386 0.00447028
R1106 IOVDD.n423 IOVDD.n391 0.00447028
R1107 IOVDD.n431 IOVDD.n391 0.00447028
R1108 IOVDD.n241 IOVDD.n7 0.00444105
R1109 IOVDD.n263 IOVDD.n33 0.00444105
R1110 IOVDD.n242 IOVDD.n8 0.00444105
R1111 IOVDD.n262 IOVDD.n32 0.00444105
R1112 IOVDD.n243 IOVDD.n9 0.00444105
R1113 IOVDD.n261 IOVDD.n31 0.00444105
R1114 IOVDD.n244 IOVDD.n10 0.00444105
R1115 IOVDD.n260 IOVDD.n30 0.00444105
R1116 IOVDD.n245 IOVDD.n12 0.00444105
R1117 IOVDD.n259 IOVDD.n29 0.00444105
R1118 IOVDD.n246 IOVDD.n13 0.00444105
R1119 IOVDD.n257 IOVDD.n28 0.00444105
R1120 IOVDD.n248 IOVDD.n15 0.00444105
R1121 IOVDD.n256 IOVDD.n27 0.00444105
R1122 IOVDD.n250 IOVDD.n17 0.00444105
R1123 IOVDD.n255 IOVDD.n26 0.00444105
R1124 IOVDD.n375 IOVDD.n374 0.0043535
R1125 IOVDD.n408 IOVDD.n407 0.0043535
R1126 IOVDD.n90 IOVDD.n89 0.00434574
R1127 IOVDD.n252 IOVDD.n251 0.00430541
R1128 IOVDD IOVDD.n52 0.00421204
R1129 IOVDD.n104 IOVDD.n91 0.00417304
R1130 IOVDD.n68 IOVDD.n67 0.00416667
R1131 IOVDD.n167 IOVDD.n166 0.00416667
R1132 IOVDD.n77 IOVDD.n11 0.00416415
R1133 IOVDD.n258 IOVDD.n14 0.00416415
R1134 IOVDD.n265 IOVDD.n16 0.00416415
R1135 IOVDD.n397 IOVDD.n346 0.00404506
R1136 IOVDD.n339 IOVDD.n338 0.00404506
R1137 IOVDD.n331 IOVDD.n329 0.00404506
R1138 IOVDD.n364 IOVDD.n326 0.00404506
R1139 IOVDD.n333 IOVDD.n326 0.00404506
R1140 IOVDD.n330 IOVDD.n329 0.00404506
R1141 IOVDD.n340 IOVDD.n339 0.00404506
R1142 IOVDD.n401 IOVDD.n346 0.00404506
R1143 IOVDD.n252 IOVDD.n18 0.00396393
R1144 IOVDD.n109 IOVDD.n92 0.00374996
R1145 IOVDD.n110 IOVDD.n95 0.00374996
R1146 IOVDD.n211 IOVDD.n83 0.00374996
R1147 IOVDD.n372 IOVDD.n371 0.00365287
R1148 IOVDD.n384 IOVDD.n383 0.00365287
R1149 IOVDD.n412 IOVDD.n410 0.00365287
R1150 IOVDD.n425 IOVDD.n424 0.00365287
R1151 IOVDD.n404 IOVDD.n344 0.00363518
R1152 IOVDD.n332 IOVDD.n331 0.00363518
R1153 IOVDD.n335 IOVDD.n328 0.00363518
R1154 IOVDD.n334 IOVDD.n327 0.00363518
R1155 IOVDD.n509 IOVDD.n307 0.00354348
R1156 IOVDD.n551 IOVDD.n549 0.00354348
R1157 IOVDD.n377 IOVDD.n376 0.00353609
R1158 IOVDD.n437 IOVDD.n388 0.00353609
R1159 IOVDD.n415 IOVDD.n395 0.00353609
R1160 IOVDD.n433 IOVDD.n432 0.00353609
R1161 IOVDD.n35 IOVDD.n34 0.00346788
R1162 IOVDD.n342 IOVDD.n341 0.00345603
R1163 IOVDD.n332 IOVDD.n328 0.00345603
R1164 IOVDD.n334 IOVDD.n333 0.00345603
R1165 IOVDD.n103 IOVDD.n90 0.00344829
R1166 IOVDD.n497 IOVDD 0.00338967
R1167 IOVDD.n481 IOVDD 0.00338967
R1168 IOVDD.n336 IOVDD.n327 0.00336645
R1169 IOVDD.n178 IOVDD.n123 0.00335405
R1170 IOVDD.n267 IOVDD.n77 0.00335405
R1171 IOVDD.n494 IOVDD.t18 0.00325659
R1172 IOVDD.n125 IOVDD.n124 0.00322216
R1173 IOVDD.n266 IOVDD.n265 0.00311622
R1174 IOVDD.n171 IOVDD.n81 0.00309928
R1175 IOVDD.n57 IOVDD.n52 0.00309843
R1176 IOVDD.n129 IOVDD.n128 0.00309843
R1177 IOVDD.n269 IOVDD.n50 0.0030866
R1178 IOVDD.n254 IOVDD.n19 0.00308241
R1179 IOVDD.n557 IOVDD.n532 0.00305072
R1180 IOVDD.n202 IOVDD.n201 0.00301442
R1181 IOVDD.n402 IOVDD.n401 0.00300814
R1182 IOVDD.n183 IOVDD.n182 0.00296269
R1183 IOVDD.n370 IOVDD.n369 0.00283546
R1184 IOVDD.n414 IOVDD.n411 0.00283546
R1185 IOVDD.n450 IOVDD.n295 0.00279587
R1186 IOVDD.n200 IOVDD.n199 0.00277658
R1187 IOVDD.n519 IOVDD.n518 0.00275641
R1188 IOVDD.n382 IOVDD.n381 0.00271868
R1189 IOVDD.n439 IOVDD.n438 0.00271868
R1190 IOVDD.n428 IOVDD.n426 0.00271868
R1191 IOVDD.n390 IOVDD.n389 0.00271868
R1192 IOVDD.n258 IOVDD 0.00264054
R1193 IOVDD.n495 IOVDD.n347 0.00261784
R1194 IOVDD.n445 IOVDD.n378 0.00260191
R1195 IOVDD.n417 IOVDD.n416 0.00260191
R1196 IOVDD.n264 IOVDD.n7 0.00260154
R1197 IOVDD.n241 IOVDD.n33 0.00260154
R1198 IOVDD.n263 IOVDD.n8 0.00260154
R1199 IOVDD.n242 IOVDD.n32 0.00260154
R1200 IOVDD.n262 IOVDD.n9 0.00260154
R1201 IOVDD.n243 IOVDD.n31 0.00260154
R1202 IOVDD.n261 IOVDD.n10 0.00260154
R1203 IOVDD.n76 IOVDD.n30 0.00260154
R1204 IOVDD.n260 IOVDD.n12 0.00260154
R1205 IOVDD.n245 IOVDD.n29 0.00260154
R1206 IOVDD.n259 IOVDD.n13 0.00260154
R1207 IOVDD.n247 IOVDD.n28 0.00260154
R1208 IOVDD.n257 IOVDD.n15 0.00260154
R1209 IOVDD.n249 IOVDD.n27 0.00260154
R1210 IOVDD.n256 IOVDD.n17 0.00260154
R1211 IOVDD.n250 IOVDD.n26 0.00260154
R1212 IOVDD.n107 IOVDD.n93 0.00247436
R1213 IOVDD.n126 IOVDD.n23 0.00247333
R1214 IOVDD.n531 IOVDD.n302 0.00241304
R1215 IOVDD.n200 IOVDD.n152 0.0024027
R1216 IOVDD.n347 IOVDD.n311 0.00238174
R1217 IOVDD.n404 IOVDD.n403 0.00238111
R1218 IOVDD.n205 IOVDD.n112 0.00236395
R1219 IOVDD.n161 IOVDD.n159 0.00236395
R1220 IOVDD.n160 IOVDD.n113 0.00236395
R1221 IOVDD.n158 IOVDD.n156 0.00236395
R1222 IOVDD.n157 IOVDD.n114 0.00236395
R1223 IOVDD.n155 IOVDD.n153 0.00236395
R1224 IOVDD.n154 IOVDD.n115 0.00236395
R1225 IOVDD.n152 IOVDD.n151 0.00236395
R1226 IOVDD.n199 IOVDD.n116 0.00236395
R1227 IOVDD.n150 IOVDD.n148 0.00236395
R1228 IOVDD.n149 IOVDD.n117 0.00236395
R1229 IOVDD.n147 IOVDD.n145 0.00236395
R1230 IOVDD.n146 IOVDD.n118 0.00236395
R1231 IOVDD.n144 IOVDD.n142 0.00236395
R1232 IOVDD.n143 IOVDD.n119 0.00236395
R1233 IOVDD.n141 IOVDD.n139 0.00236395
R1234 IOVDD.n140 IOVDD.n120 0.00236395
R1235 IOVDD.n138 IOVDD.n137 0.00236395
R1236 IOVDD.n201 IOVDD.n121 0.00236395
R1237 IOVDD.n136 IOVDD.n134 0.00236395
R1238 IOVDD.n135 IOVDD.n122 0.00236395
R1239 IOVDD.n133 IOVDD.n131 0.00236395
R1240 IOVDD.n132 IOVDD.n123 0.00236395
R1241 IOVDD.n343 IOVDD.n342 0.00220195
R1242 IOVDD.n253 IOVDD.n19 0.00219915
R1243 IOVDD.n202 IOVDD.n138 0.00216486
R1244 IOVDD IOVDD.n75 0.00216486
R1245 IOVDD.n89 IOVDD.n88 0.00205128
R1246 IOVDD.n58 IOVDD.n57 0.00204595
R1247 IOVDD.n271 IOVDD.n270 0.00204595
R1248 IOVDD.n208 IOVDD.n22 0.00204362
R1249 IOVDD.n468 IOVDD.n463 0.00204116
R1250 IOVDD.n473 IOVDD.n472 0.00204116
R1251 IOVDD.n193 IOVDD.n192 0.00196667
R1252 IOVDD.n63 IOVDD.n60 0.00196667
R1253 IOVDD.n341 IOVDD.n340 0.00193322
R1254 IOVDD.n366 IOVDD.n365 0.00193322
R1255 IOVDD.n380 IOVDD.n379 0.00190127
R1256 IOVDD.n430 IOVDD.n427 0.00190127
R1257 IOVDD.n467 IOVDD.n466 0.00184851
R1258 IOVDD.n474 IOVDD.n462 0.00184851
R1259 IOVDD.t4 IOVDD.n484 0.0018333
R1260 IOVDD.t4 IOVDD.n483 0.00179999
R1261 IOVDD.n447 IOVDD.n446 0.0017845
R1262 IOVDD.n394 IOVDD.n393 0.0017845
R1263 IOVDD.n106 IOVDD.n92 0.00177561
R1264 IOVDD.n95 IOVDD.n94 0.00177561
R1265 IOVDD.n212 IOVDD.n211 0.00177561
R1266 IOVDD.n108 IOVDD.n91 0.00177561
R1267 IOVDD.n109 IOVDD.n108 0.00176923
R1268 IOVDD.n107 IOVDD.n106 0.00176923
R1269 IOVDD.n111 IOVDD.n110 0.00176923
R1270 IOVDD.n94 IOVDD.n83 0.00176923
R1271 IOVDD.n214 IOVDD.n213 0.00176923
R1272 IOVDD.n477 IOVDD.n452 0.00175
R1273 IOVDD.n495 IOVDD.n355 0.00175
R1274 IOVDD.n573 IOVDD.n1 0.00173951
R1275 IOVDD.n321 IOVDD.n296 0.00170834
R1276 IOVDD.n266 IOVDD.n74 0.00168919
R1277 IOVDD.n564 IOVDD.n288 0.00166667
R1278 IOVDD.n102 IOVDD.n101 0.00166667
R1279 IOVDD.n111 IOVDD.n105 0.00162821
R1280 IOVDD.n215 IOVDD.n214 0.00162821
R1281 IOVDD.n493 IOVDD.t14 0.00162502
R1282 IOVDD.n567 IOVDD.n280 0.00160001
R1283 IOVDD.n277 IOVDD.n3 0.00155308
R1284 IOVDD.n128 IOVDD.n125 0.00148988
R1285 IOVDD.n398 IOVDD.n397 0.00148534
R1286 IOVDD.n400 IOVDD.n345 0.00148534
R1287 IOVDD.n399 IOVDD.n344 0.00148534
R1288 IOVDD.n177 IOVDD.n130 0.00145135
R1289 IOVDD.n268 IOVDD.n267 0.00145135
R1290 IOVDD.n225 IOVDD.n219 0.00141286
R1291 IOVDD.n568 IOVDD.n567 0.00139998
R1292 IOVDD.t18 IOVDD.n493 0.00137495
R1293 IOVDD.n85 IOVDD.n84 0.00136912
R1294 IOVDD.n84 IOVDD.n22 0.00136912
R1295 IOVDD.n88 IOVDD.n87 0.00134615
R1296 IOVDD.n104 IOVDD.n103 0.00134615
R1297 IOVDD.n288 IOVDD.n282 0.00133332
R1298 IOVDD.n210 IOVDD.n102 0.00133332
R1299 IOVDD.n495 IOVDD.n321 0.00129162
R1300 IOVDD.n127 IOVDD.n126 0.0012715
R1301 IOVDD.n510 IOVDD.t33 0.00124999
R1302 IOVDD.n355 IOVDD.n296 0.00124998
R1303 IOVDD.n477 IOVDD.n311 0.00124998
R1304 IOVDD.n365 IOVDD.n364 0.00121661
R1305 IOVDD.t31 IOVDD.n295 0.00120353
R1306 IOVDD.n483 IOVDD.t16 0.00119996
R1307 IOVDD.n484 IOVDD.t0 0.00116661
R1308 IOVDD.n86 IOVDD.n85 0.00110403
R1309 IOVDD.n130 IOVDD.n129 0.00109459
R1310 IOVDD.n269 IOVDD.n44 0.0010937
R1311 IOVDD.n172 IOVDD.n81 0.00108937
R1312 IOVDD.n573 IOVDD.n279 0.00106076
R1313 IOVDD.n278 IOVDD.n277 0.00104786
R1314 IOVDD.n240 IOVDD.n239 0.00103691
R1315 IOVDD.n127 IOVDD.n24 0.00103691
R1316 IOVDD.n207 IOVDD.n23 0.00103691
R1317 IOVDD.n87 IOVDD.n86 0.00103691
R1318 IOVDD.n363 IOVDD.n311 0.001
R1319 IOVDD.n482 IOVDD.n362 0.001
R1320 IOVDD.n480 IOVDD.n479 0.001
R1321 IOVDD.n459 IOVDD.n458 0.001
R1322 IOVDD.n460 IOVDD.n456 0.001
R1323 IOVDD.n461 IOVDD.n454 0.001
R1324 IOVDD.n496 IOVDD.n311 0.001
R1325 IOVDD.t114 IOVDD.n396 0.001
R1326 IOVDD.t90 IOVDD.n392 0.001
R1327 IOVDD.n429 IOVDD.n392 0.001
R1328 IOVDD.n413 IOVDD.n396 0.001
R1329 IOVDD.n568 IOVDD.n284 0.001
R1330 IOVDD.n294 IOVDD.n287 0.001
R1331 IOVDD.n566 IOVDD.n565 0.001
R1332 IOVDD.t14 IOVDD.n492 0.001
R1333 IOVDD.t0 IOVDD.n350 0.001
R1334 IOVDD.n361 IOVDD.t87 0.001
R1335 IOVDD.t11 IOVDD.n360 0.001
R1336 IOVDD.n457 IOVDD.n354 0.001
R1337 IOVDD.t26 IOVDD.n359 0.001
R1338 IOVDD.n455 IOVDD.t20 0.001
R1339 IOVDD.n453 IOVDD.t154 0.001
R1340 IOVDD.n451 IOVDD.n450 0.001
R1341 IOVDD.n496 IOVDD.n495 0.001
R1342 IOVDD.n461 IOVDD.n452 0.001
R1343 IOVDD.n460 IOVDD.n454 0.001
R1344 IOVDD.n459 IOVDD.n456 0.001
R1345 IOVDD.n479 IOVDD.n458 0.001
R1346 IOVDD.n480 IOVDD.n362 0.001
R1347 IOVDD.n482 IOVDD.n363 0.001
R1348 IOVDD.n451 IOVDD.t154 0.001
R1349 IOVDD.n453 IOVDD.t20 0.001
R1350 IOVDD.n455 IOVDD.t26 0.001
R1351 IOVDD.n457 IOVDD.t11 0.001
R1352 IOVDD.t16 IOVDD.n361 0.001
R1353 IOVDD.n350 IOVDD.t25 0.001
R1354 IOVDD.n492 IOVDD.t25 0.001
R1355 IOVDD.n359 IOVDD.n354 0.001
R1356 IOVDD.n360 IOVDD.t87 0.001
R1357 IOVDD.n559 IOVDD.n303 0.001
R1358 IOVDD.n298 IOVDD.n297 0.001
R1359 IOVDD.n300 IOVDD.n299 0.001
R1360 IOVDD.n301 IOVDD.n293 0.001
R1361 IOVDD.n560 IOVDD.n290 0.001
R1362 IOVDD.n563 IOVDD.n289 0.001
R1363 IOVDD.n560 IOVDD.n293 0.001
R1364 IOVDD.n301 IOVDD.n300 0.001
R1365 IOVDD.n299 IOVDD.n298 0.001
R1366 IOVDD.n303 IOVDD.n297 0.001
R1367 IOVDD.n285 IOVDD.n280 0.001
R1368 IOVDD.n286 IOVDD.n281 0.001
R1369 IOVDD.n564 IOVDD.n563 0.001
R1370 IOVDD.n565 IOVDD.n287 0.001
R1371 IOVDD.n290 IOVDD.n289 0.001
R1372 IOVDD.t31 IOVDD.n294 0.001
R1373 IOVDD.n559 IOVDD.n284 0.001
R1374 IOVDD.n286 IOVDD.n282 0.001
R1375 IOVDD.n285 IOVDD.n281 0.001
R1376 IOVDD.n81 IOVDD.n54 0.001
R1377 IOVDD.n98 IOVDD.t28 0.001
R1378 IOVDD.n269 IOVDD.n25 0.001
R1379 IOVDD.n269 IOVDD.n54 0.001
R1380 IOVDD.n81 IOVDD.n25 0.001
R1381 IOVDD.n209 IOVDD.n81 0.001
R1382 IOVDD.n101 IOVDD.n100 0.001
R1383 IOVDD.n99 IOVDD.n55 0.001
R1384 IOVDD.n269 IOVDD.n55 0.001
R1385 IOVDD.n100 IOVDD.n99 0.001
R1386 IOVDD.n98 IOVDD.t3 0.001
R1387 IOVDD.n210 IOVDD.n209 0.001
R1388 IOVDD.n105 IOVDD.n93 0.000923077
R1389 IOVDD.n213 IOVDD.n212 0.000923077
R1390 IOVDD.n337 IOVDD.n330 0.000858306
R1391 IOVDD.n253 IOVDD 0.000768456
R1392 IOVDD.n124 IOVDD.n24 0.000768456
R1393 IOVDD.n178 IOVDD.n177 0.000737838
R1394 IOVDD.n251 IOVDD.n58 0.000737838
R1395 IOVDD.n249 IOVDD.n74 0.000737838
R1396 IOVDD.n247 IOVDD.n75 0.000737838
R1397 IOVDD.n268 IOVDD.n76 0.000737838
R1398 IOVDD.n208 IOVDD.n207 0.000701342
R1399 IOVDD.n197 IOVDD.n196 0.000618919
R1400 IOVDD.n270 IOVDD.n5 0.000618919
R1401 IOVDD.n403 IOVDD.n400 0.000589576
R1402 IOVDD.n336 IOVDD.n335 0.000589576
R1403 VSS.n3187 VSS.n412 6.2022e+06
R1404 VSS.t465 VSS.t541 4.1553e+06
R1405 VSS.t168 VSS.t497 4.02485e+06
R1406 VSS.n2074 VSS.n2073 3.1068e+06
R1407 VSS.n2038 VSS.n2035 1.20431e+06
R1408 VSS.n3407 VSS.n3406 514200
R1409 VSS.n3189 VSS.n413 513600
R1410 VSS.n3190 VSS.n412 508946
R1411 VSS.n3188 VSS.n3186 352896
R1412 VSS.n3407 VSS.n3405 320659
R1413 VSS.n3182 VSS.n409 136017
R1414 VSS.n3581 VSS.n167 136017
R1415 VSS.n3189 VSS.n3188 67697.4
R1416 VSS.n3408 VSS.n3407 56131.6
R1417 VSS.n3190 VSS.n3189 53631.6
R1418 VSS.n3439 VSS.t611 44553.2
R1419 VSS.n2075 VSS.t252 43259.1
R1420 VSS.t55 VSS.n167 43200
R1421 VSS.t640 VSS.n408 38425.5
R1422 VSS.t247 VSS.n409 36800
R1423 VSS.n2127 VSS.n2076 21553.8
R1424 VSS.n2073 VSS.n412 20249.7
R1425 VSS.n3188 VSS.t894 16131.6
R1426 VSS.t252 VSS.n2074 15269
R1427 VSS.t247 VSS.n408 14042.6
R1428 VSS.n3439 VSS.t55 14042.6
R1429 VSS.n2580 VSS.n2579 12185.3
R1430 VSS.t458 VSS.t91 11621.2
R1431 VSS.t41 VSS.t388 11621.2
R1432 VSS.t894 VSS.n3187 9710.53
R1433 VSS.t388 VSS.n317 9649.3
R1434 VSS.n2902 VSS.t458 9072.14
R1435 VSS.n1073 VSS.n1072 8102.75
R1436 VSS.n3186 VSS.n3185 7998.76
R1437 VSS.n3186 VSS.t907 7718.56
R1438 VSS.n2438 VSS.n1432 7570.59
R1439 VSS.n2075 VSS.n2073 5998.2
R1440 VSS.n3381 VSS.n3380 4697.5
R1441 VSS.n2608 VSS.n602 4697.5
R1442 VSS.n3096 VSS.n3095 4694.12
R1443 VSS.n3354 VSS.n3353 4694.12
R1444 VSS.n3184 VSS.n414 4538.68
R1445 VSS.n3404 VSS.n3403 4535.29
R1446 VSS.n3406 VSS.t41 4436.87
R1447 VSS.t91 VSS.n413 4430.86
R1448 VSS.n306 VSS.n305 3776.47
R1449 VSS.t86 VSS.n2494 3635.29
R1450 VSS.n2494 VSS.n1349 3282.35
R1451 VSS.t778 VSS.t834 2944.44
R1452 VSS.n3413 VSS.n407 2929.41
R1453 VSS.n1067 VSS.n1066 2858.82
R1454 VSS.n1039 VSS.n1038 2858.82
R1455 VSS.n3125 VSS.n3124 2858.82
R1456 VSS.n3246 VSS.n3244 2858.82
R1457 VSS.n2245 VSS.t778 2761.11
R1458 VSS.n3408 VSS.n3190 2500
R1459 VSS.t1003 VSS.t64 2382.35
R1460 VSS.t58 VSS.t1003 2382.35
R1461 VSS.t1006 VSS.t58 2382.35
R1462 VSS.t890 VSS.t1006 2382.35
R1463 VSS.t381 VSS.t890 2382.35
R1464 VSS.t918 VSS.t1 2382.35
R1465 VSS.t1 VSS.t470 2382.35
R1466 VSS.t541 VSS.n3184 2382.35
R1467 VSS.t640 VSS.n407 2382.35
R1468 VSS.n305 VSS.t611 2382.35
R1469 VSS.t497 VSS.n3404 2382.35
R1470 VSS.n3411 VSS.n3408 2382.21
R1471 VSS.t541 VSS.t330 2325.58
R1472 VSS.t330 VSS.t332 2325.58
R1473 VSS.t332 VSS.t305 2325.58
R1474 VSS.t305 VSS.t319 2325.58
R1475 VSS.t319 VSS.t640 2325.58
R1476 VSS.t937 VSS.t611 2325.58
R1477 VSS.t951 VSS.t937 2325.58
R1478 VSS.t976 VSS.t951 2325.58
R1479 VSS.t960 VSS.t976 2325.58
R1480 VSS.t497 VSS.t960 2325.58
R1481 VSS.n2881 VSS.t1048 2283.02
R1482 VSS.n1060 VSS.t110 2241.18
R1483 VSS.t258 VSS.n1047 2241.18
R1484 VSS.n2891 VSS.t60 1981.13
R1485 VSS.n2243 VSS.t880 1941.67
R1486 VSS.t64 VSS.n2438 1941.18
R1487 VSS.t470 VSS.n1349 1941.18
R1488 VSS.n3413 VSS.t247 1941.18
R1489 VSS.t55 VSS.n306 1941.18
R1490 VSS.t898 VSS.n1577 1887.1
R1491 VSS.t898 VSS.n1619 1882.54
R1492 VSS.t247 VSS.t4 1875
R1493 VSS.t4 VSS.t85 1875
R1494 VSS.t63 VSS.t73 1875
R1495 VSS.t55 VSS.t73 1875
R1496 VSS.n1072 VSS.t89 1861.76
R1497 VSS.n1067 VSS.t89 1861.76
R1498 VSS.n1066 VSS.t163 1861.76
R1499 VSS.n1061 VSS.t163 1861.76
R1500 VSS.n1044 VSS.t913 1861.76
R1501 VSS.n1039 VSS.t913 1861.76
R1502 VSS.n1038 VSS.t1023 1861.76
R1503 VSS.n2579 VSS.t1023 1861.76
R1504 VSS.t1025 VSS.n2608 1861.76
R1505 VSS.n3125 VSS.t1025 1861.76
R1506 VSS.n3124 VSS.t277 1861.76
R1507 VSS.n3095 VSS.t277 1861.76
R1508 VSS.n3380 VSS.t24 1861.76
R1509 VSS.n3244 VSS.t24 1861.76
R1510 VSS.t1030 VSS.n3246 1861.76
R1511 VSS.n3354 VSS.t1030 1861.76
R1512 VSS.t880 VSS.n1600 1841.67
R1513 VSS.n2246 VSS.t518 1837.17
R1514 VSS.n2434 VSS.n2417 1712.8
R1515 VSS.t405 VSS.n2338 1667.65
R1516 VSS.t141 VSS.n1432 1667.65
R1517 VSS.t115 VSS.t110 1658.82
R1518 VSS.t121 VSS.t115 1658.82
R1519 VSS.t116 VSS.t103 1658.82
R1520 VSS.t103 VSS.t258 1658.82
R1521 VSS.n1539 VSS.n1538 1644.61
R1522 VSS.n2439 VSS.t918 1500
R1523 VSS.n1047 VSS.n1044 1394.12
R1524 VSS.n2902 VSS.t1018 1322.65
R1525 VSS.t455 VSS.n317 1322.65
R1526 VSS.t212 VSS.n2033 1266.67
R1527 VSS.n1061 VSS.n1060 1217.65
R1528 VSS.t86 VSS.t26 1103.49
R1529 VSS.t26 VSS.t251 1103.49
R1530 VSS.t251 VSS.t6 1103.49
R1531 VSS.t6 VSS.t96 1103.49
R1532 VSS.t85 VSS.n3411 1022.69
R1533 VSS.n3440 VSS.n3439 1010.23
R1534 VSS.n408 VSS.n403 973.672
R1535 VSS.n3411 VSS.t63 951.422
R1536 VSS.t834 VSS.n2244 916.668
R1537 VSS.t288 VSS.t285 900
R1538 VSS.t276 VSS.t262 900
R1539 VSS.n2439 VSS.t381 882.354
R1540 VSS.t60 VSS.t195 880.504
R1541 VSS.t1048 VSS.t915 880.504
R1542 VSS.n3159 VSS.n561 875.48
R1543 VSS.t255 VSS.n995 855.539
R1544 VSS.n1052 VSS.t256 853.101
R1545 VSS.n892 VSS.n891 835.987
R1546 VSS.n3480 VSS.n273 822.311
R1547 VSS.n2325 VSS.n2312 815.024
R1548 VSS.n2447 VSS.n1348 776.078
R1549 VSS.n2471 VSS.n2452 713.38
R1550 VSS.n1051 VSS.n1002 697.059
R1551 VSS.t96 VSS.n1073 695.196
R1552 VSS.n2144 VSS.t212 675
R1553 VSS.n2304 VSS.n1559 662.836
R1554 VSS.n3051 VSS.n3050 636.015
R1555 VSS.n2580 VSS.n668 616.534
R1556 VSS.n3096 VSS.n2687 616.534
R1557 VSS.n3403 VSS.n3193 616.534
R1558 VSS.n3353 VSS.n3248 616.534
R1559 VSS.n2145 VSS.n2144 591.668
R1560 VSS.n1049 VSS.t112 589.619
R1561 VSS.t198 VSS.t79 563.283
R1562 VSS.t79 VSS.t888 563.283
R1563 VSS.t888 VSS.t48 563.283
R1564 VSS.t48 VSS.t445 563.283
R1565 VSS.t445 VSS.t396 563.283
R1566 VSS.t440 VSS.t190 563.283
R1567 VSS.t50 VSS.t440 563.283
R1568 VSS.n3469 VSS.n3442 559.721
R1569 VSS.n1004 VSS.t121 554.324
R1570 VSS.n2242 VSS.t898 546.894
R1571 VSS.t293 VSS.n667 538.236
R1572 VSS.t279 VSS.n665 538.236
R1573 VSS.n658 VSS.t289 538.236
R1574 VSS.n656 VSS.t281 538.236
R1575 VSS.t275 VSS.n2686 538.236
R1576 VSS.t269 VSS.n2684 538.236
R1577 VSS.n2681 VSS.t270 538.236
R1578 VSS.n2679 VSS.t264 538.236
R1579 VSS.n3400 VSS.t15 538.236
R1580 VSS.t21 VSS.n3395 538.236
R1581 VSS.n3389 VSS.t22 538.236
R1582 VSS.n3385 VSS.t13 538.236
R1583 VSS.t182 VSS.n3258 538.236
R1584 VSS.t176 VSS.n3256 538.236
R1585 VSS.t172 VSS.n3253 538.236
R1586 VSS.n1004 VSS.t108 536.678
R1587 VSS.t106 VSS.n1049 501.384
R1588 VSS.n2495 VSS.n1348 484.007
R1589 VSS.n2434 VSS.t198 458.971
R1590 VSS.n2447 VSS.t50 458.971
R1591 VSS.n1048 VSS.t116 448.887
R1592 VSS.n413 VSS.t189 446.541
R1593 VSS.n3185 VSS.t908 443.397
R1594 VSS.n3405 VSS.t925 443.397
R1595 VSS.n3187 VSS.t897 443.397
R1596 VSS.n2074 VSS.t45 443.397
R1597 VSS.n3406 VSS.t8 443.397
R1598 VSS.n3185 VSS.t131 437.108
R1599 VSS.n3405 VSS.t391 437.108
R1600 VSS.n3187 VSS.t147 437.108
R1601 VSS.n2074 VSS.t152 437.108
R1602 VSS.n3406 VSS.t133 437.108
R1603 VSS.n3040 VSS.n2928 434.793
R1604 VSS.n413 VSS.t1072 433.962
R1605 VSS.t256 VSS.t253 412.399
R1606 VSS.t253 VSS.t254 412.399
R1607 VSS.t257 VSS.t255 412.399
R1608 VSS.n1051 VSS.t257 396.226
R1609 VSS.n1003 VSS.t113 395.945
R1610 VSS.t184 VSS.n3250 376.209
R1611 VSS.n2495 VSS.t86 375.522
R1612 VSS.n667 VSS.t283 361.765
R1613 VSS.t292 VSS.n658 361.765
R1614 VSS.t287 VSS.n656 361.765
R1615 VSS.n2686 VSS.t272 361.765
R1616 VSS.n2684 VSS.t266 361.765
R1617 VSS.t274 VSS.n2681 361.765
R1618 VSS.t268 VSS.n2679 361.765
R1619 VSS.n3400 VSS.t23 361.765
R1620 VSS.n3395 VSS.t17 361.765
R1621 VSS.t9 VSS.n3389 361.765
R1622 VSS.t20 VSS.n3385 361.765
R1623 VSS.t178 VSS.n3258 361.765
R1624 VSS.t170 VSS.n3256 361.765
R1625 VSS.t177 VSS.n3253 361.765
R1626 VSS.t190 VSS.n2439 354.659
R1627 VSS.t922 VSS.t168 341.88
R1628 VSS.n2511 VSS.n1138 337.238
R1629 VSS.t431 VSS.t405 300
R1630 VSS.t924 VSS.t469 300
R1631 VSS.t136 VSS.t0 300
R1632 VSS.t473 VSS.t95 300
R1633 VSS.t385 VSS.t141 300
R1634 VSS.t468 VSS.t465 298.401
R1635 VSS.n2143 VSS.n1574 296.024
R1636 VSS.n2090 VSS.n2089 286.135
R1637 VSS.n2142 VSS.n2141 282.43
R1638 VSS.n2070 VSS.n2069 281.825
R1639 VSS.t241 VSS.n2036 265.598
R1640 VSS.n2243 VSS.n1558 258.036
R1641 VSS.t283 VSS.n666 254.325
R1642 VSS.t291 VSS.n662 254.325
R1643 VSS.n659 VSS.t292 254.325
R1644 VSS.n657 VSS.t287 254.325
R1645 VSS.t272 VSS.n2685 254.325
R1646 VSS.t266 VSS.n2683 254.325
R1647 VSS.n2682 VSS.t274 254.325
R1648 VSS.n2680 VSS.t268 254.325
R1649 VSS.t23 VSS.n3397 254.325
R1650 VSS.t17 VSS.n3393 254.325
R1651 VSS.n3391 VSS.t9 254.325
R1652 VSS.n3387 VSS.t20 254.325
R1653 VSS.t178 VSS.n3257 254.325
R1654 VSS.t170 VSS.n3255 254.325
R1655 VSS.t177 VSS.n3254 254.325
R1656 VSS.t184 VSS.n3252 254.325
R1657 VSS.n2882 VSS.n2880 228.506
R1658 VSS.n2882 VSS.n2881 228.506
R1659 VSS.n2144 VSS.n2143 221.267
R1660 VSS.t113 VSS.n1002 220.589
R1661 VSS.n2305 VSS.n1558 214.024
R1662 VSS.n2439 VSS.t396 208.624
R1663 VSS.n2036 VSS.n1988 204.488
R1664 VSS.n2145 VSS.n1988 200
R1665 VSS.n2033 VSS.n1600 200
R1666 VSS.n2127 VSS.n2126 195.477
R1667 VSS.n859 VSS.t31 183.805
R1668 VSS.t518 VSS.n2245 183.333
R1669 VSS.n3405 VSS.t922 183.15
R1670 VSS.n2030 VSS.n2029 182.393
R1671 VSS.n2128 VSS.n2127 170.954
R1672 VSS.n2024 VSS.n2023 167.933
R1673 VSS.n2026 VSS.n2025 167.933
R1674 VSS.n2028 VSS.n2027 167.933
R1675 VSS.t903 VSS.n2889 161.589
R1676 VSS.n2888 VSS.t185 161.587
R1677 VSS.t156 VSS.n1370 160.632
R1678 VSS.n3185 VSS.t468 159.858
R1679 VSS.n2064 VSS.n2038 156.847
R1680 VSS.n2890 VSS.t1018 156.114
R1681 VSS.n2887 VSS.t455 156.113
R1682 VSS.n2076 VSS.n2075 148.595
R1683 VSS.t1047 VSS.n411 147.553
R1684 VSS.n2471 VSS.n855 145.493
R1685 VSS.n1538 VSS.n1405 145.308
R1686 VSS.n3050 VSS.n2726 145.308
R1687 VSS.n3051 VSS.n2757 145.306
R1688 VSS.n3480 VSS.n20 145.306
R1689 VSS.t212 VSS.n2034 144.786
R1690 VSS.t514 VSS.n11 141.65
R1691 VSS.n3063 VSS.t489 141.641
R1692 VSS.n20 VSS.t522 141.476
R1693 VSS.t538 VSS.n2726 141.476
R1694 VSS.n3618 VSS.n30 138.921
R1695 VSS.n3075 VSS.n2695 137.931
R1696 VSS.n856 VSS.t82 137.829
R1697 VSS.t167 VSS.n860 137.828
R1698 VSS.n1050 VSS.t106 130.796
R1699 VSS.n891 VSS.n867 130.268
R1700 VSS.n818 VSS.n817 130.268
R1701 VSS.n817 VSS.n561 130.268
R1702 VSS.n3159 VSS.n568 130.268
R1703 VSS.n2694 VSS.n481 130.268
R1704 VSS.n2695 VSS.n2694 130.268
R1705 VSS.n2589 VSS.n524 126.438
R1706 VSS.n2588 VSS.n523 126.438
R1707 VSS.n2591 VSS.n522 126.438
R1708 VSS.n2615 VSS.n513 126.438
R1709 VSS.n2616 VSS.n512 126.438
R1710 VSS.n2617 VSS.n511 126.438
R1711 VSS.n3201 VSS.n3200 126.438
R1712 VSS.n3203 VSS.n3202 126.438
R1713 VSS.n3205 VSS.n3204 126.438
R1714 VSS.n3243 VSS.n3231 126.438
R1715 VSS.n3238 VSS.n3237 126.438
R1716 VSS.n3240 VSS.n3239 126.438
R1717 VSS.t134 VSS.n1372 126.314
R1718 VSS.n1370 VSS.t443 126.15
R1719 VSS.t395 VSS.n2745 122.724
R1720 VSS.n907 VSS.n751 122.606
R1721 VSS.n910 VSS.n730 122.606
R1722 VSS.n911 VSS.n753 122.606
R1723 VSS.n962 VSS.n774 122.606
R1724 VSS.n1016 VSS.n687 122.606
R1725 VSS.n1020 VSS.n795 122.606
R1726 VSS.n1022 VSS.n685 122.606
R1727 VSS.n1368 VSS.t429 122.484
R1728 VSS.t139 VSS.n1374 122.483
R1729 VSS.t188 VSS.n2745 122.361
R1730 VSS.n2088 VSS.t36 120.903
R1731 VSS.n893 VSS.n738 118.775
R1732 VSS.n895 VSS.n743 118.775
R1733 VSS.n896 VSS.n736 118.775
R1734 VSS.n1031 VSS.n804 118.775
R1735 VSS.n1030 VSS.n680 118.775
R1736 VSS.n805 VSS.n671 118.775
R1737 VSS.n1359 VSS.t144 118.653
R1738 VSS.t150 VSS.n2746 118.653
R1739 VSS.t926 VSS.n2755 118.653
R1740 VSS.n2740 VSS.t323 118.653
R1741 VSS.n17 VSS.t945 118.653
R1742 VSS.t42 VSS.n1401 118.651
R1743 VSS.t311 VSS.n2738 118.651
R1744 VSS.t932 VSS.n15 118.651
R1745 VSS.n2020 VSS.n2019 116.698
R1746 VSS.t53 VSS.n410 115.228
R1747 VSS.n1352 VSS.t70 114.822
R1748 VSS.n2747 VSS.t124 114.822
R1749 VSS.t153 VSS.n2756 114.822
R1750 VSS.t38 VSS.n1402 114.82
R1751 VSS.t277 VSS.n514 113.028
R1752 VSS.n3214 VSS.t24 113.028
R1753 VSS.n884 VSS.t485 111.112
R1754 VSS.t508 VSS.n820 111.112
R1755 VSS.n556 VSS.t697 111.112
R1756 VSS.t712 VSS.n483 111.112
R1757 VSS.n3606 VSS.t687 111.112
R1758 VSS.n2511 VSS.n1132 109.984
R1759 VSS.t163 VSS.n728 109.195
R1760 VSS.n3220 VSS.n3219 107.626
R1761 VSS.n3222 VSS.n3220 107.626
R1762 VSS.t89 VSS.n745 105.365
R1763 VSS.n631 VSS.n538 103.448
R1764 VSS.n624 VSS.n536 103.448
R1765 VSS.n623 VSS.n535 103.448
R1766 VSS.n617 VSS.n533 103.448
R1767 VSS.n611 VSS.n532 103.448
R1768 VSS.n610 VSS.n531 103.448
R1769 VSS.n606 VSS.n530 103.448
R1770 VSS.n605 VSS.n529 103.448
R1771 VSS.n2626 VSS.n506 103.448
R1772 VSS.n2678 VSS.n505 103.448
R1773 VSS.n2675 VSS.n504 103.448
R1774 VSS.n2674 VSS.n503 103.448
R1775 VSS.n2668 VSS.n502 103.448
R1776 VSS.n2661 VSS.n500 103.448
R1777 VSS.n2660 VSS.n499 103.448
R1778 VSS.n2654 VSS.n497 103.448
R1779 VSS.n85 VSS.n53 103.448
R1780 VSS.n3388 VSS.n55 103.448
R1781 VSS.n81 VSS.n80 103.448
R1782 VSS.n3384 VSS.n75 103.448
R1783 VSS.n68 VSS.n59 103.448
R1784 VSS.n70 VSS.n69 103.448
R1785 VSS.n3196 VSS.n61 103.448
R1786 VSS.n3198 VSS.n3197 103.448
R1787 VSS.n3345 VSS.n3305 103.448
R1788 VSS.n3344 VSS.n3343 103.448
R1789 VSS.n3342 VSS.n3341 103.448
R1790 VSS.n3340 VSS.n3339 103.448
R1791 VSS.n3338 VSS.n3337 103.448
R1792 VSS.n3334 VSS.n3333 103.448
R1793 VSS.n3332 VSS.n3331 103.448
R1794 VSS.n3328 VSS.n3327 103.448
R1795 VSS.n860 VSS.t7 103.347
R1796 VSS.t54 VSS.n856 103.347
R1797 VSS.n2022 VSS.t209 102.697
R1798 VSS.n3408 VSS.n411 101.463
R1799 VSS.n2244 VSS.n2242 99.9706
R1800 VSS.n2309 VSS.t434 99.966
R1801 VSS.t436 VSS.n2309 99.965
R1802 VSS.n2596 VSS.n521 99.6174
R1803 VSS.n2597 VSS.n520 99.6174
R1804 VSS.n2602 VSS.n519 99.6174
R1805 VSS.n2604 VSS.n2603 99.6174
R1806 VSS.n2610 VSS.n2609 99.6174
R1807 VSS.n2612 VSS.n516 99.6174
R1808 VSS.n2613 VSS.n515 99.6174
R1809 VSS.n3216 VSS.n3215 99.6174
R1810 VSS.n3218 VSS.n3217 99.6174
R1811 VSS.n3221 VSS.n3213 99.6174
R1812 VSS.n3225 VSS.n3224 99.6174
R1813 VSS.n3230 VSS.n3229 99.6174
R1814 VSS.t108 VSS.n1003 95.9444
R1815 VSS.n916 VSS.n755 95.7859
R1816 VSS.n920 VSS.n726 95.7859
R1817 VSS.n921 VSS.n756 95.7859
R1818 VSS.n1007 VSS.n1006 95.7859
R1819 VSS.n1011 VSS.n791 95.7859
R1820 VSS.n1012 VSS.n689 95.7859
R1821 VSS.n1015 VSS.n793 95.7859
R1822 VSS.n2738 VSS.t307 95.6639
R1823 VSS.n15 VSS.t935 95.6639
R1824 VSS.t327 VSS.n2740 95.6629
R1825 VSS.t929 VSS.n17 95.6629
R1826 VSS.t469 VSS.n1545 95.4545
R1827 VSS.n2306 VSS.n2305 94.2179
R1828 VSS.n1330 VSS.t923 92.7405
R1829 VSS.n3199 VSS.t97 92.3054
R1830 VSS.n2312 VSS.t532 92.3022
R1831 VSS.t624 VSS.n2306 92.3022
R1832 VSS.t100 VSS.n3304 92.3019
R1833 VSS.n2089 VSS.n2088 92.1568
R1834 VSS.n900 VSS.n734 91.9545
R1835 VSS.n903 VSS.n747 91.9545
R1836 VSS.n904 VSS.n733 91.9545
R1837 VSS.n991 VSS.n758 91.9545
R1838 VSS.n990 VSS.n760 91.9545
R1839 VSS.n987 VSS.n720 91.9545
R1840 VSS.n986 VSS.n762 91.9545
R1841 VSS.n983 VSS.n718 91.9545
R1842 VSS.n979 VSS.n716 91.9545
R1843 VSS.n978 VSS.n766 91.9545
R1844 VSS.n974 VSS.n768 91.9545
R1845 VSS.n971 VSS.n712 91.9545
R1846 VSS.n967 VSS.n710 91.9545
R1847 VSS.n966 VSS.n772 91.9545
R1848 VSS.n963 VSS.n708 91.9545
R1849 VSS.n1024 VSS.n800 91.9545
R1850 VSS.n1026 VSS.n683 91.9545
R1851 VSS.n1033 VSS.n802 91.9545
R1852 VSS.n1028 VSS.n681 91.9545
R1853 VSS.n2083 VSS.n2076 90.657
R1854 VSS.n1277 VSS.n1184 89.9302
R1855 VSS.n1276 VSS.n1187 89.9302
R1856 VSS.n1275 VSS.n1190 89.9302
R1857 VSS.n1274 VSS.n1194 89.9302
R1858 VSS.n1273 VSS.n1196 89.9302
R1859 VSS.n1272 VSS.n1199 89.9302
R1860 VSS.n1271 VSS.n1202 89.9302
R1861 VSS.n1270 VSS.n1205 89.9302
R1862 VSS.n1268 VSS.n1211 89.9302
R1863 VSS.n1267 VSS.n1214 89.9302
R1864 VSS.n1266 VSS.n1218 89.9302
R1865 VSS.n1265 VSS.n1221 89.9302
R1866 VSS.n1264 VSS.n1224 89.9302
R1867 VSS.n1263 VSS.n1227 89.9302
R1868 VSS.n1262 VSS.n1231 89.9302
R1869 VSS.n1261 VSS.n1234 89.9302
R1870 VSS.n1260 VSS.n1237 89.9302
R1871 VSS.n1257 VSS.n1238 89.9302
R1872 VSS.n3180 VSS.n430 88.9281
R1873 VSS.n3469 VSS.n242 88.9281
R1874 VSS.n665 VSS.n664 88.2358
R1875 VSS.t118 VSS.n770 88.1231
R1876 VSS.t252 VSS.t102 87.0742
R1877 VSS.n2244 VSS.n2243 86.1116
R1878 VSS.t447 VSS.n722 84.2917
R1879 VSS.n575 VSS.t300 84.2917
R1880 VSS.n582 VSS.t303 84.2917
R1881 VSS.n2019 VSS.n1887 82.5178
R1882 VSS.t0 VSS.n1546 82.4628
R1883 VSS.t281 VSS.n602 78.3124
R1884 VSS.t264 VSS.n414 78.3124
R1885 VSS.t13 VSS.n3381 78.3115
R1886 VSS.n668 VSS.t293 78.2973
R1887 VSS.n2687 VSS.t275 78.2973
R1888 VSS.t15 VSS.n3193 78.2973
R1889 VSS.t182 VSS.n3248 78.2973
R1890 VSS.n666 VSS.t279 77.854
R1891 VSS.n662 VSS.t288 77.854
R1892 VSS.t285 VSS.n659 77.854
R1893 VSS.t289 VSS.n657 77.854
R1894 VSS.n2685 VSS.t269 77.854
R1895 VSS.n2683 VSS.t276 77.854
R1896 VSS.t262 VSS.n2682 77.854
R1897 VSS.t270 VSS.n2680 77.854
R1898 VSS.n3397 VSS.t21 77.854
R1899 VSS.n3393 VSS.t11 77.854
R1900 VSS.t19 VSS.n3391 77.854
R1901 VSS.t22 VSS.n3387 77.854
R1902 VSS.t176 VSS.n3257 77.854
R1903 VSS.t183 VSS.n3255 77.854
R1904 VSS.t180 VSS.n3254 77.854
R1905 VSS.t172 VSS.n3252 77.854
R1906 VSS.n1509 VSS.n1502 77.191
R1907 VSS.n2415 VSS.n1503 77.191
R1908 VSS.n1550 VSS.n1436 77.191
R1909 VSS.n2343 VSS.n1440 77.191
R1910 VSS.n2347 VSS.n1483 77.191
R1911 VSS.n2357 VSS.n1474 77.191
R1912 VSS.n2360 VSS.n1471 77.191
R1913 VSS.n2367 VSS.n1463 77.191
R1914 VSS.n2369 VSS.n1462 77.191
R1915 VSS.n2381 VSS.n1451 77.191
R1916 VSS.n2385 VSS.n1447 77.191
R1917 VSS.n2402 VSS.n1492 77.191
R1918 VSS.n2404 VSS.n1443 77.191
R1919 VSS.n2417 VSS.n1435 77.191
R1920 VSS.n2308 VSS.t402 76.9805
R1921 VSS.t206 VSS.n2310 76.9763
R1922 VSS.n2021 VSS.n2020 76.8506
R1923 VSS.n2037 VSS.t241 76.7094
R1924 VSS.n2245 VSS.n1559 76.6288
R1925 VSS.n955 VSS.n776 76.6288
R1926 VSS.n952 VSS.n704 76.6288
R1927 VSS.n951 VSS.n778 76.6288
R1928 VSS.n948 VSS.n702 76.6288
R1929 VSS.n947 VSS.n780 76.6288
R1930 VSS.n944 VSS.n700 76.6288
R1931 VSS.n943 VSS.n782 76.6288
R1932 VSS.n939 VSS.n784 76.6288
R1933 VSS.n936 VSS.n696 76.6288
R1934 VSS.n932 VSS.n694 76.6288
R1935 VSS.n931 VSS.n788 76.6288
R1936 VSS.n926 VSS.n925 76.6288
R1937 VSS.t35 VSS.t1058 75.8787
R1938 VSS.t85 VSS.n368 73.235
R1939 VSS.n2345 VSS.t1069 73.0186
R1940 VSS.n2383 VSS.t1071 73.0186
R1941 VSS.t63 VSS.n3409 71.8266
R1942 VSS.t212 VSS.n2032 71.3398
R1943 VSS.n2248 VSS 71.1852
R1944 VSS.t4 VSS.n377 70.6195
R1945 VSS.n355 VSS.t73 70.6195
R1946 VSS.t169 VSS.n1241 70.2581
R1947 VSS.n2311 VSS.t206 69.3177
R1948 VSS.t402 VSS.n2307 69.3134
R1949 VSS.t247 VSS.n386 68.004
R1950 VSS.t55 VSS.n307 68.004
R1951 VSS.n2134 VSS.t92 66.6017
R1952 VSS.t174 VSS.n3250 66.5313
R1953 VSS.n3307 VSS.n3306 66.2445
R1954 VSS.n2892 VSS.t1018 66.1409
R1955 VSS.n982 VSS.t107 65.1346
R1956 VSS.n940 VSS.t114 65.1346
R1957 VSS.n603 VSS.n553 65.1346
R1958 VSS.n603 VSS.n552 65.1346
R1959 VSS.n655 VSS.n552 65.1346
R1960 VSS.n655 VSS.n550 65.1346
R1961 VSS.n654 VSS.n550 65.1346
R1962 VSS.n654 VSS.n549 65.1346
R1963 VSS.n653 VSS.n549 65.1346
R1964 VSS.n652 VSS.n548 65.1346
R1965 VSS.n652 VSS.n547 65.1346
R1966 VSS.n651 VSS.n543 65.1346
R1967 VSS.n645 VSS.n543 65.1346
R1968 VSS.n644 VSS.n542 65.1346
R1969 VSS.n639 VSS.n540 65.1346
R1970 VSS.n638 VSS.n540 65.1346
R1971 VSS.n2647 VSS.n494 65.1346
R1972 VSS.n2646 VSS.n494 65.1346
R1973 VSS.n2640 VSS.n493 65.1346
R1974 VSS.n2640 VSS.n492 65.1346
R1975 VSS.n2639 VSS.n491 65.1346
R1976 VSS.n2634 VSS.n491 65.1346
R1977 VSS.n2633 VSS.n490 65.1346
R1978 VSS.n2633 VSS.n489 65.1346
R1979 VSS.n2631 VSS.n488 65.1346
R1980 VSS.n2630 VSS.n488 65.1346
R1981 VSS.n2630 VSS.n487 65.1346
R1982 VSS.n2629 VSS.n487 65.1346
R1983 VSS.n2629 VSS.n486 65.1346
R1984 VSS.n2628 VSS.n486 65.1346
R1985 VSS.n2628 VSS.n485 65.1346
R1986 VSS.n3605 VSS.n3604 65.1346
R1987 VSS.n3604 VSS.n3603 65.1346
R1988 VSS.n3603 VSS.n3602 65.1346
R1989 VSS.n3602 VSS.n45 65.1346
R1990 VSS.n46 VSS.n45 65.1346
R1991 VSS.n104 VSS.n46 65.1346
R1992 VSS.n105 VSS.n104 65.1346
R1993 VSS.n3398 VSS.n47 65.1346
R1994 VSS.n3399 VSS.n47 65.1346
R1995 VSS.n103 VSS.n102 65.1346
R1996 VSS.n102 VSS.n49 65.1346
R1997 VSS.n3396 VSS.n98 65.1346
R1998 VSS.n3394 VSS.n98 65.1346
R1999 VSS.n92 VSS.n51 65.1346
R2000 VSS.n93 VSS.n92 65.1346
R2001 VSS.n3325 VSS.n3324 65.1346
R2002 VSS.n3324 VSS.n3323 65.1346
R2003 VSS.n3322 VSS.n3321 65.1346
R2004 VSS.n3321 VSS.n3320 65.1346
R2005 VSS.n3319 VSS.n3318 65.1346
R2006 VSS.n3318 VSS.n3317 65.1346
R2007 VSS.n3316 VSS.n3315 65.1346
R2008 VSS.n3315 VSS.n3314 65.1346
R2009 VSS.n3313 VSS.n3312 65.1346
R2010 VSS.n3312 VSS.n3311 65.1346
R2011 VSS.n3311 VSS.n3310 65.1346
R2012 VSS.n3310 VSS.n3309 65.1346
R2013 VSS.n3309 VSS.n3308 65.1346
R2014 VSS.n3308 VSS.n3307 65.1346
R2015 VSS.n2741 VSS.t327 65.0298
R2016 VSS.n18 VSS.t929 65.0298
R2017 VSS.t307 VSS.n2737 65.0288
R2018 VSS.t935 VSS.n14 65.0288
R2019 VSS.n2415 VSS.n1502 64.6737
R2020 VSS.n1503 VSS.n1436 64.6737
R2021 VSS.n1550 VSS.n1498 64.6737
R2022 VSS.n1555 VSS.n1496 64.6737
R2023 VSS.n2339 VSS.n1440 64.6737
R2024 VSS.n2343 VSS.n1486 64.6737
R2025 VSS.n2345 VSS.n1483 64.6737
R2026 VSS.n2347 VSS.n1482 64.6737
R2027 VSS.n2353 VSS.n1475 64.6737
R2028 VSS.n2355 VSS.n1474 64.6737
R2029 VSS.n2357 VSS.n1471 64.6737
R2030 VSS.n2369 VSS.n1463 64.6737
R2031 VSS.n2371 VSS.n1462 64.6737
R2032 VSS.n2374 VSS.n1459 64.6737
R2033 VSS.n2381 VSS.n1454 64.6737
R2034 VSS.n2383 VSS.n1451 64.6737
R2035 VSS.n2385 VSS.n1450 64.6737
R2036 VSS.n2388 VSS.n1447 64.6737
R2037 VSS.n2392 VSS.n1445 64.6737
R2038 VSS.n2402 VSS.n1489 64.6737
R2039 VSS.n2404 VSS.n1492 64.6737
R2040 VSS.n1443 VSS.n1435 64.6737
R2041 VSS.t211 VSS.n1208 64.6375
R2042 VSS.t1036 VSS.n1090 64.6375
R2043 VSS.n3408 VSS.n410 63.787
R2044 VSS.n2038 VSS.n2037 62.8195
R2045 VSS.n1321 VSS.n1130 61.8272
R2046 VSS.n1340 VSS.n1129 61.8272
R2047 VSS.n1318 VSS.n1128 61.8272
R2048 VSS.n1339 VSS.n1127 61.8272
R2049 VSS.n1317 VSS.n1126 61.8272
R2050 VSS.n1338 VSS.n1123 61.8272
R2051 VSS.n1316 VSS.n1122 61.8272
R2052 VSS.n1337 VSS.n1121 61.8272
R2053 VSS.n1315 VSS.n1120 61.8272
R2054 VSS.n1336 VSS.n1117 61.8272
R2055 VSS.n1314 VSS.n1116 61.8272
R2056 VSS.n1313 VSS.n1114 61.8272
R2057 VSS.n1334 VSS.n1113 61.8272
R2058 VSS.n1312 VSS.n1112 61.8272
R2059 VSS.n1333 VSS.n1109 61.8272
R2060 VSS.n1311 VSS.n1108 61.8272
R2061 VSS.n1310 VSS.n1105 61.8272
R2062 VSS.n1331 VSS.n1104 61.8272
R2063 VSS.n1309 VSS.n1101 61.8272
R2064 VSS.n2141 VSS.n2140 61.1703
R2065 VSS.t887 VSS.n1107 59.0169
R2066 VSS.n2405 VSS 57.8
R2067 VSS.t111 VSS.n714 57.4718
R2068 VSS.t7 VSS.n859 57.37
R2069 VSS.n857 VSS.t54 57.369
R2070 VSS.t1027 VSS.n2087 56.8833
R2071 VSS.n2087 VSS.t1029 56.8833
R2072 VSS.n2495 VSS.n1131 56.2066
R2073 VSS.n2133 VSS.t46 55.5002
R2074 VSS.t192 VSS.n2134 55.392
R2075 VSS.t11 VSS.n3392 54.3988
R2076 VSS.n3326 VSS.t180 54.3988
R2077 VSS.t1064 VSS.n1479 54.2425
R2078 VSS.t1068 VSS.n1455 54.2425
R2079 VSS.n2307 VSS.t624 53.989
R2080 VSS.t532 VSS.n2311 53.9868
R2081 VSS.t5 VSS.n2135 53.8989
R2082 VSS.n2132 VSS.t132 53.8989
R2083 VSS.n956 VSS.n774 53.6403
R2084 VSS.n955 VSS.n706 53.6403
R2085 VSS.n952 VSS.n776 53.6403
R2086 VSS.n948 VSS.n778 53.6403
R2087 VSS.n947 VSS.n702 53.6403
R2088 VSS.n943 VSS.n700 53.6403
R2089 VSS.n940 VSS.n782 53.6403
R2090 VSS.n939 VSS.n698 53.6403
R2091 VSS.n936 VSS.n784 53.6403
R2092 VSS.n935 VSS.n696 53.6403
R2093 VSS.n932 VSS.n786 53.6403
R2094 VSS.n931 VSS.n694 53.6403
R2095 VSS.n928 VSS.n788 53.6403
R2096 VSS.n926 VSS.n692 53.6403
R2097 VSS.n2974 VSS.n2830 53.6186
R2098 VSS.n2969 VSS.n2829 53.6186
R2099 VSS.n2963 VSS.t673 53.6186
R2100 VSS.n2961 VSS.n2827 53.6186
R2101 VSS.n2957 VSS.t482 53.6186
R2102 VSS.n2955 VSS.n2834 53.6186
R2103 VSS.n2951 VSS.t590 53.6186
R2104 VSS.n2947 VSS.t423 53.6186
R2105 VSS.t423 VSS.n2946 53.6186
R2106 VSS.n2932 VSS.t857 53.6186
R2107 VSS.n2935 VSS.n2805 53.6186
R2108 VSS.n2936 VSS.t563 53.6186
R2109 VSS.n2938 VSS.n2838 53.6186
R2110 VSS.n2939 VSS.t743 53.6186
R2111 VSS.n3037 VSS.n2840 53.6186
R2112 VSS.n3039 VSS.n2802 53.6186
R2113 VSS.n3574 VSS.n3573 53.6186
R2114 VSS.n3501 VSS.n237 53.6186
R2115 VSS.t748 VSS.n231 53.6186
R2116 VSS.n3503 VSS.n229 53.6186
R2117 VSS.t569 VSS.n225 53.6186
R2118 VSS.n243 VSS.n223 53.6186
R2119 VSS.t657 VSS.n219 53.6186
R2120 VSS.n194 VSS.t411 53.6186
R2121 VSS.t411 VSS.n189 53.6186
R2122 VSS.n215 VSS.t659 53.6186
R2123 VSS.n211 VSS.n184 53.6186
R2124 VSS.n209 VSS.t630 53.6186
R2125 VSS.n205 VSS.n182 53.6186
R2126 VSS.n203 VSS.t843 53.6186
R2127 VSS.n197 VSS.n177 53.6186
R2128 VSS.t31 VSS.n857 53.5386
R2129 VSS.t47 VSS.n2136 52.2976
R2130 VSS.n2131 VSS.t74 52.2976
R2131 VSS.t185 VSS.n2887 52.0982
R2132 VSS.n2890 VSS.t903 52.0965
R2133 VSS.t293 VSS.n548 51.7246
R2134 VSS.t283 VSS.n651 51.7246
R2135 VSS.t279 VSS.n542 51.7246
R2136 VSS.t291 VSS.n639 51.7246
R2137 VSS.t288 VSS.n660 51.7246
R2138 VSS.t292 VSS.n630 51.7246
R2139 VSS.t292 VSS.n537 51.7246
R2140 VSS.t287 VSS.n618 51.7246
R2141 VSS.t287 VSS.n534 51.7246
R2142 VSS.t272 VSS.n501 51.7246
R2143 VSS.t272 VSS.n2667 51.7246
R2144 VSS.t266 VSS.n498 51.7246
R2145 VSS.t266 VSS.n2655 51.7246
R2146 VSS.t262 VSS.n495 51.7246
R2147 VSS.t274 VSS.n2646 51.7246
R2148 VSS.t270 VSS.n492 51.7246
R2149 VSS.t268 VSS.n2634 51.7246
R2150 VSS.t264 VSS.n489 51.7246
R2151 VSS.t15 VSS.n3398 51.7246
R2152 VSS.t23 VSS.n103 51.7246
R2153 VSS.t21 VSS.n3396 51.7246
R2154 VSS.t17 VSS.n51 51.7246
R2155 VSS.t9 VSS.n86 51.7246
R2156 VSS.t9 VSS.n3390 51.7246
R2157 VSS.t20 VSS.n57 51.7246
R2158 VSS.t20 VSS.n3386 51.7246
R2159 VSS.n3336 VSS.t178 51.7246
R2160 VSS.t178 VSS.n3335 51.7246
R2161 VSS.n3330 VSS.t170 51.7246
R2162 VSS.t170 VSS.n3329 51.7246
R2163 VSS.n3323 VSS.t177 51.7246
R2164 VSS.n3320 VSS.t172 51.7246
R2165 VSS.n3317 VSS.t184 51.7246
R2166 VSS.n3314 VSS.t174 51.7246
R2167 VSS.n2967 VSS.t554 51.0031
R2168 VSS.n3035 VSS.t493 51.0031
R2169 VSS.t544 VSS.n235 51.0031
R2170 VSS.n199 VSS.t511 51.0031
R2171 VSS.t27 VSS.n2137 50.6964
R2172 VSS.n2130 VSS.t67 50.6964
R2173 VSS.t455 VSS.n2880 50.315
R2174 VSS.t117 VSS.n706 49.8089
R2175 VSS.t104 VSS.n704 49.8089
R2176 VSS.n3040 VSS.n3039 49.4833
R2177 VSS.t28 VSS.n2138 49.0951
R2178 VSS.n2129 VSS.t424 49.0951
R2179 VSS.n2031 VSS.n2030 48.6165
R2180 VSS.n3408 VSS.n366 48.3876
R2181 VSS.n2496 VSS.n1132 48.1569
R2182 VSS.t924 VSS.n2349 47.9838
R2183 VSS.n2353 VSS.t924 47.9838
R2184 VSS.n2355 VSS.t1066 47.9838
R2185 VSS.n2371 VSS.t1070 47.9838
R2186 VSS.t473 VSS.n2374 47.9838
R2187 VSS.n2379 VSS.t473 47.9838
R2188 VSS.n2144 VSS.n2142 47.2472
R2189 VSS.n2888 VSS.t53 46.6237
R2190 VSS.n2889 VSS.t1047 46.622
R2191 VSS.n2310 VSS.t436 46.3262
R2192 VSS.t434 VSS.n2308 46.3239
R2193 VSS.t449 VSS.n692 45.9775
R2194 VSS.t300 VSS.n529 45.9775
R2195 VSS.t303 VSS.n506 45.9775
R2196 VSS.t97 VSS.n3198 45.9775
R2197 VSS.n3305 VSS.t100 45.9775
R2198 VSS.t431 VSS.n1498 45.8976
R2199 VSS.t431 VSS.n1496 45.8976
R2200 VSS.t385 VSS.n1445 45.8976
R2201 VSS.t385 VSS.n1489 45.8976
R2202 VSS.n2452 VSS.t70 45.8743
R2203 VSS.t124 VSS.n273 45.8707
R2204 VSS.n2757 VSS.t153 45.6909
R2205 VSS.n1405 VSS.t38 45.6899
R2206 VSS.t773 VSS.n2828 44.4643
R2207 VSS.t585 VSS.n2833 44.4643
R2208 VSS.t784 VSS.n2826 44.4643
R2209 VSS.t738 VSS.n2835 44.4643
R2210 VSS.t558 VSS.n2806 44.4643
R2211 VSS.t638 VSS.n2837 44.4643
R2212 VSS.t862 VSS.n2804 44.4643
R2213 VSS.t643 VSS.n2839 44.4643
R2214 VSS.n3502 VSS.t867 44.4643
R2215 VSS.n244 VSS.t652 44.4643
R2216 VSS.n3504 VSS.t872 44.4643
R2217 VSS.n3505 VSS.t571 44.4643
R2218 VSS.n3580 VSS.t762 44.4643
R2219 VSS.t718 VSS.n185 44.4643
R2220 VSS.t548 VSS.n183 44.4643
R2221 VSS.t723 VSS.n179 44.4643
R2222 VSS.n2305 VSS.n2304 44.0618
R2223 VSS.t36 VSS.n2077 43.101
R2224 VSS.t112 VSS.n1048 43.0032
R2225 VSS.n197 VSS.n156 42.8926
R2226 VSS.n1051 VSS.n1050 42.5599
R2227 VSS.n1296 VSS.n1100 42.2394
R2228 VSS.t119 VSS.n786 42.1461
R2229 VSS.n2739 VSS.t311 42.0413
R2230 VSS.n16 VSS.t932 42.0413
R2231 VSS.t323 VSS.n2739 42.0403
R2232 VSS.t945 VSS.n16 42.0403
R2233 VSS.n2756 VSS.t926 42.0241
R2234 VSS.t144 VSS.n1352 42.0241
R2235 VSS.n2747 VSS.t150 42.0241
R2236 VSS.n1402 VSS.t42 42.024
R2237 VSS.t405 VSS.n1545 41.3605
R2238 VSS.n367 VSS.n366 41.0698
R2239 VSS.n2091 VSS.t1027 40.2082
R2240 VSS.t1029 VSS.n2082 40.2063
R2241 VSS.n2023 VSS.n2022 40.0776
R2242 VSS.n3409 VSS.n3408 39.7616
R2243 VSS.n2242 VSS.n2241 39.1713
R2244 VSS.n2407 VSS.n2351 38.8757
R2245 VSS.n2407 VSS.n2377 38.8757
R2246 VSS.n2893 VSS.n410 38.6918
R2247 VSS.n900 VSS.n745 38.3147
R2248 VSS.n903 VSS.n734 38.3147
R2249 VSS.n904 VSS.n747 38.3147
R2250 VSS.n991 VSS.n724 38.3147
R2251 VSS.n992 VSS.n758 38.3147
R2252 VSS.n990 VSS.n722 38.3147
R2253 VSS.n987 VSS.n760 38.3147
R2254 VSS.n983 VSS.n762 38.3147
R2255 VSS.n982 VSS.n718 38.3147
R2256 VSS.n979 VSS.n764 38.3147
R2257 VSS.n978 VSS.n716 38.3147
R2258 VSS.n975 VSS.n766 38.3147
R2259 VSS.n974 VSS.n714 38.3147
R2260 VSS.n971 VSS.n768 38.3147
R2261 VSS.n970 VSS.n712 38.3147
R2262 VSS.n967 VSS.n770 38.3147
R2263 VSS.n966 VSS.n710 38.3147
R2264 VSS.n962 VSS.n708 38.3147
R2265 VSS.n1024 VSS.n683 38.3147
R2266 VSS.n1026 VSS.n802 38.3147
R2267 VSS.n1033 VSS.n681 38.3147
R2268 VSS.t429 VSS.n1359 38.1927
R2269 VSS.n2755 VSS.t188 38.1927
R2270 VSS.n2746 VSS.t395 38.1927
R2271 VSS.n1401 VSS.t139 38.1926
R2272 VSS.n664 VSS.n663 37.7764
R2273 VSS.n2360 VSS.t1065 35.4664
R2274 VSS.n2367 VSS.t1067 35.4664
R2275 VSS.n2974 VSS.n430 35.31
R2276 VSS.n2969 VSS.n2830 35.31
R2277 VSS.n2967 VSS.n2829 35.31
R2278 VSS.n2965 VSS.n2831 35.31
R2279 VSS.n2963 VSS.n2828 35.31
R2280 VSS.n2961 VSS.t673 35.31
R2281 VSS.n2959 VSS.n2827 35.31
R2282 VSS.n2955 VSS.t482 35.31
R2283 VSS.n2953 VSS.n2834 35.31
R2284 VSS.n2951 VSS.n2826 35.31
R2285 VSS.n2949 VSS.t590 35.31
R2286 VSS.n2949 VSS.t316 35.31
R2287 VSS.n2948 VSS.n2824 35.31
R2288 VSS.n2947 VSS.n2835 35.31
R2289 VSS.n2946 VSS.n2806 35.31
R2290 VSS.n2945 VSS.n2836 35.31
R2291 VSS.n2944 VSS.t309 35.31
R2292 VSS.n2944 VSS.t857 35.31
R2293 VSS.n2932 VSS.n2837 35.31
R2294 VSS.n2934 VSS.n2805 35.31
R2295 VSS.n2935 VSS.t563 35.31
R2296 VSS.n2937 VSS.n2838 35.31
R2297 VSS.n2938 VSS.t743 35.31
R2298 VSS.n2939 VSS.n2839 35.31
R2299 VSS.n2940 VSS.n2803 35.31
R2300 VSS.n3035 VSS.n2840 35.31
R2301 VSS.n3037 VSS.n2802 35.31
R2302 VSS.n3574 VSS.n242 35.31
R2303 VSS.n3573 VSS.n237 35.31
R2304 VSS.n3501 VSS.n235 35.31
R2305 VSS.n246 VSS.n233 35.31
R2306 VSS.n3502 VSS.n231 35.31
R2307 VSS.t748 VSS.n229 35.31
R2308 VSS.n3503 VSS.n227 35.31
R2309 VSS.t569 VSS.n223 35.31
R2310 VSS.n243 VSS.n221 35.31
R2311 VSS.n3504 VSS.n219 35.31
R2312 VSS.t657 VSS.n191 35.31
R2313 VSS.t927 VSS.n191 35.31
R2314 VSS.n3571 VSS.n193 35.31
R2315 VSS.n3505 VSS.n194 35.31
R2316 VSS.n3580 VSS.n189 35.31
R2317 VSS.n3579 VSS.n186 35.31
R2318 VSS.n217 VSS.t939 35.31
R2319 VSS.n217 VSS.t659 35.31
R2320 VSS.n215 VSS.n185 35.31
R2321 VSS.n213 VSS.n184 35.31
R2322 VSS.n211 VSS.t630 35.31
R2323 VSS.n207 VSS.n182 35.31
R2324 VSS.n205 VSS.t843 35.31
R2325 VSS.n203 VSS.n179 35.31
R2326 VSS.n200 VSS.n178 35.31
R2327 VSS.n199 VSS.n177 35.31
R2328 VSS.n916 VSS.n728 34.4833
R2329 VSS.n920 VSS.n755 34.4833
R2330 VSS.n921 VSS.n726 34.4833
R2331 VSS.n986 VSS.t120 34.4833
R2332 VSS.n975 VSS.t111 34.4833
R2333 VSS.n944 VSS.t109 34.4833
R2334 VSS.n935 VSS.t119 34.4833
R2335 VSS.n1007 VSS.n791 34.4833
R2336 VSS.n1011 VSS.n689 34.4833
R2337 VSS.n1012 VSS.n793 34.4833
R2338 VSS.t443 VSS.n1368 34.3612
R2339 VSS.n1374 VSS.t134 34.3612
R2340 VSS.t313 VSS.n2833 34.0022
R2341 VSS.t321 VSS.n2804 34.0022
R2342 VSS.n244 VSS.t943 34.0022
R2343 VSS.t941 VSS.n183 34.0022
R2344 VSS.n1321 VSS.n1131 33.7242
R2345 VSS.n1340 VSS.n1130 33.7242
R2346 VSS.n1339 VSS.n1128 33.7242
R2347 VSS.n1317 VSS.n1127 33.7242
R2348 VSS.n1338 VSS.n1126 33.7242
R2349 VSS.n1337 VSS.n1122 33.7242
R2350 VSS.n1315 VSS.n1121 33.7242
R2351 VSS.n1336 VSS.n1120 33.7242
R2352 VSS.n1314 VSS.n1117 33.7242
R2353 VSS.n1335 VSS.n1116 33.7242
R2354 VSS.n1313 VSS.n1115 33.7242
R2355 VSS.n1334 VSS.n1114 33.7242
R2356 VSS.n1312 VSS.n1113 33.7242
R2357 VSS.n1333 VSS.n1112 33.7242
R2358 VSS.n1311 VSS.n1109 33.7242
R2359 VSS.n1332 VSS.n1108 33.7242
R2360 VSS.n1310 VSS.n1107 33.7242
R2361 VSS.n1331 VSS.n1105 33.7242
R2362 VSS.n1309 VSS.n1104 33.7242
R2363 VSS.n1696 VSS.t205 33.6975
R2364 VSS.n2069 VSS.n2038 32.0261
R2365 VSS.n2339 VSS.t431 31.294
R2366 VSS.t385 VSS.n2388 31.294
R2367 VSS.n2407 VSS.n2395 31.2671
R2368 VSS.n2407 VSS.n1553 31.2671
R2369 VSS.n2140 VSS.n2070 31.2255
R2370 VSS.t95 VSS.n1517 31.0235
R2371 VSS.n1335 VSS.t294 30.9138
R2372 VSS.t294 VSS.n1115 30.9138
R2373 VSS.n1091 VSS.t1036 30.9138
R2374 VSS.n1755 VSS.n1650 30.8092
R2375 VSS.n1753 VSS.n1652 30.8092
R2376 VSS.n1751 VSS.n1654 30.8092
R2377 VSS.n1750 VSS.n1717 30.8092
R2378 VSS.n928 VSS.t449 30.6518
R2379 VSS.n2597 VSS.n521 30.6518
R2380 VSS.n2602 VSS.n520 30.6518
R2381 VSS.n2604 VSS.n519 30.6518
R2382 VSS.n2610 VSS.n516 30.6518
R2383 VSS.n2612 VSS.n515 30.6518
R2384 VSS.n2613 VSS.n514 30.6518
R2385 VSS.n3215 VSS.n3214 30.6518
R2386 VSS.n3217 VSS.n3216 30.6518
R2387 VSS.n3219 VSS.n3218 30.6518
R2388 VSS.n3222 VSS.n3221 30.6518
R2389 VSS.n3224 VSS.n3213 30.6518
R2390 VSS.n3229 VSS.n3225 30.6518
R2391 VSS.n2140 VSS.n2139 30.5733
R2392 VSS.n1372 VSS.t156 30.5298
R2393 VSS.t141 VSS.n1539 29.457
R2394 VSS.t924 VSS.n1482 29.2077
R2395 VSS.t924 VSS.n1479 29.2077
R2396 VSS.t1066 VSS.n1475 29.2077
R2397 VSS.t1065 VSS.n1470 29.2077
R2398 VSS.t1067 VSS.n1466 29.2077
R2399 VSS.t1070 VSS.n1459 29.2077
R2400 VSS.t473 VSS.n1455 29.2077
R2401 VSS.t473 VSS.n1454 29.2077
R2402 VSS.n2214 VSS.n1706 28.8837
R2403 VSS.n2209 VSS.n1666 28.8837
R2404 VSS.n2200 VSS.n1705 28.8837
R2405 VSS.n1943 VSS.n1668 28.8837
R2406 VSS.n1941 VSS.n1703 28.8837
R2407 VSS.n1939 VSS.n1669 28.8837
R2408 VSS.n1937 VSS.n1702 28.8837
R2409 VSS.n1935 VSS.n1670 28.8837
R2410 VSS.n1933 VSS.n1701 28.8837
R2411 VSS.n1916 VSS.n1676 28.8837
R2412 VSS.n1914 VSS.n1690 28.8837
R2413 VSS.n1912 VSS.n1677 28.8837
R2414 VSS.n3608 VSS.n30 28.6146
R2415 VSS.t209 VSS.n2021 28.4635
R2416 VSS.n1318 VSS.t399 28.1035
R2417 VSS.t1033 VSS.n1101 28.1035
R2418 VSS.n574 VSS.n518 27.5175
R2419 VSS.n574 VSS.n517 27.5175
R2420 VSS.n888 VSS.n886 26.9642
R2421 VSS.n888 VSS.n887 26.9642
R2422 VSS.n887 VSS.n885 26.9642
R2423 VSS.n827 VSS.n748 26.9642
R2424 VSS.n826 VSS.n749 26.9642
R2425 VSS.n824 VSS.n798 26.9642
R2426 VSS.n819 VSS.n677 26.9642
R2427 VSS.n3156 VSS.n558 26.9642
R2428 VSS.n3156 VSS.n557 26.9642
R2429 VSS.n570 VSS.n557 26.9642
R2430 VSS.n576 VSS.n528 26.9642
R2431 VSS.n577 VSS.n527 26.9642
R2432 VSS.n578 VSS.n526 26.9642
R2433 VSS.n580 VSS.n509 26.9642
R2434 VSS.n581 VSS.n508 26.9642
R2435 VSS.n571 VSS.n482 26.9642
R2436 VSS.n3610 VSS.n3609 26.9642
R2437 VSS.n577 VSS.n526 26.9642
R2438 VSS.n576 VSS.n527 26.9642
R2439 VSS.n579 VSS.n509 26.9642
R2440 VSS.n580 VSS.n508 26.9642
R2441 VSS.n581 VSS.n507 26.9642
R2442 VSS.n572 VSS.n482 26.9642
R2443 VSS.n826 VSS.n748 26.9642
R2444 VSS.n824 VSS.n797 26.9642
R2445 VSS.n823 VSS.n798 26.9642
R2446 VSS.n819 VSS.n678 26.9642
R2447 VSS.n3609 VSS.n3608 26.9642
R2448 VSS.t107 VSS.n764 26.8204
R2449 VSS.n963 VSS.t105 26.8204
R2450 VSS.n956 VSS.t117 26.8204
R2451 VSS.n630 VSS.n538 26.8204
R2452 VSS.n624 VSS.n537 26.8204
R2453 VSS.n618 VSS.n535 26.8204
R2454 VSS.n617 VSS.n534 26.8204
R2455 VSS.n610 VSS.n532 26.8204
R2456 VSS.n606 VSS.n531 26.8204
R2457 VSS.n605 VSS.n530 26.8204
R2458 VSS.n2626 VSS.n505 26.8204
R2459 VSS.n2678 VSS.n504 26.8204
R2460 VSS.n2675 VSS.n503 26.8204
R2461 VSS.n2668 VSS.n501 26.8204
R2462 VSS.n2667 VSS.n500 26.8204
R2463 VSS.n2660 VSS.n498 26.8204
R2464 VSS.n2655 VSS.n497 26.8204
R2465 VSS.n86 VSS.n85 26.8204
R2466 VSS.n3390 VSS.n55 26.8204
R2467 VSS.n80 VSS.n57 26.8204
R2468 VSS.n3386 VSS.n75 26.8204
R2469 VSS.n70 VSS.n68 26.8204
R2470 VSS.n69 VSS.n61 26.8204
R2471 VSS.n3197 VSS.n3196 26.8204
R2472 VSS.n3345 VSS.n3344 26.8204
R2473 VSS.n3343 VSS.n3342 26.8204
R2474 VSS.n3341 VSS.n3340 26.8204
R2475 VSS.n3337 VSS.n3336 26.8204
R2476 VSS.n3335 VSS.n3334 26.8204
R2477 VSS.n3331 VSS.n3330 26.8204
R2478 VSS.n3329 VSS.n3328 26.8204
R2479 VSS.n1727 VSS.t224 26.4768
R2480 VSS.n3436 VSS.n296 26.4585
R2481 VSS.n3361 VSS.t885 26.0062
R2482 VSS.n2621 VSS.t416 26.0062
R2483 VSS.n959 VSS.t450 26.0062
R2484 VSS.n2025 VSS.n2024 25.6172
R2485 VSS.n2027 VSS.n2026 25.6172
R2486 VSS.n2029 VSS.n2028 25.6172
R2487 VSS.t95 VSS.n1516 25.4593
R2488 VSS.n1244 VSS.t169 25.2932
R2489 VSS.n1269 VSS.t211 25.2932
R2490 VSS.t900 VSS.n1667 25.0326
R2491 VSS.n1683 VSS.t898 25.0326
R2492 VSS.n804 VSS.t1023 24.9047
R2493 VSS.n2872 VSS.n391 24.5976
R2494 VSS.n391 VSS.n390 24.5976
R2495 VSS.n385 VSS.n382 24.5976
R2496 VSS.n382 VSS.n381 24.5976
R2497 VSS.n376 VSS.n373 24.5976
R2498 VSS.n373 VSS.n372 24.5976
R2499 VSS.n360 VSS.n359 24.5976
R2500 VSS.n359 VSS.n356 24.5976
R2501 VSS.n352 VSS.n351 24.5976
R2502 VSS.n351 VSS.n347 24.5976
R2503 VSS.n3437 VSS.n3436 24.5976
R2504 VSS.n3578 VSS.n156 24.2482
R2505 VSS.n1386 VSS.t430 24.0115
R2506 VSS.n1395 VSS.t157 24.0017
R2507 VSS.n1384 VSS.t1073 24.0017
R2508 VSS.n2243 VSS.n1574 23.3124
R2509 VSS.n2407 VSS.n2363 23.2427
R2510 VSS.n892 VSS.t167 22.8868
R2511 VSS.t82 VSS.n855 22.886
R2512 VSS.n1279 VSS.n1184 22.4829
R2513 VSS.n2495 VSS.t102 21.4579
R2514 VSS.n1798 VSS.n1711 21.3649
R2515 VSS.n1801 VSS.n1661 21.3649
R2516 VSS.n1805 VSS.n1662 21.3649
R2517 VSS.t913 VSS.n687 21.0733
R2518 VSS.n2395 VSS.n1488 20.9247
R2519 VSS.n1553 VSS.n1438 20.9247
R2520 VSS.t247 VSS.n389 20.9247
R2521 VSS.t55 VSS.n3438 20.9247
R2522 VSS.t238 VSS.n1646 20.7001
R2523 VSS.n1752 VSS.t222 20.7001
R2524 VSS.t141 VSS.n1517 20.3178
R2525 VSS.t424 VSS.n2128 20.2846
R2526 VSS.t501 VSS.n1704 20.2187
R2527 VSS.t599 VSS.n1684 20.2187
R2528 VSS.n2139 VSS.t28 20.1637
R2529 VSS.n1297 VSS.n1097 19.7569
R2530 VSS.n1298 VSS.n1096 19.7569
R2531 VSS.n1300 VSS.n1089 19.7569
R2532 VSS.n1301 VSS.n1086 19.7569
R2533 VSS.n1302 VSS.n1084 19.7569
R2534 VSS.n1303 VSS.n1083 19.7569
R2535 VSS.n1305 VSS.n1081 19.7569
R2536 VSS.n1297 VSS.n1100 19.7563
R2537 VSS.n1298 VSS.n1097 19.7563
R2538 VSS.n1301 VSS.n1089 19.7563
R2539 VSS.n1302 VSS.n1086 19.7563
R2540 VSS.n1303 VSS.n1084 19.7563
R2541 VSS.n1305 VSS.n1080 19.7563
R2542 VSS.n1304 VSS.n1081 19.7563
R2543 VSS.t34 VSS.n1123 19.6726
R2544 VSS.n1054 VSS.n999 19.411
R2545 VSS.n1806 VSS.n1660 19.256
R2546 VSS.n1306 VSS.n1080 19.2494
R2547 VSS.t183 VSS.n3326 19.2191
R2548 VSS.n3392 VSS.t19 19.2191
R2549 VSS.n998 VSS.t160 19.1936
R2550 VSS.t485 VSS.n739 19.1576
R2551 VSS.t109 VSS.n780 19.1576
R2552 VSS.n821 VSS.t508 19.1576
R2553 VSS.t697 VSS.n553 19.1576
R2554 VSS.n664 VSS.n644 19.1576
R2555 VSS.n485 VSS.t712 19.1576
R2556 VSS.t687 VSS.n3605 19.1576
R2557 VSS.n2737 VSS.t489 19.0538
R2558 VSS.n14 VSS.t514 19.0538
R2559 VSS.t522 VSS.n18 19.0528
R2560 VSS.n2741 VSS.t538 19.0528
R2561 VSS.n1382 VSS.n1381 18.8996
R2562 VSS.n999 VSS.t162 18.8244
R2563 VSS.t0 VSS.n1516 18.8057
R2564 VSS.n2893 VSS.n411 18.7297
R2565 VSS.t67 VSS.n2129 18.6704
R2566 VSS.n1159 VSS.n1158 18.5358
R2567 VSS.n1356 VSS.n1355 18.5358
R2568 VSS.n3628 VSS.n3627 18.3222
R2569 VSS.n2564 VSS.n2563 18.3222
R2570 VSS.n545 VSS.n544 18.3222
R2571 VSS.t316 VSS.n2824 18.3091
R2572 VSS.t309 VSS.n2836 18.3091
R2573 VSS.t4 VSS.n380 18.3091
R2574 VSS.n350 VSS.t73 18.3091
R2575 VSS.n3571 VSS.t927 18.3091
R2576 VSS.t939 VSS.n186 18.3091
R2577 VSS.n1846 VSS.n1845 18.2932
R2578 VSS.t232 VSS.n1710 17.8118
R2579 VSS.n3360 VSS.t98 17.7897
R2580 VSS.n2620 VSS.t301 17.7897
R2581 VSS.n958 VSS.t1043 17.7897
R2582 VSS.n1045 VSS.t259 17.4606
R2583 VSS.n1762 VSS.t225 17.3339
R2584 VSS.n1760 VSS.t223 17.3339
R2585 VSS.n2056 VSS.t242 17.3339
R2586 VSS.n2058 VSS.t243 17.3339
R2587 VSS.n998 VSS.t161 17.2961
R2588 VSS.t1025 VSS.n522 17.2419
R2589 VSS.t1030 VSS.n3243 17.2419
R2590 VSS.n1164 VSS.t889 17.1952
R2591 VSS.n2138 VSS.t891 17.0691
R2592 VSS.n2137 VSS.t47 17.0691
R2593 VSS.t74 VSS.n2130 17.0691
R2594 VSS.n3568 VSS.n190 17.011
R2595 VSS.n3030 VSS.n3013 17.0107
R2596 VSS.n3627 VSS.t883 17.0062
R2597 VSS.n2563 VSS.t448 17.0062
R2598 VSS.n544 VSS.t414 17.0062
R2599 VSS.n3633 VSS.t791 17.0024
R2600 VSS.n3360 VSS.t99 17.0024
R2601 VSS.n2620 VSS.t302 17.0024
R2602 VSS.n958 VSS.t1045 17.0024
R2603 VSS.n806 VSS.t847 17.0023
R2604 VSS.n1054 VSS.n1053 17.001
R2605 VSS.n2893 VSS.n2880 17.0005
R2606 VSS.t676 VSS.n1959 17.0005
R2607 VSS.n3071 VSS.t308 17.0005
R2608 VSS.n3071 VSS.t597 17.0005
R2609 VSS.n3071 VSS.t596 17.0005
R2610 VSS.n3065 VSS.t358 17.0005
R2611 VSS.n3065 VSS.t850 17.0005
R2612 VSS.n3065 VSS.t849 17.0005
R2613 VSS.n468 VSS.t331 17.0005
R2614 VSS.n468 VSS.t682 17.0005
R2615 VSS.n468 VSS.t681 17.0005
R2616 VSS.n417 VSS.t375 17.0005
R2617 VSS.n417 VSS.t543 17.0005
R2618 VSS.n417 VSS.t542 17.0005
R2619 VSS.n442 VSS.t344 17.0005
R2620 VSS.n442 VSS.t752 17.0005
R2621 VSS.n442 VSS.t751 17.0005
R2622 VSS.n459 VSS.t314 17.0005
R2623 VSS.n459 VSS.t607 17.0005
R2624 VSS.n459 VSS.t606 17.0005
R2625 VSS.n457 VSS.t360 17.0005
R2626 VSS.n457 VSS.t866 17.0005
R2627 VSS.n457 VSS.t865 17.0005
R2628 VSS.n448 VSS.t335 17.0005
R2629 VSS.n448 VSS.t692 17.0005
R2630 VSS.n448 VSS.t691 17.0005
R2631 VSS.n446 VSS.t377 17.0005
R2632 VSS.n446 VSS.t556 17.0005
R2633 VSS.n446 VSS.t555 17.0005
R2634 VSS.n435 VSS.t348 17.0005
R2635 VSS.n435 VSS.t772 17.0005
R2636 VSS.n435 VSS.t771 17.0005
R2637 VSS.n3175 VSS.t318 17.0005
R2638 VSS.n3175 VSS.t616 17.0005
R2639 VSS.n3175 VSS.t615 17.0005
R2640 VSS.n2807 VSS.t365 17.0005
R2641 VSS.n2807 VSS.t370 17.0005
R2642 VSS.n2808 VSS.t339 17.0005
R2643 VSS.n2808 VSS.t345 17.0005
R2644 VSS.n2809 VSS.t380 17.0005
R2645 VSS.n2809 VSS.t315 17.0005
R2646 VSS.n2810 VSS.t355 17.0005
R2647 VSS.n2810 VSS.t361 17.0005
R2648 VSS.n2811 VSS.t352 17.0005
R2649 VSS.n2811 VSS.t369 17.0005
R2650 VSS.n2812 VSS.t324 17.0005
R2651 VSS.n2812 VSS.t343 17.0005
R2652 VSS.n2813 VSS.t367 17.0005
R2653 VSS.n2813 VSS.t312 17.0005
R2654 VSS.n2814 VSS.t340 17.0005
R2655 VSS.n2814 VSS.t359 17.0005
R2656 VSS.n2815 VSS.t306 17.0005
R2657 VSS.n2815 VSS.t333 17.0005
R2658 VSS.n2816 VSS.t354 17.0005
R2659 VSS.n2816 VSS.t371 17.0005
R2660 VSS.n2817 VSS.t325 17.0005
R2661 VSS.n2817 VSS.t346 17.0005
R2662 VSS.n2818 VSS.t368 17.0005
R2663 VSS.n2818 VSS.t317 17.0005
R2664 VSS.n2819 VSS.t342 17.0005
R2665 VSS.n2819 VSS.t363 17.0005
R2666 VSS.n2820 VSS.t310 17.0005
R2667 VSS.n2820 VSS.t337 17.0005
R2668 VSS.n2821 VSS.t356 17.0005
R2669 VSS.n2821 VSS.t373 17.0005
R2670 VSS.n2822 VSS.t326 17.0005
R2671 VSS.n2822 VSS.t349 17.0005
R2672 VSS.n2841 VSS.t734 17.0005
R2673 VSS.n2801 VSS.t506 17.0005
R2674 VSS.n2861 VSS.t666 17.0005
R2675 VSS.n2845 VSS.t833 17.0005
R2676 VSS.n2858 VSS.t584 17.0005
R2677 VSS.n2855 VSS.t717 17.0005
R2678 VSS.n2853 VSS.t495 17.0005
R2679 VSS.n2850 VSS.t642 17.0005
R2680 VSS.n2778 VSS.t812 17.0005
R2681 VSS.n2781 VSS.t567 17.0005
R2682 VSS.n2784 VSS.t702 17.0005
R2683 VSS.n2977 VSS.t645 17.0005
R2684 VSS.t645 VSS.n2975 17.0005
R2685 VSS.t645 VSS.n2976 17.0005
R2686 VSS.n3008 VSS.t733 17.0005
R2687 VSS.n3008 VSS.t379 17.0005
R2688 VSS.n3007 VSS.t505 17.0005
R2689 VSS.n3007 VSS.t338 17.0005
R2690 VSS.n3006 VSS.t665 17.0005
R2691 VSS.n3006 VSS.t366 17.0005
R2692 VSS.n3005 VSS.t832 17.0005
R2693 VSS.n3005 VSS.t322 17.0005
R2694 VSS.n3004 VSS.t583 17.0005
R2695 VSS.n3004 VSS.t351 17.0005
R2696 VSS.n3002 VSS.t716 17.0005
R2697 VSS.n3002 VSS.t376 17.0005
R2698 VSS.n3001 VSS.t494 17.0005
R2699 VSS.n3001 VSS.t334 17.0005
R2700 VSS.n3000 VSS.t641 17.0005
R2701 VSS.n3000 VSS.t364 17.0005
R2702 VSS.n2999 VSS.t811 17.0005
R2703 VSS.n2999 VSS.t320 17.0005
R2704 VSS.n2998 VSS.t566 17.0005
R2705 VSS.n2998 VSS.t350 17.0005
R2706 VSS.n2997 VSS.t701 17.0005
R2707 VSS.n2997 VSS.t374 17.0005
R2708 VSS.n2788 VSS.t678 17.0005
R2709 VSS.n2788 VSS.t357 17.0005
R2710 VSS.n2789 VSS.t539 17.0005
R2711 VSS.n2789 VSS.t328 17.0005
R2712 VSS.n2994 VSS.t782 17.0005
R2713 VSS.n2994 VSS.t372 17.0005
R2714 VSS.n2995 VSS.t618 17.0005
R2715 VSS.n2995 VSS.t347 17.0005
R2716 VSS.n2996 VSS.t875 17.0005
R2717 VSS.n2996 VSS.t329 17.0005
R2718 VSS.n3080 VSS.t336 17.0005
R2719 VSS.n3080 VSS.t634 17.0005
R2720 VSS.n2731 VSS.t830 17.0005
R2721 VSS.n2730 VSS.t362 17.0005
R2722 VSS.n2730 VSS.t794 17.0005
R2723 VSS.n2730 VSS.t793 17.0005
R2724 VSS.n3080 VSS.t633 17.0005
R2725 VSS.n3081 VSS.t747 17.0005
R2726 VSS.n2719 VSS.t378 17.0005
R2727 VSS.n2719 VSS.t491 17.0005
R2728 VSS.n2719 VSS.t490 17.0005
R2729 VSS.n2718 VSS.t800 17.0005
R2730 VSS.n2711 VSS.t353 17.0005
R2731 VSS.n2711 VSS.t710 17.0005
R2732 VSS.n2711 VSS.t709 17.0005
R2733 VSS.n439 VSS.t714 17.0005
R2734 VSS.n2700 VSS.t341 17.0005
R2735 VSS.n2700 VSS.t737 17.0005
R2736 VSS.n2700 VSS.t736 17.0005
R2737 VSS.n3164 VSS.t829 17.0005
R2738 VSS.n477 VSS.t746 17.0005
R2739 VSS.n3089 VSS.t799 17.0005
R2740 VSS.n3091 VSS.t713 17.0005
R2741 VSS.n598 VSS.t809 17.0005
R2742 VSS.n596 VSS.t731 17.0005
R2743 VSS.n586 VSS.t777 17.0005
R2744 VSS.n3138 VSS.t699 17.0005
R2745 VSS.n590 VSS.t808 17.0005
R2746 VSS.n3142 VSS.t730 17.0005
R2747 VSS.n585 VSS.t776 17.0005
R2748 VSS.n3153 VSS.t698 17.0005
R2749 VSS.n808 VSS.t510 17.0005
R2750 VSS.n812 VSS.t879 17.0005
R2751 VSS.n815 VSS.t537 17.0005
R2752 VSS.n675 VSS.t846 17.0005
R2753 VSS.n836 VSS.t509 17.0005
R2754 VSS.n830 VSS.t878 17.0005
R2755 VSS.n839 VSS.t536 17.0005
R2756 VSS.n2560 VSS.t487 17.0005
R2757 VSS.n841 VSS.t827 17.0005
R2758 VSS.n869 VSS.t861 17.0005
R2759 VSS.n843 VSS.t803 17.0005
R2760 VSS.n848 VSS.t486 17.0005
R2761 VSS.n870 VSS.t826 17.0005
R2762 VSS.n868 VSS.t860 17.0005
R2763 VSS.n881 VSS.t802 17.0005
R2764 VSS.n2416 VSS.n1448 17.0005
R2765 VSS.n2416 VSS.n1447 17.0005
R2766 VSS.n2416 VSS.n1449 17.0005
R2767 VSS.n2416 VSS.n1450 17.0005
R2768 VSS.n2416 VSS.n1452 17.0005
R2769 VSS.n2416 VSS.n1451 17.0005
R2770 VSS.n2416 VSS.n1453 17.0005
R2771 VSS.n2416 VSS.n1454 17.0005
R2772 VSS.n2416 VSS.n1456 17.0005
R2773 VSS.n2416 VSS.n1455 17.0005
R2774 VSS.n2416 VSS.n1457 17.0005
R2775 VSS.n2416 VSS.n1458 17.0005
R2776 VSS.n2416 VSS.n1460 17.0005
R2777 VSS.n2416 VSS.n1459 17.0005
R2778 VSS.n2416 VSS.n1461 17.0005
R2779 VSS.n2416 VSS.n1462 17.0005
R2780 VSS.n2416 VSS.n1464 17.0005
R2781 VSS.n2416 VSS.n1463 17.0005
R2782 VSS.n2416 VSS.n1465 17.0005
R2783 VSS.n2416 VSS.n1466 17.0005
R2784 VSS.n2416 VSS.n1468 17.0005
R2785 VSS.n2416 VSS.n1467 17.0005
R2786 VSS.n2416 VSS.n1469 17.0005
R2787 VSS.n2416 VSS.n1470 17.0005
R2788 VSS.n2416 VSS.n1472 17.0005
R2789 VSS.n2416 VSS.n1471 17.0005
R2790 VSS.n2416 VSS.n1473 17.0005
R2791 VSS.n2416 VSS.n1474 17.0005
R2792 VSS.n2416 VSS.n1476 17.0005
R2793 VSS.n2416 VSS.n1475 17.0005
R2794 VSS.n2416 VSS.n1477 17.0005
R2795 VSS.n2416 VSS.n1478 17.0005
R2796 VSS.n2416 VSS.n1480 17.0005
R2797 VSS.n2416 VSS.n1479 17.0005
R2798 VSS.n2416 VSS.n1481 17.0005
R2799 VSS.n2416 VSS.n1482 17.0005
R2800 VSS.n2416 VSS.n1484 17.0005
R2801 VSS.n2416 VSS.n1483 17.0005
R2802 VSS.n2416 VSS.n1485 17.0005
R2803 VSS.n2416 VSS.n1486 17.0005
R2804 VSS.n2407 VSS.n2342 17.0005
R2805 VSS.n2407 VSS.n2343 17.0005
R2806 VSS.n2407 VSS.n2344 17.0005
R2807 VSS.n2407 VSS.n2345 17.0005
R2808 VSS.n2407 VSS.n2346 17.0005
R2809 VSS.n2407 VSS.n2347 17.0005
R2810 VSS.n2407 VSS.n2348 17.0005
R2811 VSS.n2407 VSS.n2349 17.0005
R2812 VSS.n2407 VSS.n2350 17.0005
R2813 VSS.n2407 VSS.n2352 17.0005
R2814 VSS.n2407 VSS.n2353 17.0005
R2815 VSS.n2407 VSS.n2354 17.0005
R2816 VSS.n2407 VSS.n2355 17.0005
R2817 VSS.n2407 VSS.n2356 17.0005
R2818 VSS.n2407 VSS.n2357 17.0005
R2819 VSS.n2407 VSS.n2359 17.0005
R2820 VSS.n2407 VSS.n2360 17.0005
R2821 VSS.n2407 VSS.n2362 17.0005
R2822 VSS.n2407 VSS.n2365 17.0005
R2823 VSS.n2407 VSS.n2366 17.0005
R2824 VSS.n2407 VSS.n2367 17.0005
R2825 VSS.n2407 VSS.n2368 17.0005
R2826 VSS.n2407 VSS.n2369 17.0005
R2827 VSS.n2407 VSS.n2370 17.0005
R2828 VSS.n2407 VSS.n2371 17.0005
R2829 VSS.n2407 VSS.n2373 17.0005
R2830 VSS.n2407 VSS.n2374 17.0005
R2831 VSS.n2407 VSS.n2376 17.0005
R2832 VSS.n2407 VSS.n2378 17.0005
R2833 VSS.n2407 VSS.n2379 17.0005
R2834 VSS.n2407 VSS.n2380 17.0005
R2835 VSS.n2407 VSS.n2381 17.0005
R2836 VSS.n2407 VSS.n2382 17.0005
R2837 VSS.n2407 VSS.n2383 17.0005
R2838 VSS.n2407 VSS.n2384 17.0005
R2839 VSS.n2407 VSS.n2385 17.0005
R2840 VSS.n1212 VSS.n1142 17.0005
R2841 VSS.n1268 VSS.n1142 17.0005
R2842 VSS.n1209 VSS.n1142 17.0005
R2843 VSS.n1269 VSS.n1142 17.0005
R2844 VSS.n1206 VSS.n1142 17.0005
R2845 VSS.n1270 VSS.n1142 17.0005
R2846 VSS.n1203 VSS.n1142 17.0005
R2847 VSS.n1271 VSS.n1142 17.0005
R2848 VSS.n1200 VSS.n1142 17.0005
R2849 VSS.n1272 VSS.n1142 17.0005
R2850 VSS.n1197 VSS.n1142 17.0005
R2851 VSS.n1273 VSS.n1142 17.0005
R2852 VSS.n1360 VSS.n1142 17.0005
R2853 VSS.n1274 VSS.n1142 17.0005
R2854 VSS.n1192 VSS.n1142 17.0005
R2855 VSS.n1275 VSS.n1142 17.0005
R2856 VSS.n1188 VSS.n1142 17.0005
R2857 VSS.n1276 VSS.n1142 17.0005
R2858 VSS.n1185 VSS.n1142 17.0005
R2859 VSS.n1277 VSS.n1142 17.0005
R2860 VSS.n1182 VSS.n1142 17.0005
R2861 VSS.n1167 VSS.n1142 17.0005
R2862 VSS.n2501 VSS.n1244 17.0005
R2863 VSS.n2501 VSS.n1279 17.0005
R2864 VSS.n2501 VSS.n1277 17.0005
R2865 VSS.n2501 VSS.n1276 17.0005
R2866 VSS.n2501 VSS.n1275 17.0005
R2867 VSS.n2501 VSS.n1274 17.0005
R2868 VSS.n2501 VSS.n1273 17.0005
R2869 VSS.n2501 VSS.n1272 17.0005
R2870 VSS.n2501 VSS.n1271 17.0005
R2871 VSS.n2501 VSS.n1270 17.0005
R2872 VSS.n2501 VSS.n1269 17.0005
R2873 VSS.n2501 VSS.n1268 17.0005
R2874 VSS.n2501 VSS.n1267 17.0005
R2875 VSS.n2501 VSS.n1266 17.0005
R2876 VSS.n2501 VSS.n1265 17.0005
R2877 VSS.n2501 VSS.n1264 17.0005
R2878 VSS.n2501 VSS.n1263 17.0005
R2879 VSS.n2501 VSS.n1262 17.0005
R2880 VSS.n2501 VSS.n1261 17.0005
R2881 VSS.n2501 VSS.n1260 17.0005
R2882 VSS.n2504 VSS.n1167 17.0005
R2883 VSS.n2504 VSS.n1168 17.0005
R2884 VSS.n2504 VSS.n1170 17.0005
R2885 VSS.n2504 VSS.n1172 17.0005
R2886 VSS.n2504 VSS.n1175 17.0005
R2887 VSS.n2504 VSS.n1177 17.0005
R2888 VSS.n2504 VSS.n1179 17.0005
R2889 VSS.n2504 VSS.n1180 17.0005
R2890 VSS.n2504 VSS.n1183 17.0005
R2891 VSS.n2504 VSS.n1184 17.0005
R2892 VSS.n2504 VSS.n1186 17.0005
R2893 VSS.n2504 VSS.n1187 17.0005
R2894 VSS.n2504 VSS.n1189 17.0005
R2895 VSS.n2504 VSS.n1190 17.0005
R2896 VSS.n2504 VSS.n1193 17.0005
R2897 VSS.n2504 VSS.n1194 17.0005
R2898 VSS.n2504 VSS.n1195 17.0005
R2899 VSS.n2504 VSS.n1196 17.0005
R2900 VSS.n2504 VSS.n1198 17.0005
R2901 VSS.n2504 VSS.n1199 17.0005
R2902 VSS.n2504 VSS.n1201 17.0005
R2903 VSS.n2504 VSS.n1202 17.0005
R2904 VSS.n2504 VSS.n1204 17.0005
R2905 VSS.n2504 VSS.n1205 17.0005
R2906 VSS.n2504 VSS.n1207 17.0005
R2907 VSS.n2504 VSS.n1208 17.0005
R2908 VSS.n2504 VSS.n1210 17.0005
R2909 VSS.n2504 VSS.n1211 17.0005
R2910 VSS.n2504 VSS.n1213 17.0005
R2911 VSS.n2504 VSS.n1214 17.0005
R2912 VSS.n1346 VSS.n1343 17.0005
R2913 VSS.n1346 VSS.n1345 17.0005
R2914 VSS.n1344 VSS.n1342 17.0005
R2915 VSS.n1342 VSS.n1341 17.0005
R2916 VSS.n2501 VSS.n1293 17.0005
R2917 VSS.n2501 VSS.n1292 17.0005
R2918 VSS.n2501 VSS.n1290 17.0005
R2919 VSS.n1257 VSS.n1142 17.0005
R2920 VSS.n1143 VSS.n1142 17.0005
R2921 VSS.n1260 VSS.n1142 17.0005
R2922 VSS.n1235 VSS.n1142 17.0005
R2923 VSS.n1261 VSS.n1142 17.0005
R2924 VSS.n1232 VSS.n1142 17.0005
R2925 VSS.n1262 VSS.n1142 17.0005
R2926 VSS.n1229 VSS.n1142 17.0005
R2927 VSS.n1263 VSS.n1142 17.0005
R2928 VSS.n1225 VSS.n1142 17.0005
R2929 VSS.n1264 VSS.n1142 17.0005
R2930 VSS.n1222 VSS.n1142 17.0005
R2931 VSS.n1265 VSS.n1142 17.0005
R2932 VSS.n1219 VSS.n1142 17.0005
R2933 VSS.n1266 VSS.n1142 17.0005
R2934 VSS.n1216 VSS.n1142 17.0005
R2935 VSS.n1267 VSS.n1142 17.0005
R2936 VSS.n2513 VSS.n1131 17.0005
R2937 VSS.n2513 VSS.n1130 17.0005
R2938 VSS.n2513 VSS.n1129 17.0005
R2939 VSS.n2513 VSS.n1128 17.0005
R2940 VSS.n2513 VSS.n1127 17.0005
R2941 VSS.n2513 VSS.n1126 17.0005
R2942 VSS.n2513 VSS.n1123 17.0005
R2943 VSS.n2513 VSS.n1122 17.0005
R2944 VSS.n2513 VSS.n1121 17.0005
R2945 VSS.n2513 VSS.n1120 17.0005
R2946 VSS.n2513 VSS.n1117 17.0005
R2947 VSS.n2513 VSS.n1116 17.0005
R2948 VSS.n2513 VSS.n1115 17.0005
R2949 VSS.n2513 VSS.n1114 17.0005
R2950 VSS.n2513 VSS.n1113 17.0005
R2951 VSS.n2513 VSS.n1112 17.0005
R2952 VSS.n2513 VSS.n1109 17.0005
R2953 VSS.n2513 VSS.n1108 17.0005
R2954 VSS.n2513 VSS.n1107 17.0005
R2955 VSS.n2513 VSS.n1106 17.0005
R2956 VSS.n2513 VSS.n1105 17.0005
R2957 VSS.n2513 VSS.n1104 17.0005
R2958 VSS.n2513 VSS.n1101 17.0005
R2959 VSS.n2513 VSS.n1095 17.0005
R2960 VSS.n2513 VSS.n1092 17.0005
R2961 VSS.n2513 VSS.n1091 17.0005
R2962 VSS.n2513 VSS.n1090 17.0005
R2963 VSS.n2513 VSS.n1082 17.0005
R2964 VSS.n2513 VSS.n1078 17.0005
R2965 VSS.n1238 VSS.n1144 17.0005
R2966 VSS.n2504 VSS.n1217 17.0005
R2967 VSS.n2504 VSS.n1218 17.0005
R2968 VSS.n2504 VSS.n1220 17.0005
R2969 VSS.n2504 VSS.n1221 17.0005
R2970 VSS.n2504 VSS.n1223 17.0005
R2971 VSS.n2504 VSS.n1224 17.0005
R2972 VSS.n2504 VSS.n1226 17.0005
R2973 VSS.n2504 VSS.n1227 17.0005
R2974 VSS.n2504 VSS.n1230 17.0005
R2975 VSS.n2504 VSS.n1231 17.0005
R2976 VSS.n2504 VSS.n1233 17.0005
R2977 VSS.n2504 VSS.n1234 17.0005
R2978 VSS.n2504 VSS.n1236 17.0005
R2979 VSS.n2504 VSS.n1237 17.0005
R2980 VSS.n2509 VSS.n853 17.0005
R2981 VSS.n2450 VSS.n1144 17.0005
R2982 VSS.n1165 VSS.n1142 17.0005
R2983 VSS.n1241 VSS.n1142 17.0005
R2984 VSS.n2504 VSS.n1253 17.0005
R2985 VSS.n2504 VSS.n1251 17.0005
R2986 VSS.n2504 VSS.n1249 17.0005
R2987 VSS.n2504 VSS.n1246 17.0005
R2988 VSS.n2504 VSS.n1244 17.0005
R2989 VSS.n2504 VSS.n1241 17.0005
R2990 VSS.n2504 VSS.n1240 17.0005
R2991 VSS.n2504 VSS.n1162 17.0005
R2992 VSS.n1254 VSS.n1142 17.0005
R2993 VSS.n1160 VSS.n1142 17.0005
R2994 VSS.n1404 VSS.n1142 17.0005
R2995 VSS.n1287 VSS.n1142 17.0005
R2996 VSS.n1419 VSS.n1142 17.0005
R2997 VSS.n2504 VSS.n1149 17.0005
R2998 VSS.n2504 VSS.n1151 17.0005
R2999 VSS.n2504 VSS.n1152 17.0005
R3000 VSS.n2504 VSS.n1153 17.0005
R3001 VSS.n2504 VSS.n1155 17.0005
R3002 VSS.n2504 VSS.n1157 17.0005
R3003 VSS.n2504 VSS.n1160 17.0005
R3004 VSS.n2504 VSS.n1161 17.0005
R3005 VSS.n2504 VSS.n1254 17.0005
R3006 VSS.n2504 VSS.n2503 17.0005
R3007 VSS.n2416 VSS.n1493 17.0005
R3008 VSS.n2416 VSS.n1491 17.0005
R3009 VSS.n2416 VSS.n1492 17.0005
R3010 VSS.n2416 VSS.n1490 17.0005
R3011 VSS.n2416 VSS.n1489 17.0005
R3012 VSS.n2416 VSS.n1487 17.0005
R3013 VSS.n2416 VSS.n1488 17.0005
R3014 VSS.n2416 VSS.n1446 17.0005
R3015 VSS.n2416 VSS.n1445 17.0005
R3016 VSS.n2407 VSS.n2388 17.0005
R3017 VSS.n2407 VSS.n2392 17.0005
R3018 VSS.n2407 VSS.n2402 17.0005
R3019 VSS.n2407 VSS.n2404 17.0005
R3020 VSS.t527 VSS.n2397 17.0005
R3021 VSS.n2398 VSS.t527 17.0005
R3022 VSS.n2414 VSS.n1496 17.0005
R3023 VSS.n2414 VSS.n1440 17.0005
R3024 VSS.n2414 VSS.n1486 17.0005
R3025 VSS.n2414 VSS.n1483 17.0005
R3026 VSS.n2414 VSS.n1482 17.0005
R3027 VSS.n2414 VSS.n1479 17.0005
R3028 VSS.n2414 VSS.n1478 17.0005
R3029 VSS.n2414 VSS.n1475 17.0005
R3030 VSS.n2414 VSS.n1474 17.0005
R3031 VSS.n2414 VSS.n1471 17.0005
R3032 VSS.n2414 VSS.n1470 17.0005
R3033 VSS.n2414 VSS.n1467 17.0005
R3034 VSS.n2414 VSS.n1466 17.0005
R3035 VSS.n2414 VSS.n1463 17.0005
R3036 VSS.n2414 VSS.n1462 17.0005
R3037 VSS.n2414 VSS.n1459 17.0005
R3038 VSS.n2414 VSS.n1458 17.0005
R3039 VSS.n2414 VSS.n1455 17.0005
R3040 VSS.n2414 VSS.n1454 17.0005
R3041 VSS.n2414 VSS.n1451 17.0005
R3042 VSS.n2414 VSS.n1450 17.0005
R3043 VSS.n2414 VSS.n1447 17.0005
R3044 VSS.n2414 VSS.n1445 17.0005
R3045 VSS.n2414 VSS.n1488 17.0005
R3046 VSS.n1511 VSS.n1489 17.0005
R3047 VSS.n1511 VSS.n1492 17.0005
R3048 VSS.t769 VSS.n2411 17.0005
R3049 VSS.n2412 VSS.t769 17.0005
R3050 VSS.n2415 VSS.n2414 17.0005
R3051 VSS.n2414 VSS.n1436 17.0005
R3052 VSS.n2414 VSS.n1498 17.0005
R3053 VSS.n2414 VSS.n1438 17.0005
R3054 VSS.n2416 VSS.n1442 17.0005
R3055 VSS.n2416 VSS.n1440 17.0005
R3056 VSS.n2416 VSS.n1495 17.0005
R3057 VSS.n2416 VSS.n1496 17.0005
R3058 VSS.n2416 VSS.n1439 17.0005
R3059 VSS.n2416 VSS.n1438 17.0005
R3060 VSS.n2416 VSS.n1497 17.0005
R3061 VSS.n2416 VSS.n1498 17.0005
R3062 VSS.n2416 VSS.n1437 17.0005
R3063 VSS.n2416 VSS.n1436 17.0005
R3064 VSS.n2416 VSS.n1501 17.0005
R3065 VSS.n2416 VSS.n2415 17.0005
R3066 VSS.n2407 VSS.n1503 17.0005
R3067 VSS.n2407 VSS.n1550 17.0005
R3068 VSS.n2407 VSS.n1555 17.0005
R3069 VSS.n2407 VSS.n2339 17.0005
R3070 VSS.t761 VSS.n2175 17.0005
R3071 VSS.t761 VSS.n2173 17.0005
R3072 VSS.n2176 VSS.t761 17.0005
R3073 VSS.t601 VSS.n2185 17.0005
R3074 VSS.n2186 VSS.t601 17.0005
R3075 VSS.t601 VSS.n2183 17.0005
R3076 VSS.t669 VSS.n1964 17.0005
R3077 VSS.t669 VSS.n1953 17.0005
R3078 VSS.n1965 VSS.t669 17.0005
R3079 VSS.n2178 VSS.n1573 17.0005
R3080 VSS.n2167 VSS.n1573 17.0005
R3081 VSS.n2165 VSS.n2164 17.0005
R3082 VSS.n2164 VSS.n2163 17.0005
R3083 VSS.n2160 VSS.n2159 17.0005
R3084 VSS.n2159 VSS.n2158 17.0005
R3085 VSS.n1966 VSS.n1573 17.0005
R3086 VSS.n1951 VSS.n1573 17.0005
R3087 VSS.n1963 VSS.n1573 17.0005
R3088 VSS.n1952 VSS.n1573 17.0005
R3089 VSS.n1949 VSS.n1573 17.0005
R3090 VSS.n2184 VSS.n1573 17.0005
R3091 VSS.n1944 VSS.n1573 17.0005
R3092 VSS.n1598 VSS.n1573 17.0005
R3093 VSS.n1596 VSS.n1573 17.0005
R3094 VSS.n1594 VSS.n1573 17.0005
R3095 VSS.n1591 VSS.n1573 17.0005
R3096 VSS.n1589 VSS.n1573 17.0005
R3097 VSS.n1587 VSS.n1573 17.0005
R3098 VSS.n1585 VSS.n1573 17.0005
R3099 VSS.n1583 VSS.n1573 17.0005
R3100 VSS.n1580 VSS.n1573 17.0005
R3101 VSS.n1578 VSS.n1573 17.0005
R3102 VSS.n1946 VSS.n1573 17.0005
R3103 VSS.n2246 VSS.n1599 17.0005
R3104 VSS.n2246 VSS.n1597 17.0005
R3105 VSS.n2246 VSS.n1595 17.0005
R3106 VSS.n2246 VSS.n1593 17.0005
R3107 VSS.n2246 VSS.n1590 17.0005
R3108 VSS.n2246 VSS.n1588 17.0005
R3109 VSS.n2246 VSS.n1586 17.0005
R3110 VSS.n2246 VSS.n1584 17.0005
R3111 VSS.n2246 VSS.n1582 17.0005
R3112 VSS.n2246 VSS.n1579 17.0005
R3113 VSS.n2246 VSS.n1576 17.0005
R3114 VSS.n1968 VSS.n1573 17.0005
R3115 VSS.n2026 VSS.n1573 17.0005
R3116 VSS.n2174 VSS.n1573 17.0005
R3117 VSS.n2024 VSS.n1573 17.0005
R3118 VSS.n2172 VSS.n1573 17.0005
R3119 VSS.n2020 VSS.n1573 17.0005
R3120 VSS.n2028 VSS.n1573 17.0005
R3121 VSS.n1974 VSS.n1970 17.0005
R3122 VSS.n1971 VSS.n1970 17.0005
R3123 VSS.n2166 VSS.n1970 17.0005
R3124 VSS.n1890 VSS.n1573 17.0005
R3125 VSS.n1933 VSS.n1573 17.0005
R3126 VSS.n1797 VSS.n1573 17.0005
R3127 VSS.n1794 VSS.n1573 17.0005
R3128 VSS.n1792 VSS.n1573 17.0005
R3129 VSS.n1791 VSS.n1573 17.0005
R3130 VSS.n1683 VSS.n1573 17.0005
R3131 VSS.n1677 VSS.n1573 17.0005
R3132 VSS.n1675 VSS.n1573 17.0005
R3133 VSS.n2211 VSS.n1573 17.0005
R3134 VSS.n1660 VSS.n1573 17.0005
R3135 VSS.n1658 VSS.n1573 17.0005
R3136 VSS.n1715 VSS.n1573 17.0005
R3137 VSS.n1716 VSS.n1573 17.0005
R3138 VSS.n1717 VSS.n1573 17.0005
R3139 VSS.n2241 VSS.n2240 17.0005
R3140 VSS.n2240 VSS.n1683 17.0005
R3141 VSS.n2240 VSS.n1684 17.0005
R3142 VSS.n2240 VSS.n1682 17.0005
R3143 VSS.n2240 VSS.n1685 17.0005
R3144 VSS.n2240 VSS.n1681 17.0005
R3145 VSS.n2240 VSS.n1686 17.0005
R3146 VSS.n2240 VSS.n1680 17.0005
R3147 VSS.n2240 VSS.n1687 17.0005
R3148 VSS.n2240 VSS.n1679 17.0005
R3149 VSS.n2240 VSS.n1688 17.0005
R3150 VSS.n2240 VSS.n1678 17.0005
R3151 VSS.n2240 VSS.n1689 17.0005
R3152 VSS.n2240 VSS.n1677 17.0005
R3153 VSS.n2240 VSS.n1690 17.0005
R3154 VSS.n2240 VSS.n1676 17.0005
R3155 VSS.n2240 VSS.n1696 17.0005
R3156 VSS.n2240 VSS.n1675 17.0005
R3157 VSS.n2240 VSS.n1697 17.0005
R3158 VSS.n2240 VSS.n1674 17.0005
R3159 VSS.n2240 VSS.n1698 17.0005
R3160 VSS.n2240 VSS.n1673 17.0005
R3161 VSS.n2240 VSS.n1699 17.0005
R3162 VSS.n2240 VSS.n1672 17.0005
R3163 VSS.n2240 VSS.n1700 17.0005
R3164 VSS.n2240 VSS.n1671 17.0005
R3165 VSS.n2240 VSS.n1701 17.0005
R3166 VSS.n2240 VSS.n1670 17.0005
R3167 VSS.n2218 VSS.n2217 17.0005
R3168 VSS.n2218 VSS.n2214 17.0005
R3169 VSS.n2218 VSS.n2212 17.0005
R3170 VSS.n2218 VSS.n2209 17.0005
R3171 VSS.n2218 VSS.n2207 17.0005
R3172 VSS.n2218 VSS.n2200 17.0005
R3173 VSS.n2218 VSS.n2198 17.0005
R3174 VSS.n2218 VSS.n2197 17.0005
R3175 VSS.n2218 VSS.n2195 17.0005
R3176 VSS.n2218 VSS.n2194 17.0005
R3177 VSS.n2218 VSS.n2192 17.0005
R3178 VSS.n2218 VSS.n1943 17.0005
R3179 VSS.n2218 VSS.n1941 17.0005
R3180 VSS.n2218 VSS.n1939 17.0005
R3181 VSS.n2218 VSS.n1937 17.0005
R3182 VSS.n2218 VSS.n1935 17.0005
R3183 VSS.n2218 VSS.n1933 17.0005
R3184 VSS.n2218 VSS.n1932 17.0005
R3185 VSS.n2218 VSS.n1930 17.0005
R3186 VSS.n2218 VSS.n1928 17.0005
R3187 VSS.n2218 VSS.n1926 17.0005
R3188 VSS.n2218 VSS.n1924 17.0005
R3189 VSS.n2218 VSS.n1922 17.0005
R3190 VSS.n2218 VSS.n1920 17.0005
R3191 VSS.n2218 VSS.n1918 17.0005
R3192 VSS.n2218 VSS.n1916 17.0005
R3193 VSS.n2218 VSS.n1914 17.0005
R3194 VSS.n2218 VSS.n1912 17.0005
R3195 VSS.n2218 VSS.n1910 17.0005
R3196 VSS.n2218 VSS.n1908 17.0005
R3197 VSS.n2218 VSS.n1906 17.0005
R3198 VSS.n2218 VSS.n1904 17.0005
R3199 VSS.n2218 VSS.n1902 17.0005
R3200 VSS.n2218 VSS.n1900 17.0005
R3201 VSS.n2218 VSS.n1898 17.0005
R3202 VSS.n2218 VSS.n1896 17.0005
R3203 VSS.n2218 VSS.n1894 17.0005
R3204 VSS.n2218 VSS.n1892 17.0005
R3205 VSS.n2218 VSS.n1890 17.0005
R3206 VSS.n2218 VSS.n1889 17.0005
R3207 VSS.n2218 VSS.n1885 17.0005
R3208 VSS.n2232 VSS.n1644 17.0005
R3209 VSS.n2232 VSS.n1732 17.0005
R3210 VSS.n2232 VSS.n1646 17.0005
R3211 VSS.n2232 VSS.n1727 17.0005
R3212 VSS.n2232 VSS.n1648 17.0005
R3213 VSS.n2232 VSS.n1755 17.0005
R3214 VSS.n2232 VSS.n1754 17.0005
R3215 VSS.n2232 VSS.n1753 17.0005
R3216 VSS.n2232 VSS.n1752 17.0005
R3217 VSS.n2232 VSS.n1751 17.0005
R3218 VSS.n2232 VSS.n1750 17.0005
R3219 VSS.n2232 VSS.n1749 17.0005
R3220 VSS.n2232 VSS.n1748 17.0005
R3221 VSS.n1813 VSS.n1767 17.0005
R3222 VSS.n1789 VSS.n1767 17.0005
R3223 VSS.n1767 VSS.n1748 17.0005
R3224 VSS.n1767 VSS.n1749 17.0005
R3225 VSS.n1767 VSS.n1750 17.0005
R3226 VSS.n1783 VSS.n1767 17.0005
R3227 VSS.n1767 VSS.n1751 17.0005
R3228 VSS.n1781 VSS.n1767 17.0005
R3229 VSS.n1767 VSS.n1752 17.0005
R3230 VSS.n1779 VSS.n1767 17.0005
R3231 VSS.n1767 VSS.n1753 17.0005
R3232 VSS.n1777 VSS.n1767 17.0005
R3233 VSS.n1767 VSS.n1754 17.0005
R3234 VSS.n1775 VSS.n1767 17.0005
R3235 VSS.n1767 VSS.n1755 17.0005
R3236 VSS.n1773 VSS.n1767 17.0005
R3237 VSS.n1767 VSS.n1648 17.0005
R3238 VSS.n1767 VSS.n1727 17.0005
R3239 VSS.n1767 VSS.n1646 17.0005
R3240 VSS.n1767 VSS.n1732 17.0005
R3241 VSS.n1767 VSS.n1644 17.0005
R3242 VSS.n2230 VSS.n1767 17.0005
R3243 VSS.n2232 VSS.n2231 17.0005
R3244 VSS.n2228 VSS.n1794 17.0005
R3245 VSS.n2228 VSS.n1796 17.0005
R3246 VSS.n2228 VSS.n1792 17.0005
R3247 VSS.n2228 VSS.n1790 17.0005
R3248 VSS.n2228 VSS.n1791 17.0005
R3249 VSS.n2228 VSS.n1788 17.0005
R3250 VSS.n2228 VSS.n1786 17.0005
R3251 VSS.n2228 VSS.n1784 17.0005
R3252 VSS.n2228 VSS.n1654 17.0005
R3253 VSS.n2228 VSS.n1782 17.0005
R3254 VSS.n2228 VSS.n1719 17.0005
R3255 VSS.n2228 VSS.n1780 17.0005
R3256 VSS.n2228 VSS.n1652 17.0005
R3257 VSS.n2228 VSS.n1778 17.0005
R3258 VSS.n2228 VSS.n1721 17.0005
R3259 VSS.n2228 VSS.n1776 17.0005
R3260 VSS.n2228 VSS.n1650 17.0005
R3261 VSS.n2228 VSS.n1774 17.0005
R3262 VSS.n2228 VSS.n1724 17.0005
R3263 VSS.n2228 VSS.n1648 17.0005
R3264 VSS.n2228 VSS.n1727 17.0005
R3265 VSS.n2228 VSS.n1646 17.0005
R3266 VSS.n2228 VSS.n1732 17.0005
R3267 VSS.n1883 VSS.n1836 17.0005
R3268 VSS.n2220 VSS.n1883 17.0005
R3269 VSS.n1881 VSS.n1880 17.0005
R3270 VSS.n1878 VSS.n1836 17.0005
R3271 VSS.n1879 VSS.n1878 17.0005
R3272 VSS.n1876 VSS.n1836 17.0005
R3273 VSS.n1876 VSS.n1875 17.0005
R3274 VSS.n2240 VSS.n1702 17.0005
R3275 VSS.n2240 VSS.n1669 17.0005
R3276 VSS.n2240 VSS.n1703 17.0005
R3277 VSS.n2240 VSS.n1668 17.0005
R3278 VSS.n2240 VSS.n1704 17.0005
R3279 VSS.n2240 VSS.n1667 17.0005
R3280 VSS.n2240 VSS.n1705 17.0005
R3281 VSS.n2240 VSS.n1666 17.0005
R3282 VSS.n2240 VSS.n1706 17.0005
R3283 VSS.n2240 VSS.n1665 17.0005
R3284 VSS.n2240 VSS.n1707 17.0005
R3285 VSS.n2240 VSS.n1664 17.0005
R3286 VSS.n2240 VSS.n1708 17.0005
R3287 VSS.n2240 VSS.n1663 17.0005
R3288 VSS.n2240 VSS.n1709 17.0005
R3289 VSS.n2240 VSS.n1662 17.0005
R3290 VSS.n2240 VSS.n1710 17.0005
R3291 VSS.n2240 VSS.n1661 17.0005
R3292 VSS.n2240 VSS.n1711 17.0005
R3293 VSS.n2240 VSS.n1660 17.0005
R3294 VSS.n2240 VSS.n1712 17.0005
R3295 VSS.n2240 VSS.n1658 17.0005
R3296 VSS.n2240 VSS.n1714 17.0005
R3297 VSS.n2240 VSS.n1715 17.0005
R3298 VSS.n2240 VSS.n1657 17.0005
R3299 VSS.n2240 VSS.n1656 17.0005
R3300 VSS.n2240 VSS.n1716 17.0005
R3301 VSS.n2240 VSS.n1717 17.0005
R3302 VSS.n2240 VSS.n1655 17.0005
R3303 VSS.n2240 VSS.n1654 17.0005
R3304 VSS.n2240 VSS.n1718 17.0005
R3305 VSS.n2240 VSS.n1719 17.0005
R3306 VSS.n2240 VSS.n1653 17.0005
R3307 VSS.n2240 VSS.n1652 17.0005
R3308 VSS.n2240 VSS.n1720 17.0005
R3309 VSS.n2240 VSS.n1721 17.0005
R3310 VSS.n2240 VSS.n1651 17.0005
R3311 VSS.n2240 VSS.n1650 17.0005
R3312 VSS.n2240 VSS.n1722 17.0005
R3313 VSS.n2240 VSS.n1724 17.0005
R3314 VSS.n2240 VSS.n1649 17.0005
R3315 VSS.n2240 VSS.n1648 17.0005
R3316 VSS.n2240 VSS.n1725 17.0005
R3317 VSS.n2240 VSS.n1727 17.0005
R3318 VSS.n2240 VSS.n1647 17.0005
R3319 VSS.n2240 VSS.n1646 17.0005
R3320 VSS.n2240 VSS.n1730 17.0005
R3321 VSS.n2240 VSS.n1732 17.0005
R3322 VSS.n2240 VSS.n1645 17.0005
R3323 VSS.n2240 VSS.n1644 17.0005
R3324 VSS.n2240 VSS.n1735 17.0005
R3325 VSS.n2240 VSS.n1737 17.0005
R3326 VSS.n2240 VSS.n1643 17.0005
R3327 VSS.n2240 VSS.n1642 17.0005
R3328 VSS.n2240 VSS.n2239 17.0005
R3329 VSS.n1977 VSS.n1970 17.0005
R3330 VSS.n2151 VSS.n2150 17.0005
R3331 VSS.n2150 VSS.n2149 17.0005
R3332 VSS.n1998 VSS.n1984 17.0005
R3333 VSS.n1999 VSS.n1998 17.0005
R3334 VSS.n2002 VSS.n2001 17.0005
R3335 VSS.n2003 VSS.n2002 17.0005
R3336 VSS.n2154 VSS.n2153 17.0005
R3337 VSS.n2153 VSS.n2152 17.0005
R3338 VSS.n2147 VSS.n1981 17.0005
R3339 VSS.n2148 VSS.n2147 17.0005
R3340 VSS.n1997 VSS.n1985 17.0005
R3341 VSS.n2000 VSS.n1985 17.0005
R3342 VSS.n2005 VSS.n2004 17.0005
R3343 VSS.n2006 VSS.n2005 17.0005
R3344 VSS.n2017 VSS.n1992 17.0005
R3345 VSS.n2017 VSS.n2016 17.0005
R3346 VSS.n2015 VSS.n1573 17.0005
R3347 VSS.n2013 VSS.n1573 17.0005
R3348 VSS.n1601 VSS.n1573 17.0005
R3349 VSS.n1606 VSS.n1573 17.0005
R3350 VSS.n1632 VSS.n1573 17.0005
R3351 VSS.n1608 VSS.n1573 17.0005
R3352 VSS.n1609 VSS.n1573 17.0005
R3353 VSS.n1610 VSS.n1573 17.0005
R3354 VSS.n1611 VSS.n1573 17.0005
R3355 VSS.n1612 VSS.n1573 17.0005
R3356 VSS.n1613 VSS.n1573 17.0005
R3357 VSS.n1614 VSS.n1573 17.0005
R3358 VSS.n1615 VSS.n1573 17.0005
R3359 VSS.n1626 VSS.n1573 17.0005
R3360 VSS.n1639 VSS.n1573 17.0005
R3361 VSS.n1637 VSS.n1573 17.0005
R3362 VSS.n2053 VSS.n2052 17.0005
R3363 VSS.n2052 VSS.n2051 17.0005
R3364 VSS.n2062 VSS.n2045 17.0005
R3365 VSS.n2062 VSS.n2061 17.0005
R3366 VSS.n1059 VSS.n929 17.0005
R3367 VSS.n1059 VSS.n928 17.0005
R3368 VSS.n1059 VSS.n930 17.0005
R3369 VSS.n1059 VSS.n931 17.0005
R3370 VSS.n1059 VSS.n933 17.0005
R3371 VSS.n1059 VSS.n932 17.0005
R3372 VSS.n1059 VSS.n934 17.0005
R3373 VSS.n1059 VSS.n935 17.0005
R3374 VSS.n1059 VSS.n937 17.0005
R3375 VSS.n1059 VSS.n936 17.0005
R3376 VSS.n1059 VSS.n938 17.0005
R3377 VSS.n1059 VSS.n939 17.0005
R3378 VSS.n1059 VSS.n941 17.0005
R3379 VSS.n1059 VSS.n940 17.0005
R3380 VSS.n1059 VSS.n942 17.0005
R3381 VSS.n1059 VSS.n943 17.0005
R3382 VSS.n1059 VSS.n945 17.0005
R3383 VSS.n1059 VSS.n944 17.0005
R3384 VSS.n1059 VSS.n946 17.0005
R3385 VSS.n1059 VSS.n947 17.0005
R3386 VSS.n1059 VSS.n949 17.0005
R3387 VSS.n1059 VSS.n948 17.0005
R3388 VSS.n1059 VSS.n950 17.0005
R3389 VSS.n1059 VSS.n951 17.0005
R3390 VSS.n1059 VSS.n953 17.0005
R3391 VSS.n1059 VSS.n952 17.0005
R3392 VSS.n1059 VSS.n954 17.0005
R3393 VSS.n1059 VSS.n955 17.0005
R3394 VSS.n1059 VSS.n957 17.0005
R3395 VSS.n1059 VSS.n956 17.0005
R3396 VSS.n1059 VSS.n961 17.0005
R3397 VSS.n1059 VSS.n962 17.0005
R3398 VSS.n1059 VSS.n964 17.0005
R3399 VSS.n1059 VSS.n963 17.0005
R3400 VSS.n1059 VSS.n965 17.0005
R3401 VSS.n1059 VSS.n966 17.0005
R3402 VSS.n1059 VSS.n968 17.0005
R3403 VSS.n1059 VSS.n967 17.0005
R3404 VSS.n1059 VSS.n969 17.0005
R3405 VSS.n1059 VSS.n970 17.0005
R3406 VSS.n1059 VSS.n972 17.0005
R3407 VSS.n1059 VSS.n971 17.0005
R3408 VSS.n1059 VSS.n973 17.0005
R3409 VSS.n1059 VSS.n974 17.0005
R3410 VSS.n1059 VSS.n976 17.0005
R3411 VSS.n1059 VSS.n975 17.0005
R3412 VSS.n1059 VSS.n977 17.0005
R3413 VSS.n1059 VSS.n978 17.0005
R3414 VSS.n1059 VSS.n980 17.0005
R3415 VSS.n1059 VSS.n979 17.0005
R3416 VSS.n1059 VSS.n981 17.0005
R3417 VSS.n1059 VSS.n982 17.0005
R3418 VSS.n1059 VSS.n984 17.0005
R3419 VSS.n1059 VSS.n983 17.0005
R3420 VSS.n1059 VSS.n985 17.0005
R3421 VSS.n1059 VSS.n986 17.0005
R3422 VSS.n1059 VSS.n988 17.0005
R3423 VSS.n1059 VSS.n987 17.0005
R3424 VSS.n1059 VSS.n989 17.0005
R3425 VSS.n1059 VSS.n990 17.0005
R3426 VSS.n1059 VSS.n993 17.0005
R3427 VSS.n1059 VSS.n992 17.0005
R3428 VSS.n1034 VSS.n1030 17.0005
R3429 VSS.n1034 VSS.n1031 17.0005
R3430 VSS.n1034 VSS.n1029 17.0005
R3431 VSS.n1034 VSS.n1028 17.0005
R3432 VSS.n1034 VSS.n1032 17.0005
R3433 VSS.n1034 VSS.n1033 17.0005
R3434 VSS.n1034 VSS.n1027 17.0005
R3435 VSS.n1034 VSS.n1026 17.0005
R3436 VSS.n1040 VSS.n1019 17.0005
R3437 VSS.n1040 VSS.n1020 17.0005
R3438 VSS.n1040 VSS.n1018 17.0005
R3439 VSS.n1040 VSS.n1016 17.0005
R3440 VSS.n1040 VSS.n1014 17.0005
R3441 VSS.n1040 VSS.n1015 17.0005
R3442 VSS.n1040 VSS.n1013 17.0005
R3443 VSS.n1040 VSS.n1012 17.0005
R3444 VSS.n1040 VSS.n1010 17.0005
R3445 VSS.n1040 VSS.n1011 17.0005
R3446 VSS.n1062 VSS.n919 17.0005
R3447 VSS.n1062 VSS.n920 17.0005
R3448 VSS.n1062 VSS.n917 17.0005
R3449 VSS.n1062 VSS.n916 17.0005
R3450 VSS.n1062 VSS.n914 17.0005
R3451 VSS.n1062 VSS.n915 17.0005
R3452 VSS.n1062 VSS.n912 17.0005
R3453 VSS.n1062 VSS.n911 17.0005
R3454 VSS.n1062 VSS.n909 17.0005
R3455 VSS.n1062 VSS.n910 17.0005
R3456 VSS.n1068 VSS.n902 17.0005
R3457 VSS.n1068 VSS.n903 17.0005
R3458 VSS.n1068 VSS.n901 17.0005
R3459 VSS.n1068 VSS.n900 17.0005
R3460 VSS.n1068 VSS.n898 17.0005
R3461 VSS.n1068 VSS.n899 17.0005
R3462 VSS.n1068 VSS.n896 17.0005
R3463 VSS.n1068 VSS.n895 17.0005
R3464 VSS.n3355 VSS.n3236 17.0005
R3465 VSS.n3355 VSS.n3238 17.0005
R3466 VSS.n3355 VSS.n3234 17.0005
R3467 VSS.n3355 VSS.n3231 17.0005
R3468 VSS.n3355 VSS.n3228 17.0005
R3469 VSS.n3355 VSS.n3230 17.0005
R3470 VSS.n3355 VSS.n3226 17.0005
R3471 VSS.n3355 VSS.n3225 17.0005
R3472 VSS.n3356 VSS.n3355 17.0005
R3473 VSS.n3355 VSS.n3213 17.0005
R3474 VSS.n3366 VSS.n3207 17.0005
R3475 VSS.n3217 VSS.n3207 17.0005
R3476 VSS.n3368 VSS.n3207 17.0005
R3477 VSS.n3215 VSS.n3207 17.0005
R3478 VSS.n3371 VSS.n3207 17.0005
R3479 VSS.n3207 VSS.n3206 17.0005
R3480 VSS.n3373 VSS.n3207 17.0005
R3481 VSS.n3207 VSS.n3204 17.0005
R3482 VSS.n3375 VSS.n3207 17.0005
R3483 VSS.n3207 VSS.n3202 17.0005
R3484 VSS.n3303 VSS.n3302 17.0005
R3485 VSS.n3315 VSS.n3303 17.0005
R3486 VSS.n3303 VSS.n3296 17.0005
R3487 VSS.n3317 VSS.n3303 17.0005
R3488 VSS.n3303 VSS.n3294 17.0005
R3489 VSS.n3319 VSS.n3303 17.0005
R3490 VSS.n3303 VSS.n3291 17.0005
R3491 VSS.n3321 VSS.n3303 17.0005
R3492 VSS.n3303 VSS.n3289 17.0005
R3493 VSS.n3323 VSS.n3303 17.0005
R3494 VSS.n3303 VSS.n3287 17.0005
R3495 VSS.n3325 VSS.n3303 17.0005
R3496 VSS.n3303 VSS.n3283 17.0005
R3497 VSS.n3327 VSS.n3303 17.0005
R3498 VSS.n3303 VSS.n3281 17.0005
R3499 VSS.n3329 VSS.n3303 17.0005
R3500 VSS.n3303 VSS.n3279 17.0005
R3501 VSS.n3331 VSS.n3303 17.0005
R3502 VSS.n3303 VSS.n3276 17.0005
R3503 VSS.n3333 VSS.n3303 17.0005
R3504 VSS.n3303 VSS.n3274 17.0005
R3505 VSS.n3335 VSS.n3303 17.0005
R3506 VSS.n3303 VSS.n3272 17.0005
R3507 VSS.n3337 VSS.n3303 17.0005
R3508 VSS.n3303 VSS.n3269 17.0005
R3509 VSS.n3339 VSS.n3303 17.0005
R3510 VSS.n3303 VSS.n3267 17.0005
R3511 VSS.n3341 VSS.n3303 17.0005
R3512 VSS.n3303 VSS.n3265 17.0005
R3513 VSS.n3343 VSS.n3303 17.0005
R3514 VSS.n3133 VSS.n607 17.0005
R3515 VSS.n3133 VSS.n606 17.0005
R3516 VSS.n3133 VSS.n609 17.0005
R3517 VSS.n3133 VSS.n610 17.0005
R3518 VSS.n3133 VSS.n613 17.0005
R3519 VSS.n3133 VSS.n611 17.0005
R3520 VSS.n3133 VSS.n616 17.0005
R3521 VSS.n3133 VSS.n617 17.0005
R3522 VSS.n3133 VSS.n620 17.0005
R3523 VSS.n3133 VSS.n618 17.0005
R3524 VSS.n3133 VSS.n622 17.0005
R3525 VSS.n3133 VSS.n623 17.0005
R3526 VSS.n3133 VSS.n627 17.0005
R3527 VSS.n3133 VSS.n624 17.0005
R3528 VSS.n3133 VSS.n629 17.0005
R3529 VSS.n3133 VSS.n630 17.0005
R3530 VSS.n3133 VSS.n633 17.0005
R3531 VSS.n3133 VSS.n631 17.0005
R3532 VSS.n3133 VSS.n637 17.0005
R3533 VSS.n3133 VSS.n638 17.0005
R3534 VSS.n3133 VSS.n641 17.0005
R3535 VSS.n3133 VSS.n639 17.0005
R3536 VSS.n3133 VSS.n643 17.0005
R3537 VSS.n3133 VSS.n644 17.0005
R3538 VSS.n3133 VSS.n648 17.0005
R3539 VSS.n3133 VSS.n645 17.0005
R3540 VSS.n3133 VSS.n650 17.0005
R3541 VSS.n3133 VSS.n651 17.0005
R3542 VSS.n3134 VSS.n3133 17.0005
R3543 VSS.n3133 VSS.n652 17.0005
R3544 VSS.n3133 VSS.n653 17.0005
R3545 VSS.n3133 VSS.n654 17.0005
R3546 VSS.n3133 VSS.n655 17.0005
R3547 VSS.n3110 VSS.n2618 17.0005
R3548 VSS.n2618 VSS.n2616 17.0005
R3549 VSS.n3112 VSS.n2618 17.0005
R3550 VSS.n2618 VSS.n2615 17.0005
R3551 VSS.n3114 VSS.n2618 17.0005
R3552 VSS.n2618 VSS.n2614 17.0005
R3553 VSS.n3117 VSS.n2618 17.0005
R3554 VSS.n2618 VSS.n2613 17.0005
R3555 VSS.n3119 VSS.n2618 17.0005
R3556 VSS.n2618 VSS.n2612 17.0005
R3557 VSS.n3126 VSS.n2601 17.0005
R3558 VSS.n3126 VSS.n2602 17.0005
R3559 VSS.n3126 VSS.n2599 17.0005
R3560 VSS.n3126 VSS.n2597 17.0005
R3561 VSS.n3126 VSS.n2595 17.0005
R3562 VSS.n3126 VSS.n2596 17.0005
R3563 VSS.n3126 VSS.n2592 17.0005
R3564 VSS.n3126 VSS.n2591 17.0005
R3565 VSS.n3127 VSS.n3126 17.0005
R3566 VSS.n3126 VSS.n2588 17.0005
R3567 VSS.n3102 VSS.n2629 17.0005
R3568 VSS.n3102 VSS.n2630 17.0005
R3569 VSS.n3102 VSS.n2631 17.0005
R3570 VSS.n3102 VSS.n2632 17.0005
R3571 VSS.n3102 VSS.n2633 17.0005
R3572 VSS.n3102 VSS.n2636 17.0005
R3573 VSS.n3102 VSS.n2634 17.0005
R3574 VSS.n3102 VSS.n2638 17.0005
R3575 VSS.n3102 VSS.n2639 17.0005
R3576 VSS.n3102 VSS.n2643 17.0005
R3577 VSS.n3102 VSS.n2640 17.0005
R3578 VSS.n3102 VSS.n2645 17.0005
R3579 VSS.n3102 VSS.n2646 17.0005
R3580 VSS.n3102 VSS.n2649 17.0005
R3581 VSS.n3102 VSS.n2647 17.0005
R3582 VSS.n3102 VSS.n2653 17.0005
R3583 VSS.n3102 VSS.n2654 17.0005
R3584 VSS.n3102 VSS.n2657 17.0005
R3585 VSS.n3102 VSS.n2655 17.0005
R3586 VSS.n3102 VSS.n2659 17.0005
R3587 VSS.n3102 VSS.n2660 17.0005
R3588 VSS.n3102 VSS.n2664 17.0005
R3589 VSS.n3102 VSS.n2661 17.0005
R3590 VSS.n3102 VSS.n2666 17.0005
R3591 VSS.n3102 VSS.n2667 17.0005
R3592 VSS.n3102 VSS.n2670 17.0005
R3593 VSS.n3102 VSS.n2668 17.0005
R3594 VSS.n3102 VSS.n2673 17.0005
R3595 VSS.n3102 VSS.n2674 17.0005
R3596 VSS.n3102 VSS.n2677 17.0005
R3597 VSS.n3102 VSS.n2675 17.0005
R3598 VSS.n3103 VSS.n3102 17.0005
R3599 VSS.n3102 VSS.n2678 17.0005
R3600 VSS.n3062 VSS.n2742 17.0005
R3601 VSS.n3048 VSS.n3047 17.0005
R3602 VSS.n3048 VSS.n2783 17.0005
R3603 VSS.n3048 VSS.n2780 17.0005
R3604 VSS.n3064 VSS.n415 17.0005
R3605 VSS.n3066 VSS.n415 17.0005
R3606 VSS.n3073 VSS.n3067 17.0005
R3607 VSS.n3073 VSS.n3072 17.0005
R3608 VSS.n2703 VSS.n2702 17.0005
R3609 VSS.n2704 VSS.n2703 17.0005
R3610 VSS.n2708 VSS.n2707 17.0005
R3611 VSS.n2709 VSS.n2708 17.0005
R3612 VSS.n2717 VSS.n2712 17.0005
R3613 VSS.n2717 VSS.n2716 17.0005
R3614 VSS.n2722 VSS.n2721 17.0005
R3615 VSS.n2722 VSS.n2690 17.0005
R3616 VSS.n3084 VSS.n3083 17.0005
R3617 VSS.n3083 VSS.n3082 17.0005
R3618 VSS.n2693 VSS.n474 17.0005
R3619 VSS.n2732 VSS.n2693 17.0005
R3620 VSS.n3062 VSS.n2728 17.0005
R3621 VSS.n3161 VSS.n519 17.0005
R3622 VSS.n3161 VSS.n520 17.0005
R3623 VSS.n3161 VSS.n521 17.0005
R3624 VSS.n3161 VSS.n522 17.0005
R3625 VSS.n3161 VSS.n523 17.0005
R3626 VSS.n3161 VSS.n524 17.0005
R3627 VSS.n3161 VSS.n525 17.0005
R3628 VSS.n3161 VSS.n529 17.0005
R3629 VSS.n3161 VSS.n530 17.0005
R3630 VSS.n3161 VSS.n531 17.0005
R3631 VSS.n3161 VSS.n532 17.0005
R3632 VSS.n3161 VSS.n533 17.0005
R3633 VSS.n3161 VSS.n534 17.0005
R3634 VSS.n3161 VSS.n535 17.0005
R3635 VSS.n3161 VSS.n536 17.0005
R3636 VSS.n3161 VSS.n537 17.0005
R3637 VSS.n3161 VSS.n538 17.0005
R3638 VSS.n3161 VSS.n540 17.0005
R3639 VSS.n3161 VSS.n541 17.0005
R3640 VSS.n3161 VSS.n542 17.0005
R3641 VSS.n3161 VSS.n543 17.0005
R3642 VSS.n3161 VSS.n547 17.0005
R3643 VSS.n3161 VSS.n548 17.0005
R3644 VSS.n3161 VSS.n549 17.0005
R3645 VSS.n3161 VSS.n550 17.0005
R3646 VSS.n3161 VSS.n551 17.0005
R3647 VSS.n3161 VSS.n552 17.0005
R3648 VSS.n3161 VSS.n553 17.0005
R3649 VSS.n3161 VSS.n556 17.0005
R3650 VSS.n2735 VSS.n583 17.0005
R3651 VSS.n583 VSS.n474 17.0005
R3652 VSS.n583 VSS.n473 17.0005
R3653 VSS.n3079 VSS.n583 17.0005
R3654 VSS.n3082 VSS.n583 17.0005
R3655 VSS.n3086 VSS.n583 17.0005
R3656 VSS.n2720 VSS.n583 17.0005
R3657 VSS.n2715 VSS.n583 17.0005
R3658 VSS.n2714 VSS.n583 17.0005
R3659 VSS.n2710 VSS.n583 17.0005
R3660 VSS.n2706 VSS.n583 17.0005
R3661 VSS.n2705 VSS.n583 17.0005
R3662 VSS.n2701 VSS.n583 17.0005
R3663 VSS.n3157 VSS.n568 17.0005
R3664 VSS.n583 VSS.n553 17.0005
R3665 VSS.n583 VSS.n552 17.0005
R3666 VSS.n583 VSS.n550 17.0005
R3667 VSS.n583 VSS.n549 17.0005
R3668 VSS.n583 VSS.n548 17.0005
R3669 VSS.n601 VSS.n583 17.0005
R3670 VSS.n583 VSS.n547 17.0005
R3671 VSS.n649 VSS.n583 17.0005
R3672 VSS.n583 VSS.n543 17.0005
R3673 VSS.n647 VSS.n583 17.0005
R3674 VSS.n583 VSS.n542 17.0005
R3675 VSS.n642 VSS.n583 17.0005
R3676 VSS.n583 VSS.n541 17.0005
R3677 VSS.n640 VSS.n583 17.0005
R3678 VSS.n583 VSS.n540 17.0005
R3679 VSS.n636 VSS.n583 17.0005
R3680 VSS.n660 VSS.n583 17.0005
R3681 VSS.n634 VSS.n583 17.0005
R3682 VSS.n661 VSS.n583 17.0005
R3683 VSS.n632 VSS.n583 17.0005
R3684 VSS.n583 VSS.n538 17.0005
R3685 VSS.n628 VSS.n583 17.0005
R3686 VSS.n583 VSS.n537 17.0005
R3687 VSS.n625 VSS.n583 17.0005
R3688 VSS.n583 VSS.n536 17.0005
R3689 VSS.n621 VSS.n583 17.0005
R3690 VSS.n583 VSS.n535 17.0005
R3691 VSS.n619 VSS.n583 17.0005
R3692 VSS.n583 VSS.n534 17.0005
R3693 VSS.n614 VSS.n583 17.0005
R3694 VSS.n583 VSS.n533 17.0005
R3695 VSS.n612 VSS.n583 17.0005
R3696 VSS.n583 VSS.n532 17.0005
R3697 VSS.n608 VSS.n583 17.0005
R3698 VSS.n583 VSS.n531 17.0005
R3699 VSS.n2585 VSS.n583 17.0005
R3700 VSS.n583 VSS.n530 17.0005
R3701 VSS.n583 VSS.n529 17.0005
R3702 VSS.n583 VSS.n575 17.0005
R3703 VSS.n3128 VSS.n583 17.0005
R3704 VSS.n583 VSS.n524 17.0005
R3705 VSS.n2587 VSS.n583 17.0005
R3706 VSS.n583 VSS.n523 17.0005
R3707 VSS.n2594 VSS.n583 17.0005
R3708 VSS.n583 VSS.n522 17.0005
R3709 VSS.n2598 VSS.n583 17.0005
R3710 VSS.n583 VSS.n521 17.0005
R3711 VSS.n2600 VSS.n583 17.0005
R3712 VSS.n583 VSS.n520 17.0005
R3713 VSS.n2605 VSS.n583 17.0005
R3714 VSS.n583 VSS.n519 17.0005
R3715 VSS.n2603 VSS.n583 17.0005
R3716 VSS.n2609 VSS.n583 17.0005
R3717 VSS.n3120 VSS.n583 17.0005
R3718 VSS.n583 VSS.n516 17.0005
R3719 VSS.n3118 VSS.n583 17.0005
R3720 VSS.n583 VSS.n515 17.0005
R3721 VSS.n3116 VSS.n583 17.0005
R3722 VSS.n583 VSS.n514 17.0005
R3723 VSS.n3113 VSS.n583 17.0005
R3724 VSS.n583 VSS.n513 17.0005
R3725 VSS.n3111 VSS.n583 17.0005
R3726 VSS.n583 VSS.n512 17.0005
R3727 VSS.n3109 VSS.n583 17.0005
R3728 VSS.n583 VSS.n511 17.0005
R3729 VSS.n3107 VSS.n583 17.0005
R3730 VSS.n583 VSS.n582 17.0005
R3731 VSS.n583 VSS.n506 17.0005
R3732 VSS.n3104 VSS.n583 17.0005
R3733 VSS.n583 VSS.n505 17.0005
R3734 VSS.n2625 VSS.n583 17.0005
R3735 VSS.n583 VSS.n504 17.0005
R3736 VSS.n2676 VSS.n583 17.0005
R3737 VSS.n583 VSS.n503 17.0005
R3738 VSS.n2672 VSS.n583 17.0005
R3739 VSS.n583 VSS.n502 17.0005
R3740 VSS.n2669 VSS.n583 17.0005
R3741 VSS.n583 VSS.n501 17.0005
R3742 VSS.n2665 VSS.n583 17.0005
R3743 VSS.n583 VSS.n500 17.0005
R3744 VSS.n2663 VSS.n583 17.0005
R3745 VSS.n583 VSS.n499 17.0005
R3746 VSS.n2658 VSS.n583 17.0005
R3747 VSS.n583 VSS.n498 17.0005
R3748 VSS.n2656 VSS.n583 17.0005
R3749 VSS.n583 VSS.n497 17.0005
R3750 VSS.n2652 VSS.n583 17.0005
R3751 VSS.n2650 VSS.n583 17.0005
R3752 VSS.n2648 VSS.n583 17.0005
R3753 VSS.n583 VSS.n494 17.0005
R3754 VSS.n2644 VSS.n583 17.0005
R3755 VSS.n583 VSS.n493 17.0005
R3756 VSS.n2641 VSS.n583 17.0005
R3757 VSS.n583 VSS.n492 17.0005
R3758 VSS.n2637 VSS.n583 17.0005
R3759 VSS.n583 VSS.n491 17.0005
R3760 VSS.n2635 VSS.n583 17.0005
R3761 VSS.n583 VSS.n490 17.0005
R3762 VSS.n583 VSS.n489 17.0005
R3763 VSS.n583 VSS.n488 17.0005
R3764 VSS.n583 VSS.n487 17.0005
R3765 VSS.n583 VSS.n486 17.0005
R3766 VSS.n583 VSS.n485 17.0005
R3767 VSS.n3152 VSS.n3151 17.0005
R3768 VSS.n3151 VSS.n3150 17.0005
R3769 VSS.n3149 VSS.n3148 17.0005
R3770 VSS.n3148 VSS.n3147 17.0005
R3771 VSS.n3145 VSS.n3144 17.0005
R3772 VSS.n3144 VSS.n3143 17.0005
R3773 VSS.n595 VSS.n594 17.0005
R3774 VSS.n594 VSS.n593 17.0005
R3775 VSS.n3161 VSS.n516 17.0005
R3776 VSS.n3161 VSS.n515 17.0005
R3777 VSS.n3161 VSS.n514 17.0005
R3778 VSS.n3161 VSS.n513 17.0005
R3779 VSS.n3161 VSS.n512 17.0005
R3780 VSS.n3161 VSS.n511 17.0005
R3781 VSS.n3161 VSS.n510 17.0005
R3782 VSS.n3161 VSS.n506 17.0005
R3783 VSS.n3161 VSS.n505 17.0005
R3784 VSS.n3161 VSS.n504 17.0005
R3785 VSS.n3161 VSS.n503 17.0005
R3786 VSS.n3161 VSS.n502 17.0005
R3787 VSS.n3161 VSS.n501 17.0005
R3788 VSS.n3161 VSS.n500 17.0005
R3789 VSS.n3161 VSS.n499 17.0005
R3790 VSS.n3161 VSS.n498 17.0005
R3791 VSS.n3161 VSS.n497 17.0005
R3792 VSS.n3161 VSS.n496 17.0005
R3793 VSS.n3161 VSS.n495 17.0005
R3794 VSS.n3161 VSS.n494 17.0005
R3795 VSS.n3161 VSS.n493 17.0005
R3796 VSS.n3161 VSS.n492 17.0005
R3797 VSS.n3161 VSS.n491 17.0005
R3798 VSS.n3161 VSS.n490 17.0005
R3799 VSS.n3161 VSS.n489 17.0005
R3800 VSS.n3161 VSS.n488 17.0005
R3801 VSS.n3161 VSS.n487 17.0005
R3802 VSS.n3162 VSS.n3161 17.0005
R3803 VSS.n3161 VSS.n486 17.0005
R3804 VSS.n3161 VSS.n485 17.0005
R3805 VSS.n3161 VSS.n483 17.0005
R3806 VSS.n3161 VSS.n481 17.0005
R3807 VSS.n2727 VSS.n583 17.0005
R3808 VSS.n829 VSS.n708 17.0005
R3809 VSS.n829 VSS.n772 17.0005
R3810 VSS.n829 VSS.n710 17.0005
R3811 VSS.n829 VSS.n770 17.0005
R3812 VSS.n829 VSS.n712 17.0005
R3813 VSS.n829 VSS.n768 17.0005
R3814 VSS.n829 VSS.n714 17.0005
R3815 VSS.n829 VSS.n766 17.0005
R3816 VSS.n829 VSS.n716 17.0005
R3817 VSS.n829 VSS.n764 17.0005
R3818 VSS.n829 VSS.n718 17.0005
R3819 VSS.n829 VSS.n762 17.0005
R3820 VSS.n829 VSS.n720 17.0005
R3821 VSS.n829 VSS.n760 17.0005
R3822 VSS.n829 VSS.n722 17.0005
R3823 VSS.n829 VSS.n758 17.0005
R3824 VSS.n829 VSS.n726 17.0005
R3825 VSS.n829 VSS.n755 17.0005
R3826 VSS.n829 VSS.n728 17.0005
R3827 VSS.n829 VSS.n753 17.0005
R3828 VSS.n829 VSS.n730 17.0005
R3829 VSS.n829 VSS.n751 17.0005
R3830 VSS.n906 VSS.n829 17.0005
R3831 VSS.n829 VSS.n747 17.0005
R3832 VSS.n829 VSS.n734 17.0005
R3833 VSS.n829 VSS.n745 17.0005
R3834 VSS.n829 VSS.n736 17.0005
R3835 VSS.n829 VSS.n743 17.0005
R3836 VSS.n829 VSS.n738 17.0005
R3837 VSS.n884 VSS.n829 17.0005
R3838 VSS.n2573 VSS.n814 17.0005
R3839 VSS.n2573 VSS.n811 17.0005
R3840 VSS.n2573 VSS.n810 17.0005
R3841 VSS.n2573 VSS.n809 17.0005
R3842 VSS.n889 VSS.n867 17.0005
R3843 VSS.n2573 VSS.n739 17.0005
R3844 VSS.n2573 VSS.n741 17.0005
R3845 VSS.n2573 VSS.n738 17.0005
R3846 VSS.n2573 VSS.n743 17.0005
R3847 VSS.n2573 VSS.n737 17.0005
R3848 VSS.n2573 VSS.n736 17.0005
R3849 VSS.n2573 VSS.n744 17.0005
R3850 VSS.n2573 VSS.n745 17.0005
R3851 VSS.n2573 VSS.n735 17.0005
R3852 VSS.n2573 VSS.n734 17.0005
R3853 VSS.n2573 VSS.n746 17.0005
R3854 VSS.n2573 VSS.n747 17.0005
R3855 VSS.n2573 VSS.n733 17.0005
R3856 VSS.n2573 VSS.n750 17.0005
R3857 VSS.n2573 VSS.n751 17.0005
R3858 VSS.n2573 VSS.n731 17.0005
R3859 VSS.n2573 VSS.n730 17.0005
R3860 VSS.n2573 VSS.n752 17.0005
R3861 VSS.n2573 VSS.n753 17.0005
R3862 VSS.n2573 VSS.n729 17.0005
R3863 VSS.n2573 VSS.n728 17.0005
R3864 VSS.n2573 VSS.n754 17.0005
R3865 VSS.n2573 VSS.n755 17.0005
R3866 VSS.n2573 VSS.n727 17.0005
R3867 VSS.n2573 VSS.n726 17.0005
R3868 VSS.n2573 VSS.n756 17.0005
R3869 VSS.n2573 VSS.n724 17.0005
R3870 VSS.n2573 VSS.n757 17.0005
R3871 VSS.n2573 VSS.n758 17.0005
R3872 VSS.n2573 VSS.n723 17.0005
R3873 VSS.n2573 VSS.n722 17.0005
R3874 VSS.n2573 VSS.n759 17.0005
R3875 VSS.n2573 VSS.n760 17.0005
R3876 VSS.n2573 VSS.n721 17.0005
R3877 VSS.n2573 VSS.n720 17.0005
R3878 VSS.n2573 VSS.n761 17.0005
R3879 VSS.n2573 VSS.n762 17.0005
R3880 VSS.n2573 VSS.n719 17.0005
R3881 VSS.n2573 VSS.n718 17.0005
R3882 VSS.n2573 VSS.n763 17.0005
R3883 VSS.n2573 VSS.n764 17.0005
R3884 VSS.n2573 VSS.n717 17.0005
R3885 VSS.n2573 VSS.n716 17.0005
R3886 VSS.n2573 VSS.n765 17.0005
R3887 VSS.n2573 VSS.n766 17.0005
R3888 VSS.n2573 VSS.n715 17.0005
R3889 VSS.n2573 VSS.n714 17.0005
R3890 VSS.n2573 VSS.n767 17.0005
R3891 VSS.n2573 VSS.n768 17.0005
R3892 VSS.n2573 VSS.n713 17.0005
R3893 VSS.n2573 VSS.n712 17.0005
R3894 VSS.n2573 VSS.n769 17.0005
R3895 VSS.n2573 VSS.n770 17.0005
R3896 VSS.n2573 VSS.n711 17.0005
R3897 VSS.n2573 VSS.n710 17.0005
R3898 VSS.n2573 VSS.n771 17.0005
R3899 VSS.n2573 VSS.n772 17.0005
R3900 VSS.n2573 VSS.n709 17.0005
R3901 VSS.n2573 VSS.n708 17.0005
R3902 VSS.n2573 VSS.n773 17.0005
R3903 VSS.n2573 VSS.n774 17.0005
R3904 VSS.n2573 VSS.n707 17.0005
R3905 VSS.n2573 VSS.n706 17.0005
R3906 VSS.n2573 VSS.n775 17.0005
R3907 VSS.n2573 VSS.n776 17.0005
R3908 VSS.n2573 VSS.n705 17.0005
R3909 VSS.n2573 VSS.n704 17.0005
R3910 VSS.n2573 VSS.n777 17.0005
R3911 VSS.n2573 VSS.n778 17.0005
R3912 VSS.n2573 VSS.n703 17.0005
R3913 VSS.n2573 VSS.n702 17.0005
R3914 VSS.n2573 VSS.n779 17.0005
R3915 VSS.n2573 VSS.n780 17.0005
R3916 VSS.n2573 VSS.n701 17.0005
R3917 VSS.n2573 VSS.n700 17.0005
R3918 VSS.n2573 VSS.n781 17.0005
R3919 VSS.n2573 VSS.n782 17.0005
R3920 VSS.n2573 VSS.n699 17.0005
R3921 VSS.n2573 VSS.n698 17.0005
R3922 VSS.n2573 VSS.n783 17.0005
R3923 VSS.n2573 VSS.n784 17.0005
R3924 VSS.n2573 VSS.n697 17.0005
R3925 VSS.n2573 VSS.n696 17.0005
R3926 VSS.n2573 VSS.n785 17.0005
R3927 VSS.n2573 VSS.n786 17.0005
R3928 VSS.n2573 VSS.n695 17.0005
R3929 VSS.n2573 VSS.n694 17.0005
R3930 VSS.n2573 VSS.n787 17.0005
R3931 VSS.n2573 VSS.n788 17.0005
R3932 VSS.n2573 VSS.n693 17.0005
R3933 VSS.n2573 VSS.n692 17.0005
R3934 VSS.n2573 VSS.n790 17.0005
R3935 VSS.n2573 VSS.n791 17.0005
R3936 VSS.n2573 VSS.n690 17.0005
R3937 VSS.n2573 VSS.n689 17.0005
R3938 VSS.n2573 VSS.n792 17.0005
R3939 VSS.n2573 VSS.n793 17.0005
R3940 VSS.n2573 VSS.n688 17.0005
R3941 VSS.n2573 VSS.n687 17.0005
R3942 VSS.n2573 VSS.n794 17.0005
R3943 VSS.n2573 VSS.n795 17.0005
R3944 VSS.n2573 VSS.n686 17.0005
R3945 VSS.n2573 VSS.n685 17.0005
R3946 VSS.n2573 VSS.n796 17.0005
R3947 VSS.n2573 VSS.n800 17.0005
R3948 VSS.n2573 VSS.n684 17.0005
R3949 VSS.n2573 VSS.n683 17.0005
R3950 VSS.n2573 VSS.n801 17.0005
R3951 VSS.n2573 VSS.n802 17.0005
R3952 VSS.n2573 VSS.n682 17.0005
R3953 VSS.n2573 VSS.n681 17.0005
R3954 VSS.n2573 VSS.n803 17.0005
R3955 VSS.n2573 VSS.n804 17.0005
R3956 VSS.n2573 VSS.n680 17.0005
R3957 VSS.n2573 VSS.n805 17.0005
R3958 VSS.n880 VSS.n879 17.0005
R3959 VSS.n879 VSS.n878 17.0005
R3960 VSS.n877 VSS.n876 17.0005
R3961 VSS.n876 VSS.n875 17.0005
R3962 VSS.n873 VSS.n872 17.0005
R3963 VSS.n872 VSS.n871 17.0005
R3964 VSS.n2557 VSS.n2556 17.0005
R3965 VSS.n2556 VSS.n2555 17.0005
R3966 VSS.n829 VSS.n774 17.0005
R3967 VSS.n829 VSS.n706 17.0005
R3968 VSS.n829 VSS.n776 17.0005
R3969 VSS.n829 VSS.n704 17.0005
R3970 VSS.n829 VSS.n778 17.0005
R3971 VSS.n829 VSS.n702 17.0005
R3972 VSS.n829 VSS.n780 17.0005
R3973 VSS.n829 VSS.n700 17.0005
R3974 VSS.n829 VSS.n782 17.0005
R3975 VSS.n829 VSS.n698 17.0005
R3976 VSS.n829 VSS.n784 17.0005
R3977 VSS.n829 VSS.n696 17.0005
R3978 VSS.n829 VSS.n786 17.0005
R3979 VSS.n829 VSS.n694 17.0005
R3980 VSS.n829 VSS.n788 17.0005
R3981 VSS.n829 VSS.n692 17.0005
R3982 VSS.n925 VSS.n829 17.0005
R3983 VSS.n1006 VSS.n829 17.0005
R3984 VSS.n829 VSS.n791 17.0005
R3985 VSS.n829 VSS.n689 17.0005
R3986 VSS.n829 VSS.n793 17.0005
R3987 VSS.n829 VSS.n687 17.0005
R3988 VSS.n829 VSS.n795 17.0005
R3989 VSS.n829 VSS.n685 17.0005
R3990 VSS.n1021 VSS.n829 17.0005
R3991 VSS.n829 VSS.n683 17.0005
R3992 VSS.n829 VSS.n802 17.0005
R3993 VSS.n829 VSS.n681 17.0005
R3994 VSS.n829 VSS.n804 17.0005
R3995 VSS.n829 VSS.n680 17.0005
R3996 VSS.n829 VSS.n805 17.0005
R3997 VSS.n829 VSS.n822 17.0005
R3998 VSS.n829 VSS.n821 17.0005
R3999 VSS.n829 VSS.n820 17.0005
R4000 VSS.n829 VSS.n818 17.0005
R4001 VSS.n2573 VSS.n2572 17.0005
R4002 VSS.n2549 VSS.n2548 17.0005
R4003 VSS.n2548 VSS.n853 17.0005
R4004 VSS.n2451 VSS.n1357 17.0005
R4005 VSS.n2451 VSS.n1358 17.0005
R4006 VSS.n2451 VSS.n1371 17.0005
R4007 VSS.n2451 VSS.n1254 17.0005
R4008 VSS.n2451 VSS.n1160 17.0005
R4009 VSS.n2451 VSS.n1155 17.0005
R4010 VSS.n2451 VSS.n1152 17.0005
R4011 VSS.n2451 VSS.n1404 17.0005
R4012 VSS.n2451 VSS.n1406 17.0005
R4013 VSS.n2451 VSS.n1408 17.0005
R4014 VSS.n2451 VSS.n1419 17.0005
R4015 VSS.n1005 VSS.n1002 17.0005
R4016 VSS.n3351 VSS.n3258 17.0005
R4017 VSS.n3351 VSS.n3256 17.0005
R4018 VSS.n3351 VSS.n3253 17.0005
R4019 VSS.n3133 VSS.n667 17.0005
R4020 VSS.n3133 VSS.n665 17.0005
R4021 VSS.n3133 VSS.n658 17.0005
R4022 VSS.n3133 VSS.n656 17.0005
R4023 VSS.n3102 VSS.n2686 17.0005
R4024 VSS.n3102 VSS.n2684 17.0005
R4025 VSS.n3102 VSS.n2681 17.0005
R4026 VSS.n3102 VSS.n2679 17.0005
R4027 VSS.n3419 VSS.n403 17.0005
R4028 VSS.n3048 VSS.n2779 17.0005
R4029 VSS.n3048 VSS.n2777 17.0005
R4030 VSS.n3048 VSS.n2775 17.0005
R4031 VSS.n3041 VSS.n2851 17.0005
R4032 VSS.n467 VSS.n415 17.0005
R4033 VSS.n469 VSS.n415 17.0005
R4034 VSS.n3041 VSS.n2849 17.0005
R4035 VSS.n3041 VSS.n409 17.0005
R4036 VSS.n3182 VSS.n416 17.0005
R4037 VSS.n3435 VSS.n363 17.0005
R4038 VSS.n3435 VSS.n366 17.0005
R4039 VSS.n3435 VSS.n368 17.0005
R4040 VSS.n3435 VSS.n371 17.0005
R4041 VSS.n3435 VSS.n377 17.0005
R4042 VSS.n3435 VSS.n380 17.0005
R4043 VSS.n3435 VSS.n386 17.0005
R4044 VSS.n3435 VSS.n389 17.0005
R4045 VSS.n3435 VSS.n393 17.0005
R4046 VSS.n2926 VSS.n2925 17.0005
R4047 VSS.n2922 VSS.n2921 17.0005
R4048 VSS.n2921 VSS.n2920 17.0005
R4049 VSS.n2914 VSS.n2913 17.0005
R4050 VSS.n2913 VSS.n2912 17.0005
R4051 VSS.n3435 VSS.n310 17.0005
R4052 VSS.n3038 VSS.n2940 17.0005
R4053 VSS.n3038 VSS.n2939 17.0005
R4054 VSS.n3038 VSS.n2938 17.0005
R4055 VSS.n3038 VSS.n2937 17.0005
R4056 VSS.n3038 VSS.n2936 17.0005
R4057 VSS.n3038 VSS.n2935 17.0005
R4058 VSS.n3038 VSS.n2934 17.0005
R4059 VSS.n3038 VSS.n2932 17.0005
R4060 VSS.n3030 VSS.n2944 17.0005
R4061 VSS.n3030 VSS.n2945 17.0005
R4062 VSS.n3030 VSS.n2946 17.0005
R4063 VSS.n3030 VSS.n2947 17.0005
R4064 VSS.n3030 VSS.n2948 17.0005
R4065 VSS.n3030 VSS.n2950 17.0005
R4066 VSS.n3030 VSS.n2949 17.0005
R4067 VSS.n3030 VSS.n2952 17.0005
R4068 VSS.n3030 VSS.n2951 17.0005
R4069 VSS.n3030 VSS.n2954 17.0005
R4070 VSS.n3030 VSS.n2953 17.0005
R4071 VSS.n3030 VSS.n2956 17.0005
R4072 VSS.n3030 VSS.n2955 17.0005
R4073 VSS.n3030 VSS.n2958 17.0005
R4074 VSS.n3030 VSS.n2957 17.0005
R4075 VSS.n3030 VSS.n2960 17.0005
R4076 VSS.n3030 VSS.n2959 17.0005
R4077 VSS.n3030 VSS.n2962 17.0005
R4078 VSS.n3030 VSS.n2961 17.0005
R4079 VSS.n3030 VSS.n2964 17.0005
R4080 VSS.n3030 VSS.n2963 17.0005
R4081 VSS.n3030 VSS.n2966 17.0005
R4082 VSS.n3030 VSS.n2965 17.0005
R4083 VSS.n3030 VSS.n3029 17.0005
R4084 VSS.n3030 VSS.n2967 17.0005
R4085 VSS.n3030 VSS.n2969 17.0005
R4086 VSS.n3038 VSS.n2941 17.0005
R4087 VSS.n3038 VSS.n2930 17.0005
R4088 VSS.n3034 VSS.n2969 17.0005
R4089 VSS.n3034 VSS.n2967 17.0005
R4090 VSS.n3034 VSS.n2966 17.0005
R4091 VSS.n3034 VSS.n2965 17.0005
R4092 VSS.n3034 VSS.n2964 17.0005
R4093 VSS.n3034 VSS.n2963 17.0005
R4094 VSS.n3034 VSS.n2962 17.0005
R4095 VSS.n3034 VSS.n2961 17.0005
R4096 VSS.n3034 VSS.n2960 17.0005
R4097 VSS.n3034 VSS.n2959 17.0005
R4098 VSS.n3034 VSS.n2958 17.0005
R4099 VSS.n3034 VSS.n2957 17.0005
R4100 VSS.n3034 VSS.n2956 17.0005
R4101 VSS.n3034 VSS.n2955 17.0005
R4102 VSS.n3034 VSS.n2954 17.0005
R4103 VSS.n3034 VSS.n2953 17.0005
R4104 VSS.n3034 VSS.n2952 17.0005
R4105 VSS.n3034 VSS.n2951 17.0005
R4106 VSS.n3034 VSS.n2950 17.0005
R4107 VSS.n3034 VSS.n2949 17.0005
R4108 VSS.n3034 VSS.n2948 17.0005
R4109 VSS.n3034 VSS.n2947 17.0005
R4110 VSS.n3034 VSS.n2946 17.0005
R4111 VSS.n3034 VSS.n2945 17.0005
R4112 VSS.n3034 VSS.n2944 17.0005
R4113 VSS.n3034 VSS.n2932 17.0005
R4114 VSS.n3034 VSS.n2934 17.0005
R4115 VSS.n3034 VSS.n2935 17.0005
R4116 VSS.n3034 VSS.n2936 17.0005
R4117 VSS.n3034 VSS.n2937 17.0005
R4118 VSS.n3034 VSS.n2938 17.0005
R4119 VSS.n3034 VSS.n2939 17.0005
R4120 VSS.n3034 VSS.n2940 17.0005
R4121 VSS.n330 VSS.n302 17.0005
R4122 VSS.n332 VSS.n302 17.0005
R4123 VSS.n341 VSS.n340 17.0005
R4124 VSS.n342 VSS.n341 17.0005
R4125 VSS.n343 VSS.n308 17.0005
R4126 VSS.n363 VSS.n308 17.0005
R4127 VSS.n3410 VSS.n308 17.0005
R4128 VSS.n355 VSS.n308 17.0005
R4129 VSS.n350 VSS.n308 17.0005
R4130 VSS.n308 VSS.n307 17.0005
R4131 VSS.n3438 VSS.n308 17.0005
R4132 VSS.n345 VSS.n308 17.0005
R4133 VSS.n328 VSS.n308 17.0005
R4134 VSS.n326 VSS.n308 17.0005
R4135 VSS.n3432 VSS.n308 17.0005
R4136 VSS.n3431 VSS.n3430 17.0005
R4137 VSS.n3430 VSS.n3429 17.0005
R4138 VSS.n3424 VSS.n3423 17.0005
R4139 VSS.n3423 VSS.n3422 17.0005
R4140 VSS.n3041 VSS.n2852 17.0005
R4141 VSS.n3041 VSS.n2848 17.0005
R4142 VSS.n3041 VSS.n2856 17.0005
R4143 VSS.n3041 VSS.n2847 17.0005
R4144 VSS.n3041 VSS.n2857 17.0005
R4145 VSS.n3041 VSS.n2846 17.0005
R4146 VSS.n3041 VSS.n2860 17.0005
R4147 VSS.n3041 VSS.n2843 17.0005
R4148 VSS.n3041 VSS.n2800 17.0005
R4149 VSS.n3041 VSS.n430 17.0005
R4150 VSS.n3041 VSS.n2830 17.0005
R4151 VSS.n3041 VSS.n2829 17.0005
R4152 VSS.n3041 VSS.n2831 17.0005
R4153 VSS.n3041 VSS.n2828 17.0005
R4154 VSS.n3041 VSS.t673 17.0005
R4155 VSS.n3041 VSS.n2827 17.0005
R4156 VSS.n3041 VSS.n2833 17.0005
R4157 VSS.n3041 VSS.t482 17.0005
R4158 VSS.n3041 VSS.n2834 17.0005
R4159 VSS.n3041 VSS.n2826 17.0005
R4160 VSS.n3041 VSS.t590 17.0005
R4161 VSS.n3041 VSS.n2824 17.0005
R4162 VSS.n3041 VSS.n2835 17.0005
R4163 VSS.n3041 VSS.n2806 17.0005
R4164 VSS.n3041 VSS.n2836 17.0005
R4165 VSS.n3041 VSS.t857 17.0005
R4166 VSS.n3041 VSS.n2837 17.0005
R4167 VSS.n3041 VSS.n2805 17.0005
R4168 VSS.n3041 VSS.t563 17.0005
R4169 VSS.n3041 VSS.n2804 17.0005
R4170 VSS.n3041 VSS.n2838 17.0005
R4171 VSS.n3041 VSS.t743 17.0005
R4172 VSS.n3041 VSS.n2839 17.0005
R4173 VSS.n3041 VSS.n2803 17.0005
R4174 VSS.n3041 VSS.n2840 17.0005
R4175 VSS.n3041 VSS.n2802 17.0005
R4176 VSS.n3178 VSS.n3177 17.0005
R4177 VSS.n3174 VSS.n3173 17.0005
R4178 VSS.n3173 VSS.n3172 17.0005
R4179 VSS.n3171 VSS.n3170 17.0005
R4180 VSS.n3170 VSS.n3169 17.0005
R4181 VSS.n452 VSS.n447 17.0005
R4182 VSS.n453 VSS.n452 17.0005
R4183 VSS.n451 VSS.n450 17.0005
R4184 VSS.n450 VSS.n449 17.0005
R4185 VSS.n463 VSS.n458 17.0005
R4186 VSS.n464 VSS.n463 17.0005
R4187 VSS.n462 VSS.n461 17.0005
R4188 VSS.n461 VSS.n460 17.0005
R4189 VSS.n3182 VSS.n419 17.0005
R4190 VSS.n3581 VSS.n186 17.0005
R4191 VSS.n180 VSS.t839 17.0005
R4192 VSS.n180 VSS.t838 17.0005
R4193 VSS.n180 VSS.t948 17.0005
R4194 VSS.n175 VSS.t589 17.0005
R4195 VSS.n175 VSS.t588 17.0005
R4196 VSS.n175 VSS.t975 17.0005
R4197 VSS.n159 VSS.t742 17.0005
R4198 VSS.n159 VSS.t741 17.0005
R4199 VSS.n159 VSS.t1002 17.0005
R4200 VSS.n172 VSS.t513 17.0005
R4201 VSS.n172 VSS.t512 17.0005
R4202 VSS.n172 VSS.t965 17.0005
R4203 VSS.n162 VSS.t648 17.0005
R4204 VSS.n162 VSS.t647 17.0005
R4205 VSS.n162 VSS.t989 17.0005
R4206 VSS.n169 VSS.t818 17.0005
R4207 VSS.n169 VSS.t817 17.0005
R4208 VSS.n169 VSS.t942 17.0005
R4209 VSS.n164 VSS.t575 17.0005
R4210 VSS.n164 VSS.t574 17.0005
R4211 VSS.n164 VSS.t972 17.0005
R4212 VSS.n155 VSS.t721 17.0005
R4213 VSS.n155 VSS.t998 17.0005
R4214 VSS.n155 VSS.t722 17.0005
R4215 VSS.n35 VSS.t499 17.0005
R4216 VSS.n35 VSS.t498 17.0005
R4217 VSS.n35 VSS.t961 17.0005
R4218 VSS.n38 VSS.t636 17.0005
R4219 VSS.n38 VSS.t987 17.0005
R4220 VSS.n38 VSS.t637 17.0005
R4221 VSS.n3614 VSS.t805 17.0005
R4222 VSS.n3614 VSS.t936 17.0005
R4223 VSS.n3614 VSS.t806 17.0005
R4224 VSS.n3616 VSS.n40 17.0005
R4225 VSS.n3616 VSS.n37 17.0005
R4226 VSS.n3616 VSS.n36 17.0005
R4227 VSS.n3616 VSS.n34 17.0005
R4228 VSS.n3616 VSS.n32 17.0005
R4229 VSS.n3581 VSS.n166 17.0005
R4230 VSS.n3582 VSS.n3581 17.0005
R4231 VSS.n3581 VSS.n154 17.0005
R4232 VSS.n3581 VSS.n168 17.0005
R4233 VSS.n3581 VSS.n163 17.0005
R4234 VSS.n3581 VSS.n171 17.0005
R4235 VSS.n3581 VSS.n160 17.0005
R4236 VSS.n3581 VSS.n174 17.0005
R4237 VSS.n3581 VSS.n157 17.0005
R4238 VSS.n3581 VSS.t659 17.0005
R4239 VSS.n3581 VSS.n185 17.0005
R4240 VSS.n3581 VSS.n184 17.0005
R4241 VSS.n3581 VSS.t630 17.0005
R4242 VSS.n3581 VSS.n183 17.0005
R4243 VSS.n3581 VSS.n182 17.0005
R4244 VSS.n3581 VSS.t843 17.0005
R4245 VSS.n3581 VSS.n179 17.0005
R4246 VSS.n3581 VSS.n178 17.0005
R4247 VSS.n3581 VSS.n177 17.0005
R4248 VSS.n3578 VSS.n218 17.0005
R4249 VSS.n3578 VSS.n217 17.0005
R4250 VSS.n3578 VSS.n216 17.0005
R4251 VSS.n3578 VSS.n215 17.0005
R4252 VSS.n3578 VSS.n214 17.0005
R4253 VSS.n3578 VSS.n213 17.0005
R4254 VSS.n3578 VSS.n212 17.0005
R4255 VSS.n3578 VSS.n211 17.0005
R4256 VSS.n3578 VSS.n210 17.0005
R4257 VSS.n3578 VSS.n209 17.0005
R4258 VSS.n3578 VSS.n208 17.0005
R4259 VSS.n3578 VSS.n207 17.0005
R4260 VSS.n3578 VSS.n206 17.0005
R4261 VSS.n3578 VSS.n205 17.0005
R4262 VSS.n3578 VSS.n204 17.0005
R4263 VSS.n3578 VSS.n203 17.0005
R4264 VSS.n3578 VSS.n202 17.0005
R4265 VSS.n3578 VSS.n200 17.0005
R4266 VSS.n3578 VSS.n199 17.0005
R4267 VSS.n199 VSS.n190 17.0005
R4268 VSS.n202 VSS.n190 17.0005
R4269 VSS.n200 VSS.n190 17.0005
R4270 VSS.n204 VSS.n190 17.0005
R4271 VSS.n203 VSS.n190 17.0005
R4272 VSS.n206 VSS.n190 17.0005
R4273 VSS.n205 VSS.n190 17.0005
R4274 VSS.n208 VSS.n190 17.0005
R4275 VSS.n207 VSS.n190 17.0005
R4276 VSS.n210 VSS.n190 17.0005
R4277 VSS.n209 VSS.n190 17.0005
R4278 VSS.n212 VSS.n190 17.0005
R4279 VSS.n211 VSS.n190 17.0005
R4280 VSS.n214 VSS.n190 17.0005
R4281 VSS.n213 VSS.n190 17.0005
R4282 VSS.n216 VSS.n190 17.0005
R4283 VSS.n215 VSS.n190 17.0005
R4284 VSS.n218 VSS.n190 17.0005
R4285 VSS.n217 VSS.n190 17.0005
R4286 VSS.n3579 VSS.n190 17.0005
R4287 VSS.n190 VSS.n189 17.0005
R4288 VSS.n194 VSS.n190 17.0005
R4289 VSS.n3523 VSS.t949 17.0005
R4290 VSS.n3523 VSS.t957 17.0005
R4291 VSS.n3524 VSS.t991 17.0005
R4292 VSS.n3524 VSS.t996 17.0005
R4293 VSS.n3525 VSS.t969 17.0005
R4294 VSS.n3525 VSS.t974 17.0005
R4295 VSS.n3526 VSS.t933 17.0005
R4296 VSS.n3526 VSS.t946 17.0005
R4297 VSS.n3527 VSS.t934 17.0005
R4298 VSS.n3527 VSS.t964 17.0005
R4299 VSS.n3528 VSS.t986 17.0005
R4300 VSS.n3528 VSS.t1001 17.0005
R4301 VSS.n3529 VSS.t959 17.0005
R4302 VSS.n3529 VSS.t980 17.0005
R4303 VSS.n3530 VSS.t997 17.0005
R4304 VSS.n3530 VSS.t952 17.0005
R4305 VSS.n3531 VSS.t977 17.0005
R4306 VSS.n3531 VSS.t992 17.0005
R4307 VSS.n3532 VSS.t940 17.0005
R4308 VSS.n3532 VSS.t966 17.0005
R4309 VSS.n3533 VSS.t988 17.0005
R4310 VSS.n3533 VSS.t928 17.0005
R4311 VSS.n3534 VSS.t963 17.0005
R4312 VSS.n3534 VSS.t981 17.0005
R4313 VSS.n3535 VSS.t1000 17.0005
R4314 VSS.n3535 VSS.t953 17.0005
R4315 VSS.n3536 VSS.t979 17.0005
R4316 VSS.n3536 VSS.t993 17.0005
R4317 VSS.n3537 VSS.t947 17.0005
R4318 VSS.n3537 VSS.t968 17.0005
R4319 VSS.n3538 VSS.t990 17.0005
R4320 VSS.n3538 VSS.t931 17.0005
R4321 VSS.n3572 VSS.n3505 17.0005
R4322 VSS.n3581 VSS.n3580 17.0005
R4323 VSS.n193 VSS.n190 17.0005
R4324 VSS.n3578 VSS.n193 17.0005
R4325 VSS.n3578 VSS.n194 17.0005
R4326 VSS.n3578 VSS.n189 17.0005
R4327 VSS.n3579 VSS.n3578 17.0005
R4328 VSS.n192 VSS.n190 17.0005
R4329 VSS.n191 VSS.n190 17.0005
R4330 VSS.n220 VSS.n190 17.0005
R4331 VSS.n219 VSS.n190 17.0005
R4332 VSS.n222 VSS.n190 17.0005
R4333 VSS.n221 VSS.n190 17.0005
R4334 VSS.n224 VSS.n190 17.0005
R4335 VSS.n223 VSS.n190 17.0005
R4336 VSS.n226 VSS.n190 17.0005
R4337 VSS.n225 VSS.n190 17.0005
R4338 VSS.n228 VSS.n190 17.0005
R4339 VSS.n227 VSS.n190 17.0005
R4340 VSS.n230 VSS.n190 17.0005
R4341 VSS.n229 VSS.n190 17.0005
R4342 VSS.n232 VSS.n190 17.0005
R4343 VSS.n231 VSS.n190 17.0005
R4344 VSS.n234 VSS.n190 17.0005
R4345 VSS.n233 VSS.n190 17.0005
R4346 VSS.n3554 VSS.n190 17.0005
R4347 VSS.n235 VSS.n190 17.0005
R4348 VSS.n237 VSS.n190 17.0005
R4349 VSS.n3578 VSS.n237 17.0005
R4350 VSS.n3578 VSS.n235 17.0005
R4351 VSS.n3578 VSS.n234 17.0005
R4352 VSS.n3578 VSS.n233 17.0005
R4353 VSS.n3578 VSS.n232 17.0005
R4354 VSS.n3578 VSS.n231 17.0005
R4355 VSS.n3578 VSS.n230 17.0005
R4356 VSS.n3578 VSS.n229 17.0005
R4357 VSS.n3578 VSS.n228 17.0005
R4358 VSS.n3578 VSS.n227 17.0005
R4359 VSS.n3578 VSS.n226 17.0005
R4360 VSS.n3578 VSS.n225 17.0005
R4361 VSS.n3578 VSS.n224 17.0005
R4362 VSS.n3578 VSS.n223 17.0005
R4363 VSS.n3578 VSS.n222 17.0005
R4364 VSS.n3578 VSS.n221 17.0005
R4365 VSS.n3578 VSS.n220 17.0005
R4366 VSS.n3578 VSS.n219 17.0005
R4367 VSS.n3578 VSS.n192 17.0005
R4368 VSS.n3578 VSS.n191 17.0005
R4369 VSS.n3572 VSS.n242 17.0005
R4370 VSS.n3573 VSS.n3572 17.0005
R4371 VSS.n3572 VSS.n3501 17.0005
R4372 VSS.n3572 VSS.n246 17.0005
R4373 VSS.n3572 VSS.n3502 17.0005
R4374 VSS.n3572 VSS.t748 17.0005
R4375 VSS.n3572 VSS.n3503 17.0005
R4376 VSS.n3572 VSS.n244 17.0005
R4377 VSS.n3572 VSS.t569 17.0005
R4378 VSS.n3572 VSS.n243 17.0005
R4379 VSS.n3572 VSS.n3504 17.0005
R4380 VSS.n3572 VSS.t657 17.0005
R4381 VSS.n3572 VSS.n3571 17.0005
R4382 VSS.n284 VSS.t954 17.0005
R4383 VSS.n284 VSS.t672 17.0005
R4384 VSS.n284 VSS.t671 17.0005
R4385 VSS.n3475 VSS.t994 17.0005
R4386 VSS.n3475 VSS.t530 17.0005
R4387 VSS.n3475 VSS.t529 17.0005
R4388 VSS.n3473 VSS.t971 17.0005
R4389 VSS.n3473 VSS.t766 17.0005
R4390 VSS.n3473 VSS.t765 17.0005
R4391 VSS.n290 VSS.t938 17.0005
R4392 VSS.n290 VSS.t613 17.0005
R4393 VSS.n290 VSS.t612 17.0005
R4394 VSS.n293 VSS.t984 17.0005
R4395 VSS.n293 VSS.t853 17.0005
R4396 VSS.n293 VSS.t852 17.0005
R4397 VSS.n3464 VSS.t956 17.0005
R4398 VSS.n3464 VSS.t685 17.0005
R4399 VSS.n3464 VSS.t684 17.0005
R4400 VSS.n3459 VSS.t995 17.0005
R4401 VSS.n3459 VSS.t546 17.0005
R4402 VSS.n3459 VSS.t545 17.0005
R4403 VSS.n3451 VSS.t973 17.0005
R4404 VSS.n3451 VSS.t788 17.0005
R4405 VSS.n3451 VSS.t787 17.0005
R4406 VSS.n3446 VSS.t944 17.0005
R4407 VSS.n3446 VSS.t622 17.0005
R4408 VSS.n3446 VSS.t621 17.0005
R4409 VSS.n252 VSS.t985 17.0005
R4410 VSS.n252 VSS.t871 17.0005
R4411 VSS.n252 VSS.t870 17.0005
R4412 VSS.n3496 VSS.t958 17.0005
R4413 VSS.n3496 VSS.t695 17.0005
R4414 VSS.n3496 VSS.t694 17.0005
R4415 VSS.n3498 VSS.n247 17.0005
R4416 VSS.n3495 VSS.n3494 17.0005
R4417 VSS.n3494 VSS.n3493 17.0005
R4418 VSS.n3492 VSS.n3491 17.0005
R4419 VSS.n3491 VSS.n3490 17.0005
R4420 VSS.n3448 VSS.n3447 17.0005
R4421 VSS.n3449 VSS.n3448 17.0005
R4422 VSS.n3453 VSS.n3450 17.0005
R4423 VSS.n3453 VSS.n3452 17.0005
R4424 VSS.n3461 VSS.n3460 17.0005
R4425 VSS.n3462 VSS.n3461 17.0005
R4426 VSS.n3466 VSS.n3463 17.0005
R4427 VSS.n3466 VSS.n3465 17.0005
R4428 VSS.n3471 VSS.n292 17.0005
R4429 VSS.n3471 VSS.n291 17.0005
R4430 VSS.n3471 VSS.n167 17.0005
R4431 VSS.n3472 VSS.n3471 17.0005
R4432 VSS.n3478 VSS.n3474 17.0005
R4433 VSS.n3478 VSS.n287 17.0005
R4434 VSS.n3478 VSS.n3477 17.0005
R4435 VSS.n3476 VSS.n286 17.0005
R4436 VSS.n286 VSS.n285 17.0005
R4437 VSS.n266 VSS.n264 17.0005
R4438 VSS.n3486 VSS.t982 17.0005
R4439 VSS.n3487 VSS.t842 17.0005
R4440 VSS.n3484 VSS.t841 17.0005
R4441 VSS.n3486 VSS.t967 17.0005
R4442 VSS.n3487 VSS.t663 17.0005
R4443 VSS.n3484 VSS.t662 17.0005
R4444 VSS.n3045 VSS.t679 17.0005
R4445 VSS.n3486 VSS.t930 17.0005
R4446 VSS.n3487 VSS.t524 17.0005
R4447 VSS.n3484 VSS.t523 17.0005
R4448 VSS.n3045 VSS.t540 17.0005
R4449 VSS.n3486 VSS.t983 17.0005
R4450 VSS.n3487 VSS.t758 17.0005
R4451 VSS.n3484 VSS.t757 17.0005
R4452 VSS.n3045 VSS.t783 17.0005
R4453 VSS.n3486 VSS.t955 17.0005
R4454 VSS.n3487 VSS.t610 17.0005
R4455 VSS.n3484 VSS.t609 17.0005
R4456 VSS.n3045 VSS.t619 17.0005
R4457 VSS.n3045 VSS.t876 17.0005
R4458 VSS.n3483 VSS.n266 17.0005
R4459 VSS.n3048 VSS.n2759 17.0005
R4460 VSS.n3621 VSS.n3620 17.0005
R4461 VSS.n3620 VSS.n21 17.0005
R4462 VSS.n3606 VSS.n1 17.0005
R4463 VSS.n111 VSS.t796 17.0005
R4464 VSS.n112 VSS.t578 17.0005
R4465 VSS.n112 VSS.t577 17.0005
R4466 VSS.n112 VSS.t962 17.0005
R4467 VSS.n133 VSS.t706 17.0005
R4468 VSS.n132 VSS.t821 17.0005
R4469 VSS.n132 VSS.t820 17.0005
R4470 VSS.n132 VSS.t999 17.0005
R4471 VSS.n118 VSS.t651 17.0005
R4472 VSS.n118 VSS.t650 17.0005
R4473 VSS.n118 VSS.t978 17.0005
R4474 VSS.n124 VSS.t754 17.0005
R4475 VSS.n137 VSS.t516 17.0005
R4476 VSS.n137 VSS.t515 17.0005
R4477 VSS.n137 VSS.t950 17.0005
R4478 VSS.n147 VSS.t688 17.0005
R4479 VSS.n141 VSS.t562 17.0005
R4480 VSS.n141 VSS.t561 17.0005
R4481 VSS.n141 VSS.t970 17.0005
R4482 VSS.n110 VSS.n23 17.0005
R4483 VSS.n113 VSS.n23 17.0005
R4484 VSS.n134 VSS.n127 17.0005
R4485 VSS.n127 VSS.n126 17.0005
R4486 VSS.n122 VSS.n121 17.0005
R4487 VSS.n123 VSS.n122 17.0005
R4488 VSS.n3590 VSS.n3589 17.0005
R4489 VSS.n3589 VSS.n116 17.0005
R4490 VSS.n146 VSS.n145 17.0005
R4491 VSS.n145 VSS.n144 17.0005
R4492 VSS.n142 VSS.n31 17.0005
R4493 VSS.n139 VSS.n31 17.0005
R4494 VSS.n140 VSS.n1 17.0005
R4495 VSS.n143 VSS.n1 17.0005
R4496 VSS.n136 VSS.n1 17.0005
R4497 VSS.n138 VSS.n1 17.0005
R4498 VSS.n3591 VSS.n1 17.0005
R4499 VSS.n3588 VSS.n1 17.0005
R4500 VSS.n117 VSS.n1 17.0005
R4501 VSS.n119 VSS.n1 17.0005
R4502 VSS.n134 VSS.n1 17.0005
R4503 VSS.n131 VSS.n1 17.0005
R4504 VSS.n128 VSS.n1 17.0005
R4505 VSS.n113 VSS.n1 17.0005
R4506 VSS.n12 VSS.n1 17.0005
R4507 VSS.n3376 VSS.n1 17.0005
R4508 VSS.n3374 VSS.n1 17.0005
R4509 VSS.n3372 VSS.n1 17.0005
R4510 VSS.n3369 VSS.n1 17.0005
R4511 VSS.n3367 VSS.n1 17.0005
R4512 VSS.n3365 VSS.n1 17.0005
R4513 VSS.n3357 VSS.n1 17.0005
R4514 VSS.n3212 VSS.n1 17.0005
R4515 VSS.n3227 VSS.n1 17.0005
R4516 VSS.n3232 VSS.n1 17.0005
R4517 VSS.n3235 VSS.n1 17.0005
R4518 VSS.n3241 VSS.n1 17.0005
R4519 VSS.n3261 VSS.n1 17.0005
R4520 VSS.n3264 VSS.n1 17.0005
R4521 VSS.n3266 VSS.n1 17.0005
R4522 VSS.n3268 VSS.n1 17.0005
R4523 VSS.n3270 VSS.n1 17.0005
R4524 VSS.n3273 VSS.n1 17.0005
R4525 VSS.n3275 VSS.n1 17.0005
R4526 VSS.n3277 VSS.n1 17.0005
R4527 VSS.n3280 VSS.n1 17.0005
R4528 VSS.n3282 VSS.n1 17.0005
R4529 VSS.n3284 VSS.n1 17.0005
R4530 VSS.n3286 VSS.n1 17.0005
R4531 VSS.n3288 VSS.n1 17.0005
R4532 VSS.n3290 VSS.n1 17.0005
R4533 VSS.n3293 VSS.n1 17.0005
R4534 VSS.n3295 VSS.n1 17.0005
R4535 VSS.n3297 VSS.n1 17.0005
R4536 VSS.n99 VSS.n1 17.0005
R4537 VSS.n100 VSS.n1 17.0005
R4538 VSS.n94 VSS.n1 17.0005
R4539 VSS.n96 VSS.n1 17.0005
R4540 VSS.n87 VSS.n1 17.0005
R4541 VSS.n90 VSS.n1 17.0005
R4542 VSS.n88 VSS.n1 17.0005
R4543 VSS.n82 VSS.n1 17.0005
R4544 VSS.n83 VSS.n1 17.0005
R4545 VSS.n77 VSS.n1 17.0005
R4546 VSS.n78 VSS.n1 17.0005
R4547 VSS.n71 VSS.n1 17.0005
R4548 VSS.n72 VSS.n1 17.0005
R4549 VSS.n65 VSS.n1 17.0005
R4550 VSS.n66 VSS.n1 17.0005
R4551 VSS.n3208 VSS.n1 17.0005
R4552 VSS.n3601 VSS.n62 17.0005
R4553 VSS.n3601 VSS.n61 17.0005
R4554 VSS.n3601 VSS.n67 17.0005
R4555 VSS.n3601 VSS.n70 17.0005
R4556 VSS.n3601 VSS.n60 17.0005
R4557 VSS.n3601 VSS.n59 17.0005
R4558 VSS.n3601 VSS.n74 17.0005
R4559 VSS.n3601 VSS.n75 17.0005
R4560 VSS.n3601 VSS.n58 17.0005
R4561 VSS.n3601 VSS.n57 17.0005
R4562 VSS.n3601 VSS.n79 17.0005
R4563 VSS.n3601 VSS.n81 17.0005
R4564 VSS.n3601 VSS.n56 17.0005
R4565 VSS.n3601 VSS.n55 17.0005
R4566 VSS.n3601 VSS.n84 17.0005
R4567 VSS.n3601 VSS.n86 17.0005
R4568 VSS.n3601 VSS.n54 17.0005
R4569 VSS.n3601 VSS.n53 17.0005
R4570 VSS.n3601 VSS.n91 17.0005
R4571 VSS.n3601 VSS.n93 17.0005
R4572 VSS.n3601 VSS.n52 17.0005
R4573 VSS.n3601 VSS.n51 17.0005
R4574 VSS.n3601 VSS.n97 17.0005
R4575 VSS.n3601 VSS.n98 17.0005
R4576 VSS.n3601 VSS.n50 17.0005
R4577 VSS.n3601 VSS.n49 17.0005
R4578 VSS.n3601 VSS.n101 17.0005
R4579 VSS.n3601 VSS.n103 17.0005
R4580 VSS.n3601 VSS.n48 17.0005
R4581 VSS.n3601 VSS.n47 17.0005
R4582 VSS.n3401 VSS.n3400 17.0005
R4583 VSS.n3401 VSS.n3395 17.0005
R4584 VSS.n3401 VSS.n3389 17.0005
R4585 VSS.n3401 VSS.n3385 17.0005
R4586 VSS.n3601 VSS.n105 17.0005
R4587 VSS.n3601 VSS.n46 17.0005
R4588 VSS.n3602 VSS.n3601 17.0005
R4589 VSS.n3593 VSS.t707 17.0005
R4590 VSS.n9 VSS.t797 17.0005
R4591 VSS.n107 VSS.t755 17.0005
R4592 VSS.n3596 VSS.t689 17.0005
R4593 VSS.n3624 VSS.n1 17.0005
R4594 VSS.n3309 VSS.n3303 17.0005
R4595 VSS.n3311 VSS.n3303 17.0005
R4596 VSS.n3313 VSS.n3303 17.0005
R4597 VSS.n3298 VSS.t790 17.0005
R4598 VSS.n3634 VSS.t855 17.0005
R4599 VSS.n8 VSS.t814 17.0005
R4600 VSS.n3631 VSS.t479 17.0005
R4601 VSS.n3638 VSS.t856 17.0005
R4602 VSS.n3 VSS.t815 17.0005
R4603 VSS.n3643 VSS.t480 17.0005
R4604 VSS.n3642 VSS.n1 17.0005
R4605 VSS.n4 VSS.n1 17.0005
R4606 VSS.n3635 VSS.n1 17.0005
R4607 VSS.n3637 VSS.n1 17.0005
R4608 VSS.t405 VSS.n1544 16.8292
R4609 VSS.t431 VSS.t768 16.6903
R4610 VSS.t385 VSS.t526 16.6903
R4611 VSS.t254 VSS.n1051 16.173
R4612 VSS.t469 VSS.n1546 15.91
R4613 VSS.t85 VSS.n371 15.6936
R4614 VSS.t63 VSS.n3410 15.6936
R4615 VSS.n2751 VSS.t151 15.5717
R4616 VSS.n3306 VSS.t478 15.5483
R4617 VSS.n1380 VSS.t418 15.4955
R4618 VSS.n1355 VSS.t382 15.4937
R4619 VSS.n1158 VSS.t1007 15.4918
R4620 VSS.n2032 VSS.n2031 15.4832
R4621 VSS.n2136 VSS.t5 15.4678
R4622 VSS.t132 VSS.n2131 15.4678
R4623 VSS.n2121 VSS.t906 15.4374
R4624 VSS.n3075 VSS.n3063 15.2042
R4625 VSS.n2325 VSS.n1544 15.1984
R4626 VSS.n1378 VSS.t135 15.1838
R4627 VSS.n1391 VSS.t1053 15.1838
R4628 VSS.n1164 VSS.t1032 15.1533
R4629 VSS.n1362 VSS.t191 15.1533
R4630 VSS.n2389 VSS.t420 15.1001
R4631 VSS.n1540 VSS.t93 15.0621
R4632 VSS.n1540 VSS.t94 15.0586
R4633 VSS.n2389 VSS.t419 15.0398
R4634 VSS.n1441 VSS.t1008 15.0393
R4635 VSS.n1365 VSS.t2 15.0078
R4636 VSS.n1365 VSS.t145 15.0078
R4637 VSS.n1365 VSS.t904 15.0078
R4638 VSS.n1365 VSS.t146 15.0078
R4639 VSS.n1365 VSS.t3 15.0078
R4640 VSS.n1365 VSS.t912 15.0078
R4641 VSS.n1365 VSS.t442 15.0078
R4642 VSS.n1215 VSS.t441 15.0078
R4643 VSS.n1375 VSS.t393 15.006
R4644 VSS.n1375 VSS.t1005 15.006
R4645 VSS.n1375 VSS.t81 15.006
R4646 VSS.n1375 VSS.t166 15.006
R4647 VSS.n1375 VSS.t165 15.006
R4648 VSS.n1375 VSS.t80 15.006
R4649 VSS.n1375 VSS.t1004 15.006
R4650 VSS.n1375 VSS.t392 15.006
R4651 VSS.n1375 VSS.t43 15.006
R4652 VSS.n1191 VSS.t397 15.0053
R4653 VSS.n1181 VSS.t1061 15.0053
R4654 VSS.n1169 VSS.t49 15.0053
R4655 VSS.n1381 VSS.t394 15.0042
R4656 VSS.n1158 VSS.t59 15.0042
R4657 VSS.n1355 VSS.t919 15.0023
R4658 VSS.n314 VSS.t456 15.0005
R4659 VSS.n312 VSS.t457 15.0005
R4660 VSS.n318 VSS.t1021 15.0005
R4661 VSS.n320 VSS.t1022 15.0005
R4662 VSS.n322 VSS.t186 15.0005
R4663 VSS.n324 VSS.t187 15.0005
R4664 VSS.n2911 VSS.t249 15.0005
R4665 VSS.n2918 VSS.t248 15.0005
R4666 VSS.n2906 VSS.t462 15.0005
R4667 VSS.n2904 VSS.t461 15.0005
R4668 VSS.n2896 VSS.t1020 15.0005
R4669 VSS.n2895 VSS.t1019 15.0005
R4670 VSS.n2760 VSS.t155 15.0005
R4671 VSS.n3417 VSS.t154 15.0005
R4672 VSS.n3420 VSS.t261 15.0005
R4673 VSS.n400 VSS.t260 15.0005
R4674 VSS.n3426 VSS.t413 15.0005
R4675 VSS.n394 VSS.t412 15.0005
R4676 VSS.n329 VSS.t56 15.0005
R4677 VSS.n335 VSS.t57 15.0005
R4678 VSS.n331 VSS.t75 15.0005
R4679 VSS.n2753 VSS.t76 15.0005
R4680 VSS.n2751 VSS.t125 15.0005
R4681 VSS.n2749 VSS.t126 15.0005
R4682 VSS.n2071 VSS.t123 15.0005
R4683 VSS.n2071 VSS.t122 15.0005
R4684 VSS.n2071 VSS.t30 15.0005
R4685 VSS.n2071 VSS.t29 15.0005
R4686 VSS.n2071 VSS.t194 15.0005
R4687 VSS.n2071 VSS.t193 15.0005
R4688 VSS.n2071 VSS.t159 15.0005
R4689 VSS.n2071 VSS.t158 15.0005
R4690 VSS.n2071 VSS.t1013 15.0005
R4691 VSS.n2071 VSS.t1012 15.0005
R4692 VSS.n1441 VSS.t1009 15.0005
R4693 VSS.n1380 VSS.t446 15.0005
R4694 VSS.n1379 VSS.t250 15.0005
R4695 VSS.n1392 VSS.t444 15.0005
R4696 VSS.n1364 VSS.t911 15.0005
R4697 VSS.n1363 VSS.t398 15.0005
R4698 VSS.t488 VSS.n434 15.0005
R4699 VSS.n3168 VSS.t488 15.0005
R4700 VSS.t488 VSS.n454 15.0005
R4701 VSS.t488 VSS.n445 15.0005
R4702 VSS.t488 VSS.n465 15.0005
R4703 VSS.t488 VSS.n444 15.0005
R4704 VSS.t488 VSS.n466 15.0005
R4705 VSS.t488 VSS.n441 15.0005
R4706 VSS.t488 VSS.n470 15.0005
R4707 VSS.t488 VSS.n440 15.0005
R4708 VSS.t481 VSS.n3021 15.0005
R4709 VSS.n3025 VSS.t481 15.0005
R4710 VSS.t481 VSS.n3022 15.0005
R4711 VSS.t481 VSS.n3020 15.0005
R4712 VSS.t481 VSS.n3023 15.0005
R4713 VSS.t481 VSS.n3019 15.0005
R4714 VSS.t481 VSS.n3024 15.0005
R4715 VSS.t492 VSS.n2786 15.0005
R4716 VSS.t492 VSS.n2791 15.0005
R4717 VSS.t492 VSS.n2792 15.0005
R4718 VSS.t492 VSS.n2793 15.0005
R4719 VSS.t492 VSS.n2794 15.0005
R4720 VSS.t492 VSS.n2795 15.0005
R4721 VSS.t492 VSS.n2796 15.0005
R4722 VSS.t492 VSS.n2797 15.0005
R4723 VSS.t492 VSS.n2798 15.0005
R4724 VSS.t492 VSS.n2799 15.0005
R4725 VSS.t492 VSS.n3043 15.0005
R4726 VSS.n2981 VSS.t61 15.0005
R4727 VSS.n2982 VSS.t62 15.0005
R4728 VSS.n2984 VSS.t196 15.0005
R4729 VSS.n2983 VSS.t197 15.0005
R4730 VSS.n2980 VSS.t459 15.0005
R4731 VSS.n2980 VSS.t1041 15.0005
R4732 VSS.n2979 VSS.t460 15.0005
R4733 VSS.n2985 VSS.t1042 15.0005
R4734 VSS.t488 VSS.n471 15.0005
R4735 VSS.t488 VSS.n439 15.0005
R4736 VSS.t488 VSS.n472 15.0005
R4737 VSS.t488 VSS.n438 15.0005
R4738 VSS.t488 VSS.n3167 15.0005
R4739 VSS.n2524 VSS.t129 15.0005
R4740 VSS.n2545 VSS.t1040 15.0005
R4741 VSS.n2544 VSS.t1039 15.0005
R4742 VSS.n2543 VSS.t467 15.0005
R4743 VSS.n2542 VSS.t466 15.0005
R4744 VSS.n2541 VSS.t69 15.0005
R4745 VSS.n2539 VSS.t68 15.0005
R4746 VSS.n2538 VSS.t1057 15.0005
R4747 VSS.n2537 VSS.t1056 15.0005
R4748 VSS.n2536 VSS.t84 15.0005
R4749 VSS.n2524 VSS.t83 15.0005
R4750 VSS.n2545 VSS.t1055 15.0005
R4751 VSS.n2544 VSS.t1054 15.0005
R4752 VSS.n2543 VSS.t1063 15.0005
R4753 VSS.n2542 VSS.t1062 15.0005
R4754 VSS.n2541 VSS.t33 15.0005
R4755 VSS.n2539 VSS.t32 15.0005
R4756 VSS.n2538 VSS.t128 15.0005
R4757 VSS.n2537 VSS.t127 15.0005
R4758 VSS.n2536 VSS.t130 15.0005
R4759 VSS.n2372 VSS.t474 15.0005
R4760 VSS.n2364 VSS.t137 15.0005
R4761 VSS.n2361 VSS.t138 15.0005
R4762 VSS.n2119 VSS.t463 15.0005
R4763 VSS.n2117 VSS.t464 15.0005
R4764 VSS.n2115 VSS.t425 15.0005
R4765 VSS.n2113 VSS.t426 15.0005
R4766 VSS.n2102 VSS.t453 15.0005
R4767 VSS.n2104 VSS.t454 15.0005
R4768 VSS.n2106 VSS.t1010 15.0005
R4769 VSS.n2108 VSS.t1011 15.0005
R4770 VSS.n2110 VSS.t909 15.0005
R4771 VSS.n2121 VSS.t910 15.0005
R4772 VSS.n1087 VSS.t1059 15.0005
R4773 VSS.n1093 VSS.t1038 15.0005
R4774 VSS.n1098 VSS.t1037 15.0005
R4775 VSS.n1102 VSS.t1035 15.0005
R4776 VSS.n1110 VSS.t1034 15.0005
R4777 VSS.n1118 VSS.t296 15.0005
R4778 VSS.n1124 VSS.t295 15.0005
R4779 VSS.n1133 VSS.t401 15.0005
R4780 VSS.n1135 VSS.t400 15.0005
R4781 VSS.n1077 VSS.t1060 15.0005
R4782 VSS.n1228 VSS.t475 15.0005
R4783 VSS.n1077 VSS.t422 15.0005
R4784 VSS.n1087 VSS.t421 15.0005
R4785 VSS.n1093 VSS.t149 15.0005
R4786 VSS.n1098 VSS.t148 15.0005
R4787 VSS.n1102 VSS.t893 15.0005
R4788 VSS.n1110 VSS.t892 15.0005
R4789 VSS.n1118 VSS.t78 15.0005
R4790 VSS.n1124 VSS.t77 15.0005
R4791 VSS.n1133 VSS.t88 15.0005
R4792 VSS.n1135 VSS.t87 15.0005
R4793 VSS.n1353 VSS.t472 15.0005
R4794 VSS.n1353 VSS.t72 15.0005
R4795 VSS.n1353 VSS.t476 15.0005
R4796 VSS.n1353 VSS.t408 15.0005
R4797 VSS.n1353 VSS.t71 15.0005
R4798 VSS.n1353 VSS.t471 15.0005
R4799 VSS.n1353 VSS.t52 15.0005
R4800 VSS.n1353 VSS.t51 15.0005
R4801 VSS.n1353 VSS.t409 15.0005
R4802 VSS.n1366 VSS.t905 15.0005
R4803 VSS.n1389 VSS.t452 15.0005
R4804 VSS.n1387 VSS.t410 15.0005
R4805 VSS.n1399 VSS.t140 15.0005
R4806 VSS.n1376 VSS.t44 15.0005
R4807 VSS.n1403 VSS.t199 15.0005
R4808 VSS.n1403 VSS.t200 15.0005
R4809 VSS.n1403 VSS.t895 15.0005
R4810 VSS.n1403 VSS.t896 15.0005
R4811 VSS.n1403 VSS.t65 15.0005
R4812 VSS.n1403 VSS.t66 15.0005
R4813 VSS.n1403 VSS.t427 15.0005
R4814 VSS.n1403 VSS.t428 15.0005
R4815 VSS.n1403 VSS.t39 15.0005
R4816 VSS.n1403 VSS.t40 15.0005
R4817 VSS.n2393 VSS.t386 15.0005
R4818 VSS.n2386 VSS.t387 15.0005
R4819 VSS.n2386 VSS.t384 15.0005
R4820 VSS.n2393 VSS.t383 15.0005
R4821 VSS.n2393 VSS.t142 15.0005
R4822 VSS.n2386 VSS.t143 15.0005
R4823 VSS.n2399 VSS.t525 15.0005
R4824 VSS.n2410 VSS.t767 15.0005
R4825 VSS.n2340 VSS.t1051 15.0005
R4826 VSS.n1551 VSS.t1052 15.0005
R4827 VSS.n2340 VSS.t406 15.0005
R4828 VSS.n1551 VSS.t407 15.0005
R4829 VSS.n2340 VSS.t432 15.0005
R4830 VSS.n1551 VSS.t433 15.0005
R4831 VSS.n2263 VSS.t531 15.0005
R4832 VSS.t531 VSS.n2257 15.0005
R4833 VSS.t531 VSS.n2255 15.0005
R4834 VSS.t531 VSS.n2262 15.0005
R4835 VSS.t623 VSS.n2286 15.0005
R4836 VSS.t623 VSS.n2289 15.0005
R4837 VSS.t623 VSS.n2250 15.0005
R4838 VSS.n2290 VSS.t623 15.0005
R4839 VSS.t496 VSS.n3586 15.0005
R4840 VSS.t496 VSS.n3585 15.0005
R4841 VSS.t496 VSS.n3584 15.0005
R4842 VSS.t496 VSS.n3583 15.0005
R4843 VSS.t496 VSS.n153 15.0005
R4844 VSS.t496 VSS.n152 15.0005
R4845 VSS.t496 VSS.n151 15.0005
R4846 VSS.t496 VSS.n150 15.0005
R4847 VSS.t496 VSS.n149 15.0005
R4848 VSS.t496 VSS.n148 15.0005
R4849 VSS.t547 VSS.n3513 15.0005
R4850 VSS.t547 VSS.n3512 15.0005
R4851 VSS.t547 VSS.n3514 15.0005
R4852 VSS.t547 VSS.n3511 15.0005
R4853 VSS.t547 VSS.n3515 15.0005
R4854 VSS.n3517 VSS.t547 15.0005
R4855 VSS.t547 VSS.n3516 15.0005
R4856 VSS.n3564 VSS.t1050 15.0005
R4857 VSS.n3555 VSS.t1049 15.0005
R4858 VSS.n3563 VSS.t917 15.0005
R4859 VSS.n3562 VSS.t916 15.0005
R4860 VSS.n3556 VSS.t921 15.0005
R4861 VSS.n3556 VSS.t390 15.0005
R4862 VSS.n3559 VSS.t389 15.0005
R4863 VSS.n3561 VSS.t920 15.0005
R4864 VSS.t568 VSS.n3548 15.0005
R4865 VSS.n3552 VSS.t568 15.0005
R4866 VSS.t568 VSS.n3549 15.0005
R4867 VSS.t568 VSS.n3547 15.0005
R4868 VSS.t568 VSS.n3550 15.0005
R4869 VSS.t568 VSS.n3546 15.0005
R4870 VSS.t568 VSS.n3551 15.0005
R4871 VSS.t521 VSS.n249 15.0005
R4872 VSS.n3489 VSS.t521 15.0005
R4873 VSS.t521 VSS.n259 15.0005
R4874 VSS.t521 VSS.n258 15.0005
R4875 VSS.t521 VSS.n260 15.0005
R4876 VSS.t521 VSS.n257 15.0005
R4877 VSS.t521 VSS.n261 15.0005
R4878 VSS.t521 VSS.n256 15.0005
R4879 VSS.t521 VSS.n262 15.0005
R4880 VSS.t521 VSS.n255 15.0005
R4881 VSS.t521 VSS.n263 15.0005
R4882 VSS.t496 VSS.n147 15.0005
R4883 VSS.n3587 VSS.t496 15.0005
R4884 VSS.t496 VSS.n135 15.0005
R4885 VSS.t496 VSS.n125 15.0005
R4886 VSS.t496 VSS.n43 15.0005
R4887 VSS.t768 VSS.n1555 14.6041
R4888 VSS.t526 VSS.n2392 14.6041
R4889 VSS.n2126 VSS.n2077 14.3543
R4890 VSS.n2083 VSS.n2082 14.1575
R4891 VSS.n2091 VSS.n2090 14.1556
R4892 VSS.n1325 VSS.n1078 14.1293
R4893 VSS.n1258 VSS.n1257 14.1284
R4894 VSS.n1316 VSS.t34 14.052
R4895 VSS.n1329 VSS.t35 14.052
R4896 VSS.n2035 VSS.n1715 13.9607
R4897 VSS.t231 VSS.n1658 13.9607
R4898 VSS.n2135 VSS.t192 13.8665
R4899 VSS.t46 VSS.n2132 13.8665
R4900 VSS.n1287 VSS.n1147 13.7415
R4901 VSS.n885 VSS.n884 13.4824
R4902 VSS.n828 VSS.n741 13.4824
R4903 VSS.n825 VSS.n724 13.4824
R4904 VSS.n925 VSS.n789 13.4824
R4905 VSS.n1021 VSS.n797 13.4824
R4906 VSS.n823 VSS.n800 13.4824
R4907 VSS.n822 VSS.n679 13.4824
R4908 VSS.n820 VSS.n678 13.4824
R4909 VSS.n570 VSS.n556 13.4824
R4910 VSS.n661 VSS.n539 13.4824
R4911 VSS.n2609 VSS.n517 13.4824
R4912 VSS.n579 VSS.n510 13.4824
R4913 VSS.n582 VSS.n507 13.4824
R4914 VSS.n573 VSS.n496 13.4824
R4915 VSS.n572 VSS.n483 13.4824
R4916 VSS.n2603 VSS.n518 13.4824
R4917 VSS.n575 VSS.n528 13.4824
R4918 VSS.n660 VSS.n539 13.4824
R4919 VSS.n568 VSS.n558 13.4824
R4920 VSS.n578 VSS.n525 13.4824
R4921 VSS.n573 VSS.n495 13.4824
R4922 VSS.n571 VSS.n481 13.4824
R4923 VSS.n825 VSS.n756 13.4824
R4924 VSS.n827 VSS.n733 13.4824
R4925 VSS.n828 VSS.n739 13.4824
R4926 VSS.n886 VSS.n867 13.4824
R4927 VSS.n906 VSS.n749 13.4824
R4928 VSS.n1006 VSS.n789 13.4824
R4929 VSS.n821 VSS.n679 13.4824
R4930 VSS.n818 VSS.n677 13.4824
R4931 VSS.n3610 VSS.n3606 13.4824
R4932 VSS.t551 VSS.n1721 13.4793
R4933 VSS.n1299 VSS.n1092 13.4205
R4934 VSS.n1306 VSS.n1078 13.4205
R4935 VSS.n1308 VSS.n1092 13.4198
R4936 VSS.n899 VSS.t89 13.4105
R4937 VSS.n915 VSS.t163 13.4105
R4938 VSS.n1015 VSS.t913 13.4105
R4939 VSS.n1028 VSS.t1023 13.4105
R4940 VSS.t293 VSS.n653 13.4105
R4941 VSS.t283 VSS.n547 13.4105
R4942 VSS.t279 VSS.n645 13.4105
R4943 VSS.t288 VSS.n638 13.4105
R4944 VSS.t285 VSS.n661 13.4105
R4945 VSS.t285 VSS.n631 13.4105
R4946 VSS.t289 VSS.n536 13.4105
R4947 VSS.t289 VSS.n623 13.4105
R4948 VSS.t281 VSS.n533 13.4105
R4949 VSS.t281 VSS.n611 13.4105
R4950 VSS.t1025 VSS.n2596 13.4105
R4951 VSS.n2614 VSS.t277 13.4105
R4952 VSS.t275 VSS.n2674 13.4105
R4953 VSS.t275 VSS.n502 13.4105
R4954 VSS.t269 VSS.n2661 13.4105
R4955 VSS.t269 VSS.n499 13.4105
R4956 VSS.t276 VSS.n2654 13.4105
R4957 VSS.t276 VSS.n496 13.4105
R4958 VSS.t262 VSS.n2647 13.4105
R4959 VSS.t274 VSS.n493 13.4105
R4960 VSS.t270 VSS.n2639 13.4105
R4961 VSS.t268 VSS.n490 13.4105
R4962 VSS.t264 VSS.n2631 13.4105
R4963 VSS.t15 VSS.n105 13.4105
R4964 VSS.t23 VSS.n3399 13.4105
R4965 VSS.t21 VSS.n49 13.4105
R4966 VSS.t17 VSS.n3394 13.4105
R4967 VSS.t11 VSS.n93 13.4105
R4968 VSS.t19 VSS.n53 13.4105
R4969 VSS.t22 VSS.n3388 13.4105
R4970 VSS.t22 VSS.n81 13.4105
R4971 VSS.t13 VSS.n3384 13.4105
R4972 VSS.t13 VSS.n59 13.4105
R4973 VSS.n3206 VSS.t24 13.4105
R4974 VSS.t1030 VSS.n3230 13.4105
R4975 VSS.n3339 VSS.t182 13.4105
R4976 VSS.t182 VSS.n3338 13.4105
R4977 VSS.n3333 VSS.t176 13.4105
R4978 VSS.t176 VSS.n3332 13.4105
R4979 VSS.n3327 VSS.t183 13.4105
R4980 VSS.t180 VSS.n3325 13.4105
R4981 VSS.t177 VSS.n3322 13.4105
R4982 VSS.t172 VSS.n3319 13.4105
R4983 VSS.t184 VSS.n3316 13.4105
R4984 VSS.t174 VSS.n3313 13.4105
R4985 VSS.n2351 VSS.n1478 13.3161
R4986 VSS.n2377 VSS.n1458 13.3161
R4987 VSS.n1296 VSS.t1033 12.8379
R4988 VSS.n1288 VSS.n1149 12.5394
R4989 VSS.n1151 VSS.n1150 12.5394
R4990 VSS.n1286 VSS.n1153 12.5394
R4991 VSS.n1157 VSS.n1156 12.5394
R4992 VSS.n1285 VSS.n1161 12.5394
R4993 VSS.n2503 VSS.n1255 12.5394
R4994 VSS.n2502 VSS.n1251 12.5394
R4995 VSS.n1250 VSS.n1249 12.5394
R4996 VSS.n1284 VSS.n1246 12.5394
R4997 VSS.n1245 VSS.n1244 12.5394
R4998 VSS.n1283 VSS.n1240 12.5394
R4999 VSS.n1240 VSS.n1239 12.5394
R5000 VSS.n1282 VSS.n1168 12.5394
R5001 VSS.n1172 VSS.n1171 12.5394
R5002 VSS.n1281 VSS.n1175 12.5394
R5003 VSS.n1177 VSS.n1176 12.5394
R5004 VSS.n1280 VSS.n1180 12.5394
R5005 VSS.n1279 VSS.n1278 12.5394
R5006 VSS.n1330 VSS.n1096 12.5394
R5007 VSS.n1329 VSS.n1083 12.5394
R5008 VSS.n1278 VSS.n1180 12.5394
R5009 VSS.n1176 VSS.n1175 12.5394
R5010 VSS.n1171 VSS.n1168 12.5394
R5011 VSS.n1288 VSS.n1287 12.5394
R5012 VSS.n1286 VSS.n1151 12.5394
R5013 VSS.n1285 VSS.n1157 12.5394
R5014 VSS.n2503 VSS.n2502 12.5394
R5015 VSS.n1284 VSS.n1249 12.5394
R5016 VSS.n1283 VSS.n1241 12.5394
R5017 VSS.n1282 VSS.n1162 12.5394
R5018 VSS.n1281 VSS.n1172 12.5394
R5019 VSS.n1280 VSS.n1177 12.5394
R5020 VSS.n1239 VSS.n1162 12.5394
R5021 VSS.n1246 VSS.n1245 12.5394
R5022 VSS.n1251 VSS.n1250 12.5394
R5023 VSS.n1255 VSS.n1161 12.5394
R5024 VSS.n1156 VSS.n1153 12.5394
R5025 VSS.n1150 VSS.n1149 12.5394
R5026 VSS.t136 VSS.n1470 12.5179
R5027 VSS.t136 VSS.n1466 12.5179
R5028 VSS.n2081 VSS.t1028 12.4032
R5029 VSS.n390 VSS.n389 12.299
R5030 VSS.n381 VSS.n380 12.299
R5031 VSS.n372 VSS.n371 12.299
R5032 VSS.n356 VSS.n355 12.299
R5033 VSS.n347 VSS.n307 12.299
R5034 VSS.n3438 VSS.n3437 12.299
R5035 VSS.n352 VSS.n350 12.299
R5036 VSS.n3410 VSS.n360 12.299
R5037 VSS.n2928 VSS.n2872 12.299
R5038 VSS.n386 VSS.n385 12.299
R5039 VSS.n377 VSS.n376 12.299
R5040 VSS.n368 VSS.n367 12.299
R5041 VSS.t92 VSS.n2133 12.2653
R5042 VSS.n1732 VSS.t238 12.0352
R5043 VSS.n3304 VSS.n3240 11.8434
R5044 VSS.n3200 VSS.n3199 11.8401
R5045 VSS.n1822 VSS.n1663 11.7245
R5046 VSS.n1832 VSS.n1708 11.7245
R5047 VSS.n1824 VSS.n1664 11.7245
R5048 VSS.n1828 VSS.n1707 11.7245
R5049 VSS.n893 VSS.n741 11.4948
R5050 VSS.n895 VSS.n738 11.4948
R5051 VSS.n896 VSS.n743 11.4948
R5052 VSS.n899 VSS.n736 11.4948
R5053 VSS.t105 VSS.n772 11.4948
R5054 VSS.t114 VSS.n698 11.4948
R5055 VSS.n1031 VSS.n680 11.4948
R5056 VSS.n1030 VSS.n805 11.4948
R5057 VSS.n822 VSS.n671 11.4948
R5058 VSS.t226 VSS.t551 11.0724
R5059 VSS.n663 VSS.t291 11.0188
R5060 VSS.n2349 VSS.t1064 10.4317
R5061 VSS.n2379 VSS.t1068 10.4317
R5062 VSS.n2395 VSS.t385 10.1254
R5063 VSS.t431 VSS.n1553 10.1254
R5064 VSS.t222 VSS.n1719 10.1096
R5065 VSS.n2035 VSS.n1791 10.1096
R5066 VSS.n1792 VSS.t231 10.1096
R5067 VSS.n554 VSS 9.92617
R5068 VSS.n3623 VSS 9.92617
R5069 VSS.t924 VSS.n2351 9.87992
R5070 VSS.t473 VSS.n2377 9.87992
R5071 VSS.n2551 VSS 9.85283
R5072 VSS.n1741 VSS.n1642 9.5576
R5073 VSS.n1832 VSS.n1831 9.40091
R5074 VSS.n1828 VSS.n1827 9.40091
R5075 VSS.n1824 VSS.n1823 9.40091
R5076 VSS.n1822 VSS.n1821 9.40091
R5077 VSS.n3361 VSS.n3360 9.37071
R5078 VSS.n2621 VSS.n2620 9.37071
R5079 VSS.n959 VSS.n958 9.37071
R5080 VSS.n3362 VSS.n3361 9.3176
R5081 VSS.n2622 VSS.n2621 9.3176
R5082 VSS.n960 VSS.n959 9.3176
R5083 VSS.n1384 VSS.n1383 9.27825
R5084 VSS.n1386 VSS.n1385 9.27642
R5085 VSS.n2965 VSS.t773 9.15481
R5086 VSS.n2959 VSS.t585 9.15481
R5087 VSS.n2953 VSS.t784 9.15481
R5088 VSS.n2948 VSS.t738 9.15481
R5089 VSS.n2945 VSS.t558 9.15481
R5090 VSS.n2934 VSS.t638 9.15481
R5091 VSS.n2937 VSS.t862 9.15481
R5092 VSS.n2940 VSS.t643 9.15481
R5093 VSS.t867 VSS.n233 9.15481
R5094 VSS.t652 VSS.n227 9.15481
R5095 VSS.t872 VSS.n221 9.15481
R5096 VSS.t571 VSS.n193 9.15481
R5097 VSS.t762 VSS.n3579 9.15481
R5098 VSS.n213 VSS.t718 9.15481
R5099 VSS.n207 VSS.t548 9.15481
R5100 VSS.n200 VSS.t723 9.15481
R5101 VSS.t239 VSS.t235 9.14684
R5102 VSS.n1962 VSS.n1961 9.13564
R5103 VSS.n1394 VSS.n1393 9.0005
R5104 VSS.n1397 VSS.n1396 9.0005
R5105 VSS.n1820 VSS.t239 8.84882
R5106 VSS.n1848 VSS.n1826 8.7008
R5107 VSS.n2171 VSS.n1969 8.6978
R5108 VSS.n1796 VSS.n1658 8.66546
R5109 VSS.n1794 VSS.n1712 8.66546
R5110 VSS.n2194 VSS.t501 8.66546
R5111 VSS.n1890 VSS.t599 8.66546
R5112 VSS.n1947 VSS.n1575 8.54141
R5113 VSS.n2501 VSS 8.52062
R5114 VSS.n3435 VSS.n3434 8.50175
R5115 VSS.n2886 VSS.n2885 8.501
R5116 VSS.n2885 VSS.n2884 8.501
R5117 VSS.n2891 VSS.n2878 8.501
R5118 VSS.n1052 VSS.n1000 8.501
R5119 VSS.n1053 VSS.n1052 8.501
R5120 VSS.n1415 VSS.n1414 8.501
R5121 VSS.n1415 VSS.n1410 8.501
R5122 VSS.n1416 VSS.n1415 8.501
R5123 VSS.n2496 VSS.n1347 8.501
R5124 VSS.n2497 VSS.n2496 8.501
R5125 VSS.n1256 VSS.n1138 8.501
R5126 VSS.n1324 VSS.n1323 8.501
R5127 VSS.n1324 VSS.n1079 8.501
R5128 VSS.n2511 VSS.n1139 8.501
R5129 VSS.n2511 VSS.n2510 8.501
R5130 VSS.n2477 VSS.n1348 8.501
R5131 VSS.n2479 VSS.n1348 8.501
R5132 VSS.n2481 VSS.n1348 8.501
R5133 VSS.n2483 VSS.n1348 8.501
R5134 VSS.n2485 VSS.n1348 8.501
R5135 VSS.n2487 VSS.n1348 8.501
R5136 VSS.n2489 VSS.n1348 8.501
R5137 VSS.n2447 VSS.n1421 8.501
R5138 VSS.n2447 VSS.n2446 8.501
R5139 VSS.n2447 VSS.n2445 8.501
R5140 VSS.n2447 VSS.n2444 8.501
R5141 VSS.n2447 VSS.n2443 8.501
R5142 VSS.n2447 VSS.n2442 8.501
R5143 VSS.n2447 VSS.n2441 8.501
R5144 VSS.n2447 VSS.n2440 8.501
R5145 VSS.n2447 VSS.n1431 8.501
R5146 VSS.n2434 VSS.n2419 8.501
R5147 VSS.n2434 VSS.n2421 8.501
R5148 VSS.n2434 VSS.n2423 8.501
R5149 VSS.n2434 VSS.n2425 8.501
R5150 VSS.n2434 VSS.n2427 8.501
R5151 VSS.n2434 VSS.n2429 8.501
R5152 VSS.n2434 VSS.n2431 8.501
R5153 VSS.n2434 VSS.n2433 8.501
R5154 VSS.n2435 VSS.n2434 8.501
R5155 VSS.n1513 VSS.n1512 8.501
R5156 VSS.n1513 VSS.n1444 8.501
R5157 VSS.n1509 VSS.n1505 8.501
R5158 VSS.n1509 VSS.n1508 8.501
R5159 VSS.n2331 VSS.n1502 8.501
R5160 VSS.n2333 VSS.n1502 8.501
R5161 VSS.n2031 VSS.n1972 8.501
R5162 VSS.n2031 VSS.n1975 8.501
R5163 VSS.n2019 VSS.n1969 8.501
R5164 VSS.n2220 VSS.n1839 8.501
R5165 VSS.n1809 VSS.n1808 8.501
R5166 VSS.n1809 VSS.n1807 8.501
R5167 VSS.n1810 VSS.n1809 8.501
R5168 VSS.n1765 VSS.n1737 8.501
R5169 VSS.n1846 VSS.n1833 8.501
R5170 VSS.n1877 VSS.n1846 8.501
R5171 VSS.n2233 VSS.n1742 8.501
R5172 VSS.n2233 VSS.n1743 8.501
R5173 VSS.n2233 VSS.n1745 8.501
R5174 VSS.n2233 VSS.n1740 8.501
R5175 VSS.n1988 VSS.n1982 8.501
R5176 VSS.n1988 VSS.n1983 8.501
R5177 VSS.n1996 VSS.n1988 8.501
R5178 VSS.n1993 VSS.n1988 8.501
R5179 VSS.n2009 VSS.n1988 8.501
R5180 VSS.n2145 VSS.n1980 8.501
R5181 VSS.n2146 VSS.n2145 8.501
R5182 VSS.n2145 VSS.n1989 8.501
R5183 VSS.n2145 VSS.n1990 8.501
R5184 VSS.n2145 VSS.n1991 8.501
R5185 VSS.n2065 VSS.n2041 8.501
R5186 VSS.n2065 VSS.n2042 8.501
R5187 VSS.n2065 VSS.n2043 8.501
R5188 VSS.n2065 VSS.n2044 8.501
R5189 VSS.n2065 VSS.n2063 8.501
R5190 VSS.n2069 VSS.n2039 8.501
R5191 VSS.n3052 VSS.n3051 8.501
R5192 VSS.n3051 VSS.n2758 8.501
R5193 VSS.n3075 VSS.n2696 8.501
R5194 VSS.n3075 VSS.n2697 8.501
R5195 VSS.n3075 VSS.n2698 8.501
R5196 VSS.n3075 VSS.n2699 8.501
R5197 VSS.n3075 VSS.n2723 8.501
R5198 VSS.n3075 VSS.n2691 8.501
R5199 VSS.n3075 VSS.n2692 8.501
R5200 VSS.n3076 VSS.n3075 8.501
R5201 VSS.n3159 VSS.n562 8.501
R5202 VSS.n3159 VSS.n563 8.501
R5203 VSS.n3159 VSS.n564 8.501
R5204 VSS.n3159 VSS.n565 8.501
R5205 VSS.n3159 VSS.n566 8.501
R5206 VSS.n3159 VSS.n567 8.501
R5207 VSS.n3160 VSS.n3159 8.501
R5208 VSS.n2694 VSS.n480 8.501
R5209 VSS.n2325 VSS.n2313 8.501
R5210 VSS.n2325 VSS.n2315 8.501
R5211 VSS.n2325 VSS.n2317 8.501
R5212 VSS.n2325 VSS.n2319 8.501
R5213 VSS.n2325 VSS.n2321 8.501
R5214 VSS.n2325 VSS.n2324 8.501
R5215 VSS.n2325 VSS.n1543 8.501
R5216 VSS.n891 VSS.n861 8.501
R5217 VSS.n891 VSS.n862 8.501
R5218 VSS.n891 VSS.n863 8.501
R5219 VSS.n891 VSS.n865 8.501
R5220 VSS.n891 VSS.n849 8.501
R5221 VSS.n891 VSS.n850 8.501
R5222 VSS.n891 VSS.n866 8.501
R5223 VSS.n817 VSS.n676 8.501
R5224 VSS.n2471 VSS.n2453 8.501
R5225 VSS.n2471 VSS.n2455 8.501
R5226 VSS.n2471 VSS.n2457 8.501
R5227 VSS.n2471 VSS.n2459 8.501
R5228 VSS.n2471 VSS.n2461 8.501
R5229 VSS.n2471 VSS.n2463 8.501
R5230 VSS.n2471 VSS.n2465 8.501
R5231 VSS.n2471 VSS.n2467 8.501
R5232 VSS.n2471 VSS.n2470 8.501
R5233 VSS.n2471 VSS.n852 8.501
R5234 VSS.n1538 VSS.n1520 8.501
R5235 VSS.n1538 VSS.n1522 8.501
R5236 VSS.n1538 VSS.n1524 8.501
R5237 VSS.n1538 VSS.n1526 8.501
R5238 VSS.n1538 VSS.n1528 8.501
R5239 VSS.n1538 VSS.n1530 8.501
R5240 VSS.n1538 VSS.n1532 8.501
R5241 VSS.n1538 VSS.n1534 8.501
R5242 VSS.n1538 VSS.n1537 8.501
R5243 VSS.n1538 VSS.n1420 8.501
R5244 VSS.n2304 VSS.n1560 8.501
R5245 VSS.n2304 VSS.n1561 8.501
R5246 VSS.n2304 VSS.n1562 8.501
R5247 VSS.n2304 VSS.n1563 8.501
R5248 VSS.n2304 VSS.n1564 8.501
R5249 VSS.n2304 VSS.n1565 8.501
R5250 VSS.n2304 VSS.n1566 8.501
R5251 VSS.n3353 VSS.n3247 8.501
R5252 VSS.n2581 VSS.n2580 8.501
R5253 VSS.n3097 VSS.n3096 8.501
R5254 VSS.n3414 VSS.n3413 8.501
R5255 VSS.n2338 VSS.n2328 8.501
R5256 VSS.n2494 VSS.n2474 8.501
R5257 VSS.n2902 VSS.n2876 8.501
R5258 VSS.n2928 VSS.n2863 8.501
R5259 VSS.n2928 VSS.n2864 8.501
R5260 VSS.n2928 VSS.n2865 8.501
R5261 VSS.n2928 VSS.n2866 8.501
R5262 VSS.n2928 VSS.n2867 8.501
R5263 VSS.n2928 VSS.n2868 8.501
R5264 VSS.n2928 VSS.n2869 8.501
R5265 VSS.n3434 VSS.n308 8.501
R5266 VSS.n3036 VSS.n3035 8.501
R5267 VSS.n2974 VSS.n2973 8.501
R5268 VSS.n3442 VSS.n3441 8.501
R5269 VSS.n3442 VSS.n301 8.501
R5270 VSS.n3442 VSS.n300 8.501
R5271 VSS.n3442 VSS.n299 8.501
R5272 VSS.n3442 VSS.n298 8.501
R5273 VSS.n2928 VSS.n395 8.501
R5274 VSS.n2928 VSS.n396 8.501
R5275 VSS.n2928 VSS.n2870 8.501
R5276 VSS.n2928 VSS.n2871 8.501
R5277 VSS.n2928 VSS.n401 8.501
R5278 VSS.n2928 VSS.n402 8.501
R5279 VSS.n3180 VSS.n421 8.501
R5280 VSS.n3180 VSS.n422 8.501
R5281 VSS.n3180 VSS.n423 8.501
R5282 VSS.n3180 VSS.n424 8.501
R5283 VSS.n3180 VSS.n425 8.501
R5284 VSS.n3180 VSS.n426 8.501
R5285 VSS.n3180 VSS.n427 8.501
R5286 VSS.n3180 VSS.n428 8.501
R5287 VSS.n3180 VSS.n429 8.501
R5288 VSS.n3181 VSS.n3180 8.501
R5289 VSS.n198 VSS.n197 8.501
R5290 VSS.n3539 VSS.n188 8.501
R5291 VSS.n3574 VSS.n241 8.501
R5292 VSS.n3469 VSS.n250 8.501
R5293 VSS.n3469 VSS.n251 8.501
R5294 VSS.n3469 VSS.n253 8.501
R5295 VSS.n3469 VSS.n3444 8.501
R5296 VSS.n3469 VSS.n3445 8.501
R5297 VSS.n3469 VSS.n3454 8.501
R5298 VSS.n3469 VSS.n3455 8.501
R5299 VSS.n3469 VSS.n3456 8.501
R5300 VSS.n3469 VSS.n3467 8.501
R5301 VSS.n3470 VSS.n3469 8.501
R5302 VSS.n3480 VSS.n274 8.501
R5303 VSS.n3480 VSS.n275 8.501
R5304 VSS.n3480 VSS.n276 8.501
R5305 VSS.n3480 VSS.n277 8.501
R5306 VSS.n3480 VSS.n278 8.501
R5307 VSS.n3480 VSS.n279 8.501
R5308 VSS.n3480 VSS.n280 8.501
R5309 VSS.n3480 VSS.n281 8.501
R5310 VSS.n3481 VSS.n3480 8.501
R5311 VSS.n3480 VSS.n22 8.501
R5312 VSS.n3050 VSS.n2725 8.501
R5313 VSS.n3050 VSS.n2773 8.501
R5314 VSS.n3050 VSS.n2770 8.501
R5315 VSS.n3050 VSS.n2768 8.501
R5316 VSS.n3050 VSS.n2766 8.501
R5317 VSS.n3050 VSS.n2764 8.501
R5318 VSS.n3050 VSS.n2762 8.501
R5319 VSS.n3619 VSS.n3618 8.501
R5320 VSS.n3618 VSS.n29 8.501
R5321 VSS.n3618 VSS.n28 8.501
R5322 VSS.n3618 VSS.n27 8.501
R5323 VSS.n3618 VSS.n26 8.501
R5324 VSS.n3618 VSS.n25 8.501
R5325 VSS.n3618 VSS.n24 8.501
R5326 VSS.n3613 VSS.n42 8.501
R5327 VSS.n3613 VSS.n41 8.501
R5328 VSS.n3403 VSS.n3192 8.501
R5329 VSS.n2191 VSS.n1573 8.50086
R5330 VSS.n2203 VSS.n1573 8.50086
R5331 VSS.n2201 VSS.n1573 8.50086
R5332 VSS.n2206 VSS.n1573 8.50086
R5333 VSS.n1713 VSS.n1573 8.5007
R5334 VSS.n1859 VSS.n1573 8.5007
R5335 VSS.n1733 VSS.n1573 8.5006
R5336 VSS.n2238 VSS.n1573 8.5006
R5337 VSS.n1603 VSS.n1573 8.5006
R5338 VSS.n1154 VSS.n1142 8.50051
R5339 VSS.n1407 VSS.n1142 8.50051
R5340 VSS.n2504 VSS.n1148 8.50051
R5341 VSS.n2498 VSS.n1321 8.5005
R5342 VSS.n2498 VSS.n1318 8.5005
R5343 VSS.n2498 VSS.n1317 8.5005
R5344 VSS.n2498 VSS.n1316 8.5005
R5345 VSS.n2498 VSS.n1315 8.5005
R5346 VSS.n2498 VSS.n1314 8.5005
R5347 VSS.n2498 VSS.n1313 8.5005
R5348 VSS.n2498 VSS.n1312 8.5005
R5349 VSS.n2498 VSS.n1311 8.5005
R5350 VSS.n2498 VSS.n1310 8.5005
R5351 VSS.n2498 VSS.n1309 8.5005
R5352 VSS.n2498 VSS.n1329 8.5005
R5353 VSS.n2498 VSS.n1330 8.5005
R5354 VSS.n2498 VSS.n1331 8.5005
R5355 VSS.n2498 VSS.n1332 8.5005
R5356 VSS.n2498 VSS.n1333 8.5005
R5357 VSS.n2498 VSS.n1334 8.5005
R5358 VSS.n2498 VSS.n1335 8.5005
R5359 VSS.n2498 VSS.n1336 8.5005
R5360 VSS.n2498 VSS.n1337 8.5005
R5361 VSS.n2498 VSS.n1338 8.5005
R5362 VSS.n2498 VSS.n1339 8.5005
R5363 VSS.n2498 VSS.n1340 8.5005
R5364 VSS.n2515 VSS.n1076 8.5005
R5365 VSS.n2515 VSS.n1075 8.5005
R5366 VSS.n2508 VSS.n1137 8.5005
R5367 VSS.n2508 VSS.n1140 8.5005
R5368 VSS.n2509 VSS.n2508 8.5005
R5369 VSS.n2504 VSS.n1238 8.5005
R5370 VSS.n2476 VSS.n853 8.5005
R5371 VSS.n2478 VSS.n853 8.5005
R5372 VSS.n2480 VSS.n853 8.5005
R5373 VSS.n2482 VSS.n853 8.5005
R5374 VSS.n2484 VSS.n853 8.5005
R5375 VSS.n2486 VSS.n853 8.5005
R5376 VSS.n2488 VSS.n853 8.5005
R5377 VSS.n2490 VSS.n853 8.5005
R5378 VSS.n2450 VSS.n1423 8.5005
R5379 VSS.n2450 VSS.n1424 8.5005
R5380 VSS.n2450 VSS.n1425 8.5005
R5381 VSS.n2450 VSS.n1426 8.5005
R5382 VSS.n2450 VSS.n1427 8.5005
R5383 VSS.n2450 VSS.n1428 8.5005
R5384 VSS.n2450 VSS.n1429 8.5005
R5385 VSS.n2450 VSS.n1430 8.5005
R5386 VSS.n2450 VSS.n2449 8.5005
R5387 VSS.n2418 VSS.n1419 8.5005
R5388 VSS.n2420 VSS.n1419 8.5005
R5389 VSS.n2422 VSS.n1419 8.5005
R5390 VSS.n2424 VSS.n1419 8.5005
R5391 VSS.n2426 VSS.n1419 8.5005
R5392 VSS.n2428 VSS.n1419 8.5005
R5393 VSS.n2430 VSS.n1419 8.5005
R5394 VSS.n2432 VSS.n1419 8.5005
R5395 VSS.n1434 VSS.n1419 8.5005
R5396 VSS.n2407 VSS.n2387 8.5005
R5397 VSS.n2407 VSS.n2391 8.5005
R5398 VSS.n2407 VSS.n2394 8.5005
R5399 VSS.n2407 VSS.n2401 8.5005
R5400 VSS.n2407 VSS.n2403 8.5005
R5401 VSS.n2416 VSS.n1443 8.5005
R5402 VSS.n2414 VSS.n1500 8.5005
R5403 VSS.n1504 VSS.n1500 8.5005
R5404 VSS.n1506 VSS.n1500 8.5005
R5405 VSS.n1507 VSS.n1500 8.5005
R5406 VSS.n2416 VSS.n1500 8.5005
R5407 VSS.n2407 VSS.n1549 8.5005
R5408 VSS.n2408 VSS.n2407 8.5005
R5409 VSS.n2407 VSS.n1552 8.5005
R5410 VSS.n2407 VSS.n1554 8.5005
R5411 VSS.n2407 VSS.n2341 8.5005
R5412 VSS.n2330 VSS.n1547 8.5005
R5413 VSS.n2332 VSS.n1547 8.5005
R5414 VSS.n2334 VSS.n1547 8.5005
R5415 VSS.n2027 VSS.n1970 8.5005
R5416 VSS.n2025 VSS.n1970 8.5005
R5417 VSS.n2023 VSS.n1970 8.5005
R5418 VSS.n2021 VSS.n1970 8.5005
R5419 VSS.n1655 VSS.n1573 8.5005
R5420 VSS.n1718 VSS.n1573 8.5005
R5421 VSS.n1653 VSS.n1573 8.5005
R5422 VSS.n1720 VSS.n1573 8.5005
R5423 VSS.n1651 VSS.n1573 8.5005
R5424 VSS.n1722 VSS.n1573 8.5005
R5425 VSS.n1649 VSS.n1573 8.5005
R5426 VSS.n1725 VSS.n1573 8.5005
R5427 VSS.n1654 VSS.n1573 8.5005
R5428 VSS.n1719 VSS.n1573 8.5005
R5429 VSS.n1652 VSS.n1573 8.5005
R5430 VSS.n1721 VSS.n1573 8.5005
R5431 VSS.n1650 VSS.n1573 8.5005
R5432 VSS.n2218 VSS.n1836 8.5005
R5433 VSS.n1884 VSS.n1836 8.5005
R5434 VSS.n1837 VSS.n1836 8.5005
R5435 VSS.n2232 VSS.n1642 8.5005
R5436 VSS.n1813 VSS.n1812 8.5005
R5437 VSS.n1814 VSS.n1813 8.5005
R5438 VSS.n1813 VSS.n1811 8.5005
R5439 VSS.n1850 VSS.n1836 8.5005
R5440 VSS.n2246 VSS.n1604 8.5005
R5441 VSS.n2246 VSS.n1608 8.5005
R5442 VSS.n2246 VSS.n1609 8.5005
R5443 VSS.n2246 VSS.n1610 8.5005
R5444 VSS.n2246 VSS.n1611 8.5005
R5445 VSS.n2246 VSS.n1612 8.5005
R5446 VSS.n2246 VSS.n1613 8.5005
R5447 VSS.n2246 VSS.n1614 8.5005
R5448 VSS.n2246 VSS.n1615 8.5005
R5449 VSS.n2246 VSS.n1616 8.5005
R5450 VSS.n2246 VSS.n1617 8.5005
R5451 VSS.n2246 VSS.n1640 8.5005
R5452 VSS.n2247 VSS.n1572 8.5005
R5453 VSS.n1556 VSS.n1547 8.5005
R5454 VSS.n2314 VSS.n1547 8.5005
R5455 VSS.n2316 VSS.n1547 8.5005
R5456 VSS.n2318 VSS.n1547 8.5005
R5457 VSS.n2320 VSS.n1547 8.5005
R5458 VSS.n2322 VSS.n1547 8.5005
R5459 VSS.n2323 VSS.n1547 8.5005
R5460 VSS.n1350 VSS.n853 8.5005
R5461 VSS.n2454 VSS.n853 8.5005
R5462 VSS.n2456 VSS.n853 8.5005
R5463 VSS.n2458 VSS.n853 8.5005
R5464 VSS.n2460 VSS.n853 8.5005
R5465 VSS.n2462 VSS.n853 8.5005
R5466 VSS.n2464 VSS.n853 8.5005
R5467 VSS.n2466 VSS.n853 8.5005
R5468 VSS.n2468 VSS.n853 8.5005
R5469 VSS.n2469 VSS.n853 8.5005
R5470 VSS.n1519 VSS.n1419 8.5005
R5471 VSS.n1521 VSS.n1419 8.5005
R5472 VSS.n1523 VSS.n1419 8.5005
R5473 VSS.n1525 VSS.n1419 8.5005
R5474 VSS.n1527 VSS.n1419 8.5005
R5475 VSS.n1529 VSS.n1419 8.5005
R5476 VSS.n1531 VSS.n1419 8.5005
R5477 VSS.n1533 VSS.n1419 8.5005
R5478 VSS.n1535 VSS.n1419 8.5005
R5479 VSS.n1536 VSS.n1419 8.5005
R5480 VSS.n2291 VSS.n1557 8.5005
R5481 VSS.n2249 VSS.n1557 8.5005
R5482 VSS.n2287 VSS.n1557 8.5005
R5483 VSS.n2288 VSS.n1557 8.5005
R5484 VSS.n2277 VSS.n1557 8.5005
R5485 VSS.n2272 VSS.n1557 8.5005
R5486 VSS.n2254 VSS.n1557 8.5005
R5487 VSS.n2256 VSS.n1557 8.5005
R5488 VSS.n2258 VSS.n1557 8.5005
R5489 VSS.n2302 VSS.n2301 8.5005
R5490 VSS.n2301 VSS.n2294 8.5005
R5491 VSS.n2301 VSS.n2295 8.5005
R5492 VSS.n2301 VSS.n2296 8.5005
R5493 VSS.n2301 VSS.n2297 8.5005
R5494 VSS.n2301 VSS.n2298 8.5005
R5495 VSS.n2301 VSS.n2299 8.5005
R5496 VSS.n2301 VSS.n2300 8.5005
R5497 VSS.n1060 VSS.n1059 8.5005
R5498 VSS.n1047 VSS.n1046 8.5005
R5499 VSS.n2329 VSS.n1547 8.5005
R5500 VSS.n2475 VSS.n853 8.5005
R5501 VSS.n3034 VSS.n2942 8.5005
R5502 VSS.n3038 VSS.n3037 8.5005
R5503 VSS.n3034 VSS.n3033 8.5005
R5504 VSS.n3033 VSS.n2972 8.5005
R5505 VSS.n3033 VSS.n3032 8.5005
R5506 VSS.n3041 VSS.n2823 8.5005
R5507 VSS.n3578 VSS.n3577 8.5005
R5508 VSS.n3577 VSS.n240 8.5005
R5509 VSS.n3577 VSS.n3576 8.5005
R5510 VSS.n3483 VSS.n267 8.5005
R5511 VSS.n3483 VSS.n268 8.5005
R5512 VSS.n3483 VSS.n269 8.5005
R5513 VSS.n3483 VSS.n270 8.5005
R5514 VSS.n3483 VSS.n271 8.5005
R5515 VSS.n3483 VSS.n272 8.5005
R5516 VSS.n3483 VSS.n3482 8.5005
R5517 VSS.n2772 VSS.n2759 8.5005
R5518 VSS.n2771 VSS.n2759 8.5005
R5519 VSS.n2769 VSS.n2759 8.5005
R5520 VSS.n2767 VSS.n2759 8.5005
R5521 VSS.n2765 VSS.n2759 8.5005
R5522 VSS.n2763 VSS.n2759 8.5005
R5523 VSS.n2774 VSS.n2759 8.5005
R5524 VSS.n3605 VSS.n1 8.5005
R5525 VSS.n3308 VSS.n1 8.5005
R5526 VSS.n3310 VSS.n1 8.5005
R5527 VSS.n3312 VSS.n1 8.5005
R5528 VSS.n3314 VSS.n1 8.5005
R5529 VSS.n3316 VSS.n1 8.5005
R5530 VSS.n3318 VSS.n1 8.5005
R5531 VSS.n3320 VSS.n1 8.5005
R5532 VSS.n3322 VSS.n1 8.5005
R5533 VSS.n3324 VSS.n1 8.5005
R5534 VSS.n3328 VSS.n1 8.5005
R5535 VSS.n3330 VSS.n1 8.5005
R5536 VSS.n3332 VSS.n1 8.5005
R5537 VSS.n3334 VSS.n1 8.5005
R5538 VSS.n3336 VSS.n1 8.5005
R5539 VSS.n3338 VSS.n1 8.5005
R5540 VSS.n3340 VSS.n1 8.5005
R5541 VSS.n3342 VSS.n1 8.5005
R5542 VSS.n3344 VSS.n1 8.5005
R5543 VSS.n3305 VSS.n1 8.5005
R5544 VSS.n3239 VSS.n1 8.5005
R5545 VSS.n3237 VSS.n1 8.5005
R5546 VSS.n3243 VSS.n1 8.5005
R5547 VSS.n3229 VSS.n1 8.5005
R5548 VSS.n3224 VSS.n1 8.5005
R5549 VSS.n3221 VSS.n1 8.5005
R5550 VSS.n3603 VSS.n1 8.5005
R5551 VSS.n45 VSS.n1 8.5005
R5552 VSS.n104 VSS.n1 8.5005
R5553 VSS.n3398 VSS.n1 8.5005
R5554 VSS.n3399 VSS.n1 8.5005
R5555 VSS.n102 VSS.n1 8.5005
R5556 VSS.n3396 VSS.n1 8.5005
R5557 VSS.n3394 VSS.n1 8.5005
R5558 VSS.n92 VSS.n1 8.5005
R5559 VSS.n85 VSS.n1 8.5005
R5560 VSS.n3390 VSS.n1 8.5005
R5561 VSS.n3388 VSS.n1 8.5005
R5562 VSS.n80 VSS.n1 8.5005
R5563 VSS.n3386 VSS.n1 8.5005
R5564 VSS.n3384 VSS.n1 8.5005
R5565 VSS.n68 VSS.n1 8.5005
R5566 VSS.n69 VSS.n1 8.5005
R5567 VSS.n3196 VSS.n1 8.5005
R5568 VSS.n3198 VSS.n1 8.5005
R5569 VSS.n3201 VSS.n1 8.5005
R5570 VSS.n3203 VSS.n1 8.5005
R5571 VSS.n3205 VSS.n1 8.5005
R5572 VSS.n3214 VSS.n1 8.5005
R5573 VSS.n3216 VSS.n1 8.5005
R5574 VSS.n3218 VSS.n1 8.5005
R5575 VSS.n2451 VSS.n1354 8.50042
R5576 VSS.n2216 VSS.n1573 8.49997
R5577 VSS.n3057 VSS.n265 8.49921
R5578 VSS.n3057 VSS.n3056 8.49921
R5579 VSS.n3078 VSS.n3077 8.49908
R5580 VSS.n3062 VSS.n2736 8.49908
R5581 VSS.n2733 VSS.n583 8.49908
R5582 VSS.n3620 VSS.n13 8.49908
R5583 VSS.n130 VSS.n129 8.49908
R5584 VSS.n109 VSS.n1 8.49908
R5585 VSS.n196 VSS.n190 8.49853
R5586 VSS.n2507 VSS.n1142 8.49807
R5587 VSS.n3034 VSS.n2968 8.49791
R5588 VSS.n3578 VSS.n236 8.49791
R5589 VSS.n1178 VSS.n1142 8.49787
R5590 VSS.n1173 VSS.n1142 8.49787
R5591 VSS.n2504 VSS.n1174 8.49787
R5592 VSS.n3070 VSS.n3068 8.49776
R5593 VSS.n3616 VSS.n3615 8.49776
R5594 VSS.n2498 VSS.n1307 8.49746
R5595 VSS.n2501 VSS.n1291 8.49746
R5596 VSS.n3182 VSS.n418 8.49742
R5597 VSS.n3176 VSS.n431 8.49742
R5598 VSS.n437 VSS.n436 8.49742
R5599 VSS.n456 VSS.n455 8.49742
R5600 VSS.n443 VSS.n420 8.49742
R5601 VSS.n3616 VSS.n39 8.49742
R5602 VSS.n3581 VSS.n165 8.49742
R5603 VSS.n3581 VSS.n170 8.49742
R5604 VSS.n3581 VSS.n161 8.49742
R5605 VSS.n3581 VSS.n173 8.49742
R5606 VSS.n3581 VSS.n158 8.49742
R5607 VSS.n3581 VSS.n176 8.49742
R5608 VSS.n3497 VSS.n248 8.49742
R5609 VSS.n3443 VSS.n254 8.49742
R5610 VSS.n3458 VSS.n3457 8.49742
R5611 VSS.n295 VSS.n294 8.49742
R5612 VSS.n3471 VSS.n289 8.49742
R5613 VSS.n283 VSS.n282 8.49742
R5614 VSS.n2182 VSS.n1573 8.49715
R5615 VSS.n2177 VSS.n1573 8.49715
R5616 VSS.n2573 VSS.n813 8.49712
R5617 VSS.n2573 VSS.n807 8.49712
R5618 VSS.n883 VSS.n882 8.49712
R5619 VSS.n864 VSS.n847 8.49712
R5620 VSS.n2554 VSS.n851 8.49712
R5621 VSS.n3154 VSS.n569 8.49677
R5622 VSS.n3141 VSS.n589 8.49677
R5623 VSS.n592 VSS.n560 8.49677
R5624 VSS.n2 VSS.n1 8.49677
R5625 VSS.n3639 VSS.n1 8.49677
R5626 VSS.n2504 VSS.n1248 8.49635
R5627 VSS.n2504 VSS.n1243 8.49635
R5628 VSS.n2504 VSS.n1163 8.49635
R5629 VSS.n1242 VSS.n1142 8.49635
R5630 VSS.n1247 VSS.n1142 8.49635
R5631 VSS.n1252 VSS.n1142 8.49635
R5632 VSS.n3048 VSS.n2785 8.496
R5633 VSS.n3048 VSS.n2782 8.496
R5634 VSS.n3041 VSS.n2854 8.496
R5635 VSS.n3041 VSS.n2859 8.496
R5636 VSS.n3041 VSS.n2844 8.496
R5637 VSS.n3041 VSS.n2862 8.496
R5638 VSS.n3042 VSS.n3041 8.496
R5639 VSS.n3435 VSS.n315 8.49469
R5640 VSS.n2894 VSS.n2893 8.49469
R5641 VSS.n2122 VSS.n2072 8.49469
R5642 VSS.n2111 VSS.n2072 8.49469
R5643 VSS.n2101 VSS.n2072 8.49469
R5644 VSS.n3057 VSS.n2748 8.49469
R5645 VSS.n2761 VSS.n405 8.49469
R5646 VSS.n3054 VSS.n3053 8.49469
R5647 VSS.n3418 VSS.n404 8.49469
R5648 VSS.n2898 VSS.n2877 8.49469
R5649 VSS.n2897 VSS.n2875 8.49469
R5650 VSS.n3435 VSS.n325 8.49469
R5651 VSS.n2924 VSS.n2873 8.49469
R5652 VSS.n2923 VSS.n2905 8.49469
R5653 VSS.n2919 VSS.n2907 8.49469
R5654 VSS.n2917 VSS.n2908 8.49469
R5655 VSS.n2916 VSS.n2909 8.49469
R5656 VSS.n2915 VSS.n2910 8.49469
R5657 VSS.n334 VSS.n333 8.49469
R5658 VSS.n337 VSS.n336 8.49469
R5659 VSS.n339 VSS.n338 8.49469
R5660 VSS.n3428 VSS.n397 8.49469
R5661 VSS.n3427 VSS.n398 8.49469
R5662 VSS.n3425 VSS.n399 8.49469
R5663 VSS.n2573 VSS.n725 8.49291
R5664 VSS.n2573 VSS.n691 8.49291
R5665 VSS.n2619 VSS.n583 8.49039
R5666 VSS.n2623 VSS.n583 8.49039
R5667 VSS.n3363 VSS.n1 8.49039
R5668 VSS.n3359 VSS.n1 8.49039
R5669 VSS.n1787 VSS.n1767 8.48686
R5670 VSS.n2228 VSS.n1772 8.48686
R5671 VSS.n2228 VSS.n1770 8.48686
R5672 VSS.n2229 VSS.n2228 8.48686
R5673 VSS.n2228 VSS.n1766 8.48686
R5674 VSS.n1986 VSS.n1978 8.48686
R5675 VSS.n2014 VSS.n1570 8.48686
R5676 VSS.n1995 VSS.n1994 8.48686
R5677 VSS.n3435 VSS.n365 8.48686
R5678 VSS.n1771 VSS.n1767 8.48686
R5679 VSS.n1768 VSS.n1767 8.48686
R5680 VSS.n2008 VSS.n2007 8.48686
R5681 VSS.n2012 VSS.n2011 8.48686
R5682 VSS.n3435 VSS.n327 8.48686
R5683 VSS.n3435 VSS.n346 8.48686
R5684 VSS.n3435 VSS.n349 8.48686
R5685 VSS.n3435 VSS.n354 8.48686
R5686 VSS.n3435 VSS.n358 8.48686
R5687 VSS.n3435 VSS.n362 8.48686
R5688 VSS.n3435 VSS.n370 8.48686
R5689 VSS.n3435 VSS.n375 8.48686
R5690 VSS.n3435 VSS.n379 8.48686
R5691 VSS.n3435 VSS.n384 8.48686
R5692 VSS.n3435 VSS.n388 8.48686
R5693 VSS.n392 VSS.n308 8.48686
R5694 VSS.n387 VSS.n308 8.48686
R5695 VSS.n383 VSS.n308 8.48686
R5696 VSS.n378 VSS.n308 8.48686
R5697 VSS.n374 VSS.n308 8.48686
R5698 VSS.n369 VSS.n308 8.48686
R5699 VSS.n364 VSS.n308 8.48686
R5700 VSS.n361 VSS.n308 8.48686
R5701 VSS.n357 VSS.n308 8.48686
R5702 VSS.n353 VSS.n308 8.48686
R5703 VSS.n348 VSS.n308 8.48686
R5704 VSS.n1059 VSS.n924 8.48362
R5705 VSS.n3303 VSS.n3260 8.48362
R5706 VSS.n3102 VSS.n2624 8.48362
R5707 VSS.n1883 VSS.n1843 8.48196
R5708 VSS.n1874 VSS.n1850 8.48196
R5709 VSS.n2228 VSS.n1835 8.48168
R5710 VSS.n1055 VSS.n997 8.46995
R5711 VSS.n1412 VSS.n1411 8.46995
R5712 VSS.n1413 VSS.n1409 8.46995
R5713 VSS.n1418 VSS.n1417 8.46995
R5714 VSS.n2228 VSS.n2227 8.46995
R5715 VSS.n2226 VSS.n2223 8.46995
R5716 VSS.n2225 VSS.n2224 8.46995
R5717 VSS.n1744 VSS.n1739 8.46995
R5718 VSS.n2236 VSS.n2235 8.46995
R5719 VSS.n2049 VSS.n2048 8.46995
R5720 VSS.n2054 VSS.n2050 8.46995
R5721 VSS.n2060 VSS.n2040 8.46995
R5722 VSS.n840 VSS.n829 8.46995
R5723 VSS.n3349 VSS.n3249 8.46995
R5724 VSS.n2584 VSS.n670 8.46995
R5725 VSS.n3100 VSS.n3094 8.46995
R5726 VSS.n3382 VSS.n3194 8.46995
R5727 VSS.n2232 VSS.n1757 8.46995
R5728 VSS.n2567 VSS.n829 8.46995
R5729 VSS.n1960 VSS.t676 8.45299
R5730 VSS.n1769 VSS.n1737 8.33978
R5731 VSS.n1769 VSS.n1644 8.33978
R5732 VSS.n2363 VSS.n1467 8.24944
R5733 VSS.n1960 VSS.t675 8.22563
R5734 VSS.n2892 VSS.n2891 8.19673
R5735 VSS.n1797 VSS.t237 8.18407
R5736 VSS.n3618 VSS.n11 8.02291
R5737 VSS.n2220 VSS.n1838 7.80935
R5738 VSS.n1932 VSS.n1931 7.80935
R5739 VSS.n1930 VSS.n1929 7.80935
R5740 VSS.n1928 VSS.n1927 7.80935
R5741 VSS.n1926 VSS.n1925 7.80935
R5742 VSS.n1924 VSS.n1923 7.80935
R5743 VSS.n1922 VSS.n1921 7.80935
R5744 VSS.n1920 VSS.n1919 7.80935
R5745 VSS.n1918 VSS.n1917 7.80935
R5746 VSS.n1909 VSS.n1689 7.80935
R5747 VSS.n1907 VSS.n1678 7.80935
R5748 VSS.n1905 VSS.n1688 7.80935
R5749 VSS.n1903 VSS.n1679 7.80935
R5750 VSS.n1901 VSS.n1687 7.80935
R5751 VSS.n1899 VSS.n1680 7.80935
R5752 VSS.n1897 VSS.n1686 7.80935
R5753 VSS.n1895 VSS.n1681 7.80935
R5754 VSS.n1893 VSS.n1685 7.80935
R5755 VSS.n1891 VSS.n1682 7.80935
R5756 VSS.n2241 VSS.n1641 7.80935
R5757 VSS.n1885 VSS.n1641 7.80935
R5758 VSS.n1892 VSS.n1891 7.80935
R5759 VSS.n1894 VSS.n1893 7.80935
R5760 VSS.n1896 VSS.n1895 7.80935
R5761 VSS.n1898 VSS.n1897 7.80935
R5762 VSS.n1900 VSS.n1899 7.80935
R5763 VSS.n1902 VSS.n1901 7.80935
R5764 VSS.n1904 VSS.n1903 7.80935
R5765 VSS.n1906 VSS.n1905 7.80935
R5766 VSS.n1908 VSS.n1907 7.80935
R5767 VSS.n1910 VSS.n1909 7.80935
R5768 VSS.n1917 VSS.n1697 7.80935
R5769 VSS.n1919 VSS.n1674 7.80935
R5770 VSS.n1921 VSS.n1698 7.80935
R5771 VSS.n1923 VSS.n1673 7.80935
R5772 VSS.n1925 VSS.n1699 7.80935
R5773 VSS.n1927 VSS.n1672 7.80935
R5774 VSS.n1929 VSS.n1700 7.80935
R5775 VSS.n1931 VSS.n1671 7.80935
R5776 VSS.n1838 VSS.n1665 7.80935
R5777 VSS.n907 VSS.n906 7.66334
R5778 VSS.n910 VSS.n751 7.66334
R5779 VSS.n911 VSS.n730 7.66334
R5780 VSS.n915 VSS.n753 7.66334
R5781 VSS.n992 VSS.t447 7.66334
R5782 VSS.n1016 VSS.n795 7.66334
R5783 VSS.n1020 VSS.n685 7.66334
R5784 VSS.n1022 VSS.n1021 7.66334
R5785 VSS.n1911 VSS.n1573 7.63618
R5786 VSS.n1913 VSS.n1573 7.63618
R5787 VSS.n1915 VSS.n1573 7.63618
R5788 VSS.n1888 VSS.n1573 7.63618
R5789 VSS.n1934 VSS.n1573 7.63618
R5790 VSS.n1936 VSS.n1573 7.63618
R5791 VSS.n1938 VSS.n1573 7.63618
R5792 VSS.n1940 VSS.n1573 7.63618
R5793 VSS.n1942 VSS.n1573 7.63618
R5794 VSS.n2193 VSS.n1573 7.63618
R5795 VSS.n2196 VSS.n1573 7.63618
R5796 VSS.n2199 VSS.n1573 7.63618
R5797 VSS.n2208 VSS.n1573 7.63618
R5798 VSS.n2213 VSS.n1573 7.63618
R5799 VSS.n1842 VSS.n1573 7.63618
R5800 VSS.n3090 VSS.n475 7.501
R5801 VSS.n3087 VSS.n476 7.501
R5802 VSS.t711 VSS.n3165 7.5005
R5803 VSS.t696 VSS.n3139 7.5005
R5804 VSS.t696 VSS.n587 7.5005
R5805 VSS.t696 VSS.n599 7.5005
R5806 VSS.n838 VSS.t507 7.5005
R5807 VSS.t507 VSS.n831 7.5005
R5808 VSS.t507 VSS.n837 7.5005
R5809 VSS.t484 VSS.n844 7.5005
R5810 VSS.t484 VSS.n846 7.5005
R5811 VSS.n2559 VSS.t484 7.5005
R5812 VSS.n1628 VSS.n1627 7.5005
R5813 VSS.n1628 VSS.n1625 7.5005
R5814 VSS.n1629 VSS.n1628 7.5005
R5815 VSS.n1862 VSS.n1860 7.5005
R5816 VSS.n1862 VSS.n1858 7.5005
R5817 VSS.n1862 VSS.n1861 7.5005
R5818 VSS.n1862 VSS.n1857 7.5005
R5819 VSS.n3595 VSS.t686 7.5005
R5820 VSS.t686 VSS.n108 7.5005
R5821 VSS.t686 VSS.n3594 7.5005
R5822 VSS.t477 VSS.n3632 7.5005
R5823 VSS.t477 VSS.n6 7.5005
R5824 VSS.t477 VSS.n7 7.5005
R5825 VSS.n2228 VSS.n1820 7.44679
R5826 VSS.n2228 VSS.n1805 7.44679
R5827 VSS.n2228 VSS.n1803 7.44679
R5828 VSS.n2228 VSS.n1801 7.44679
R5829 VSS.n2228 VSS.n1798 7.44679
R5830 VSS.n1955 VSS.t703 7.44301
R5831 VSS.n1304 VSS.n1082 7.21801
R5832 VSS.n1300 VSS.n1090 7.21734
R5833 VSS.n1541 VSS.n1540 7.14587
R5834 VSS.n1785 VSS.n1656 7.04738
R5835 VSS.n1795 VSS.n1712 7.04738
R5836 VSS.n1796 VSS.n1795 7.04738
R5837 VSS.n1786 VSS.n1785 7.04738
R5838 VSS.n3581 VSS.n156 7.015
R5839 VSS.n3306 VSS.n1 6.89936
R5840 VSS.n1827 VSS.n1573 6.77471
R5841 VSS.n1831 VSS.n1573 6.77471
R5842 VSS.n1819 VSS.n1573 6.77471
R5843 VSS.n1802 VSS.n1573 6.77471
R5844 VSS.n1844 VSS.n1573 6.77471
R5845 VSS.n1823 VSS.n1573 6.77471
R5846 VSS.n1821 VSS.n1573 6.77471
R5847 VSS.n1804 VSS.n1573 6.77471
R5848 VSS.n1800 VSS.n1573 6.77471
R5849 VSS.n1791 VSS.n1748 6.73991
R5850 VSS.n1809 VSS.n1792 6.73991
R5851 VSS.n1299 VSS.n1095 6.71048
R5852 VSS.n1308 VSS.n1091 6.71042
R5853 VSS.n2097 VSS.t37 6.6066
R5854 VSS.n1829 VSS.t240 6.4966
R5855 VSS.n2161 VSS.t210 6.4966
R5856 VSS.t224 VSS.n1648 6.25852
R5857 VSS.n1754 VSS.t226 6.25852
R5858 VSS.n3271 VSS.t179 6.06383
R5859 VSS.n3278 VSS.t171 6.06383
R5860 VSS.n3285 VSS.t181 6.06383
R5861 VSS.n3292 VSS.t173 6.06383
R5862 VSS.n3301 VSS.t175 6.06383
R5863 VSS.n3135 VSS.t284 6.06383
R5864 VSS.n646 VSS.t280 6.06383
R5865 VSS.n635 VSS.t286 6.06383
R5866 VSS.n626 VSS.t290 6.06383
R5867 VSS.n615 VSS.t282 6.06383
R5868 VSS.n2671 VSS.t273 6.06383
R5869 VSS.n2662 VSS.t267 6.06383
R5870 VSS.n2651 VSS.t263 6.06383
R5871 VSS.n2642 VSS.t271 6.06383
R5872 VSS.n2689 VSS.t265 6.06383
R5873 VSS.n3598 VSS.t16 6.06383
R5874 VSS.n95 VSS.t18 6.06383
R5875 VSS.n89 VSS.t12 6.06383
R5876 VSS.n76 VSS.t10 6.06383
R5877 VSS.n73 VSS.t14 6.06383
R5878 VSS.n1958 VSS.t297 6.02741
R5879 VSS.n2893 VSS.n2887 5.82119
R5880 VSS.n2893 VSS.n2890 5.82106
R5881 VSS.n1845 VSS.n1665 5.77714
R5882 VSS.n1964 VSS.t668 5.72083
R5883 VSS.n2185 VSS.t600 5.72083
R5884 VSS.n2175 VSS.t760 5.72083
R5885 VSS.n2190 VSS.t581 5.72083
R5886 VSS.n2190 VSS.t656 5.72083
R5887 VSS.n2190 VSS.t503 5.72083
R5888 VSS.n3030 VSS.n3011 5.67303
R5889 VSS.n3522 VSS.n190 5.66974
R5890 VSS.n1815 VSS.n1806 5.66904
R5891 VSS.n1324 VSS.n1074 5.66778
R5892 VSS.n2491 VSS.n1348 5.66778
R5893 VSS.n2448 VSS.n2447 5.66778
R5894 VSS.n1509 VSS.n1499 5.66778
R5895 VSS.n2335 VSS.n1502 5.66778
R5896 VSS.n2031 VSS.n1976 5.66778
R5897 VSS.n2220 VSS.n1841 5.66778
R5898 VSS.n1849 VSS.n1846 5.66778
R5899 VSS.n2010 VSS.n1988 5.66778
R5900 VSS.n2145 VSS.n1979 5.66778
R5901 VSS.n2145 VSS.n2018 5.66778
R5902 VSS.n2066 VSS.n2065 5.66778
R5903 VSS.n3051 VSS.n406 5.66778
R5904 VSS.n3075 VSS.n3074 5.66778
R5905 VSS.n3075 VSS.n2724 5.66778
R5906 VSS.n2326 VSS.n2325 5.66778
R5907 VSS.n2472 VSS.n2471 5.66778
R5908 VSS.n1538 VSS.n1518 5.66778
R5909 VSS.n2304 VSS.n1567 5.66778
R5910 VSS.n3413 VSS.n3412 5.66778
R5911 VSS.n2903 VSS.n2902 5.66778
R5912 VSS.n2928 VSS.n309 5.66778
R5913 VSS.n3031 VSS.n2974 5.66778
R5914 VSS.n3442 VSS.n297 5.66778
R5915 VSS.n3575 VSS.n3574 5.66778
R5916 VSS.n3613 VSS.n3612 5.66778
R5917 VSS.n1052 VSS.n1001 5.66767
R5918 VSS.n1415 VSS.n1289 5.66767
R5919 VSS.n2496 VSS.n1322 5.66767
R5920 VSS.n2512 VSS.n2511 5.66767
R5921 VSS.n1348 VSS.n1141 5.66767
R5922 VSS.n2434 VSS.n1145 5.66767
R5923 VSS.n1510 VSS.n1509 5.66767
R5924 VSS.n1548 VSS.n1502 5.66767
R5925 VSS.n2220 VSS.n2219 5.66767
R5926 VSS.n1809 VSS.n1747 5.66767
R5927 VSS.n1806 VSS.n1799 5.66767
R5928 VSS.n1988 VSS.n1987 5.66767
R5929 VSS.n2069 VSS.n2068 5.66767
R5930 VSS.n927 VSS.n926 5.66767
R5931 VSS.n2576 VSS.n672 5.66767
R5932 VSS.n3159 VSS.n3158 5.66767
R5933 VSS.n891 VSS.n890 5.66767
R5934 VSS.n2304 VSS.n2303 5.66767
R5935 VSS.n3353 VSS.n3352 5.66767
R5936 VSS.n2580 VSS.n669 5.66767
R5937 VSS.n3096 VSS.n2688 5.66767
R5938 VSS.n2338 VSS.n2337 5.66767
R5939 VSS.n2494 VSS.n2493 5.66767
R5940 VSS.n2902 VSS.n2901 5.66767
R5941 VSS.n2928 VSS.n2927 5.66767
R5942 VSS.n2974 VSS.n2970 5.66767
R5943 VSS.n3180 VSS.n3179 5.66767
R5944 VSS.n3574 VSS.n238 5.66767
R5945 VSS.n3469 VSS.n3468 5.66767
R5946 VSS.n3480 VSS.n3479 5.66767
R5947 VSS.n3403 VSS.n3402 5.66767
R5948 VSS.n1734 VSS.n1573 5.66731
R5949 VSS.t483 VSS.n3027 5.66717
R5950 VSS.t483 VSS.n3026 5.66717
R5951 VSS.t483 VSS.n3017 5.66717
R5952 VSS.t483 VSS.n3016 5.66717
R5953 VSS.t483 VSS.n3015 5.66717
R5954 VSS.t483 VSS.n3014 5.66717
R5955 VSS.n3028 VSS.t483 5.66717
R5956 VSS.n2210 VSS.t502 5.66717
R5957 VSS.n2210 VSS.t580 5.66717
R5958 VSS.n2210 VSS.t655 5.66717
R5959 VSS.n1059 VSS.n991 5.66717
R5960 VSS.n2573 VSS.n742 5.66717
R5961 VSS.n2574 VSS.n2573 5.66717
R5962 VSS.n1038 VSS.n1037 5.66717
R5963 VSS.n2579 VSS.n2578 5.66717
R5964 VSS.n1044 VSS.n1043 5.66717
R5965 VSS.n1040 VSS.n1039 5.66717
R5966 VSS.n1066 VSS.n1065 5.66717
R5967 VSS.n1062 VSS.n1061 5.66717
R5968 VSS.n1072 VSS.n1071 5.66717
R5969 VSS.n1068 VSS.n1067 5.66717
R5970 VSS.n3246 VSS.n3245 5.66717
R5971 VSS.n3355 VSS.n3354 5.66717
R5972 VSS.n3380 VSS.n3379 5.66717
R5973 VSS.n3244 VSS.n3207 5.66717
R5974 VSS.n3124 VSS.n3123 5.66717
R5975 VSS.n3095 VSS.n2618 5.66717
R5976 VSS.n2608 VSS.n2607 5.66717
R5977 VSS.n3126 VSS.n3125 5.66717
R5978 VSS.n2327 VSS.n1547 5.66717
R5979 VSS.n2473 VSS.n853 5.66717
R5980 VSS.n1433 VSS.n1419 5.66717
R5981 VSS.n201 VSS.t725 5.66717
R5982 VSS.t549 VSS.n3519 5.66717
R5983 VSS.t549 VSS.n3518 5.66717
R5984 VSS.t549 VSS.n3509 5.66717
R5985 VSS.t549 VSS.n3508 5.66717
R5986 VSS.t549 VSS.n3507 5.66717
R5987 VSS.n3520 VSS.t549 5.66717
R5988 VSS.n3567 VSS.t570 5.66717
R5989 VSS.t570 VSS.n3553 5.66717
R5990 VSS.t570 VSS.n3545 5.66717
R5991 VSS.t570 VSS.n3544 5.66717
R5992 VSS.t570 VSS.n3543 5.66717
R5993 VSS.t570 VSS.n3542 5.66717
R5994 VSS.t570 VSS.n3566 5.66717
R5995 VSS.n2451 VSS.n1351 5.66674
R5996 VSS.n3030 VSS.n2971 5.66503
R5997 VSS.n239 VSS.n190 5.66503
R5998 VSS.n2513 VSS.n1125 5.66257
R5999 VSS.n2513 VSS.n1088 5.66257
R6000 VSS.n2514 VSS.n2513 5.66257
R6001 VSS.n2573 VSS.n816 5.66089
R6002 VSS.n2116 VSS.n2072 5.65656
R6003 VSS.n2120 VSS.n2072 5.65656
R6004 VSS.n2109 VSS.n2072 5.65656
R6005 VSS.n2105 VSS.n2072 5.65656
R6006 VSS.n3416 VSS.n3415 5.65656
R6007 VSS.n2900 VSS.n2899 5.65656
R6008 VSS.n3435 VSS.n321 5.65656
R6009 VSS.n3435 VSS.n311 5.65656
R6010 VSS.n2926 VSS.n2874 5.65656
R6011 VSS.n3440 VSS.n304 5.65262
R6012 VSS.n3421 VSS.n403 5.65262
R6013 VSS.n1042 VSS.n1040 5.6487
R6014 VSS.n1 VSS.n0 5.64171
R6015 VSS.n1036 VSS.n1034 5.62487
R6016 VSS.n1064 VSS.n1062 5.62487
R6017 VSS.n3601 VSS.n63 5.62487
R6018 VSS.n3355 VSS.n3211 5.62487
R6019 VSS.n3378 VSS.n3207 5.62487
R6020 VSS.n3122 VSS.n2618 5.62487
R6021 VSS.n3126 VSS.n2586 5.62487
R6022 VSS.n1277 VSS.n1187 5.62111
R6023 VSS.n1276 VSS.n1190 5.62111
R6024 VSS.n1275 VSS.n1194 5.62111
R6025 VSS.n1274 VSS.n1196 5.62111
R6026 VSS.n1273 VSS.n1199 5.62111
R6027 VSS.n1272 VSS.n1202 5.62111
R6028 VSS.n1271 VSS.n1205 5.62111
R6029 VSS.n1270 VSS.n1208 5.62111
R6030 VSS.n1269 VSS.n1211 5.62111
R6031 VSS.n1268 VSS.n1214 5.62111
R6032 VSS.n1267 VSS.n1218 5.62111
R6033 VSS.n1266 VSS.n1221 5.62111
R6034 VSS.n1265 VSS.n1224 5.62111
R6035 VSS.n1264 VSS.n1227 5.62111
R6036 VSS.n1263 VSS.n1231 5.62111
R6037 VSS.n1262 VSS.n1234 5.62111
R6038 VSS.n1261 VSS.n1237 5.62111
R6039 VSS.n1260 VSS.n1238 5.62111
R6040 VSS.n2496 VSS.n2495 5.62111
R6041 VSS.t399 VSS.n1129 5.62111
R6042 VSS.t1058 VSS.n1082 5.62111
R6043 VSS.n2096 VSS.n2078 5.62061
R6044 VSS.n1056 VSS.n996 5.61281
R6045 VSS.n3161 VSS.n559 5.61281
R6046 VSS.n3348 VSS.n3347 5.61281
R6047 VSS.n2583 VSS.n2582 5.61281
R6048 VSS.n3099 VSS.n3098 5.61281
R6049 VSS.n3041 VSS.n2832 5.61281
R6050 VSS.n3572 VSS.n245 5.61281
R6051 VSS.n2552 VSS.n829 5.61281
R6052 VSS.n2232 VSS.n1756 5.61281
R6053 VSS.n2569 VSS.n829 5.61281
R6054 VSS.n2571 VSS.n829 5.61281
R6055 VSS.n1046 VSS.n1045 5.6036
R6056 VSS.n1723 VSS.n1648 5.59624
R6057 VSS.n1726 VSS.n1646 5.59624
R6058 VSS.n1731 VSS.n1644 5.59624
R6059 VSS.n1736 VSS.n1642 5.59624
R6060 VSS.n1724 VSS.n1723 5.59566
R6061 VSS.n1727 VSS.n1726 5.59566
R6062 VSS.n1732 VSS.n1731 5.59566
R6063 VSS.n1737 VSS.n1736 5.59566
R6064 VSS.n1803 VSS.n1802 5.5625
R6065 VSS.n1820 VSS.n1819 5.5625
R6066 VSS.n1805 VSS.n1804 5.5625
R6067 VSS.n1801 VSS.n1800 5.5625
R6068 VSS.t299 VSS.n1954 5.56245
R6069 VSS.n1956 VSS.t299 5.56245
R6070 VSS.n2228 VSS.n1828 5.52759
R6071 VSS.n2228 VSS.n1824 5.52759
R6072 VSS.n2228 VSS.n1832 5.52759
R6073 VSS.n2228 VSS.n1822 5.52759
R6074 VSS.n2034 VSS.n1577 5.51798
R6075 VSS.n2893 VSS.n2888 5.39272
R6076 VSS.n2893 VSS.n2889 5.39258
R6077 VSS.n2065 VSS.n2064 5.06063
R6078 VSS.n1691 VSS.t899 5.04532
R6079 VSS.t477 VSS.n5 5.0015
R6080 VSS.n3641 VSS.t477 5.0015
R6081 VSS.t686 VSS.n114 5.0015
R6082 VSS.t686 VSS.n115 5.0015
R6083 VSS.t686 VSS.n3592 5.0015
R6084 VSS.t484 VSS.n842 5.0015
R6085 VSS.t484 VSS.n845 5.0015
R6086 VSS.t507 VSS.n833 5.0015
R6087 VSS.t507 VSS.n834 5.0015
R6088 VSS.t507 VSS.n832 5.0015
R6089 VSS.t696 VSS.n588 5.0015
R6090 VSS.t696 VSS.n584 5.0015
R6091 VSS.n2713 VSS.n475 5.001
R6092 VSS.n3085 VSS.n476 5.001
R6093 VSS.n3166 VSS.t711 5.0005
R6094 VSS.n3140 VSS.t696 5.0005
R6095 VSS.t484 VSS.n2558 5.0005
R6096 VSS.t598 VSS.n1967 5.0005
R6097 VSS.t598 VSS.n2179 5.0005
R6098 VSS.t598 VSS.n1950 5.0005
R6099 VSS.n2180 VSS.t598 5.0005
R6100 VSS.t477 VSS.n3640 5.0005
R6101 VSS.n1795 VSS.n1573 4.97781
R6102 VSS.n1785 VSS.n1573 4.97781
R6103 VSS.n1806 VSS.n1794 4.81436
R6104 VSS.n2233 VSS.n1741 4.77909
R6105 VSS.n2390 VSS.n2389 4.76234
R6106 VSS.n1071 VSS.n1070 4.65896
R6107 VSS.n1037 VSS.n1036 4.61451
R6108 VSS.n1065 VSS.n1064 4.61451
R6109 VSS.n3245 VSS.n3211 4.61451
R6110 VSS.n3379 VSS.n3378 4.61451
R6111 VSS.n3123 VSS.n3122 4.61451
R6112 VSS.n2607 VSS.n2586 4.61451
R6113 VSS.n1917 VSS.n1573 4.59682
R6114 VSS.n1919 VSS.n1573 4.59682
R6115 VSS.n1921 VSS.n1573 4.59682
R6116 VSS.n1923 VSS.n1573 4.59682
R6117 VSS.n1925 VSS.n1573 4.59682
R6118 VSS.n1927 VSS.n1573 4.59682
R6119 VSS.n1929 VSS.n1573 4.59682
R6120 VSS.n1931 VSS.n1573 4.59682
R6121 VSS.n1641 VSS.n1573 4.59682
R6122 VSS.n1891 VSS.n1573 4.59682
R6123 VSS.n1893 VSS.n1573 4.59682
R6124 VSS.n1895 VSS.n1573 4.59682
R6125 VSS.n1897 VSS.n1573 4.59682
R6126 VSS.n1899 VSS.n1573 4.59682
R6127 VSS.n1901 VSS.n1573 4.59682
R6128 VSS.n1903 VSS.n1573 4.59682
R6129 VSS.n1905 VSS.n1573 4.59682
R6130 VSS.n1907 VSS.n1573 4.59682
R6131 VSS.n1909 VSS.n1573 4.59682
R6132 VSS.n1838 VSS.n1573 4.59682
R6133 VSS.n1415 VSS.n1147 4.58115
R6134 VSS.n1043 VSS.n1042 4.56607
R6135 VSS.n2125 VSS.n2124 4.41924
R6136 VSS.n674 VSS.n673 4.41773
R6137 VSS.n433 VSS.n432 4.40858
R6138 VSS.n3500 VSS.n3499 4.40858
R6139 VSS.n1786 VSS.t227 4.33298
R6140 VSS.n2228 VSS.n1769 4.33161
R6141 VSS.n3137 VSS.n583 4.25611
R6142 VSS.n3092 VSS.n583 4.25611
R6143 VSS.n3597 VSS.n1 4.25611
R6144 VSS.n3299 VSS.n1 4.25611
R6145 VSS.n3057 VSS.n2754 4.25415
R6146 VSS.n1816 VSS.n1815 4.25119
R6147 VSS.n3346 VSS.n3345 4.25113
R6148 VSS.n604 VSS.n603 4.25113
R6149 VSS.n2627 VSS.n2626 4.25113
R6150 VSS.n3184 VSS.n3183 4.25113
R6151 VSS.n2881 VSS.n316 4.251
R6152 VSS.n2506 VSS.n2505 4.251
R6153 VSS.n2031 VSS.n1973 4.251
R6154 VSS.n2234 VSS.n2233 4.251
R6155 VSS.n1025 VSS.n1024 4.251
R6156 VSS.n1008 VSS.n1007 4.251
R6157 VSS.n908 VSS.n907 4.251
R6158 VSS.n894 VSS.n893 4.251
R6159 VSS.n3197 VSS.n64 4.251
R6160 VSS.n3223 VSS.n3222 4.251
R6161 VSS.n3200 VSS.n3195 4.251
R6162 VSS.n3307 VSS.n3251 4.251
R6163 VSS.n2611 VSS.n2610 4.251
R6164 VSS.n2590 VSS.n2589 4.251
R6165 VSS.n2776 VSS.n407 4.251
R6166 VSS.n2438 VSS.n2437 4.251
R6167 VSS.n3404 VSS.n33 4.251
R6168 VSS.n305 VSS.n288 4.251
R6169 VSS.n3604 VSS.n44 4.251
R6170 VSS.n1729 VSS.n1573 4.25078
R6171 VSS.n2246 VSS.n1602 4.25072
R6172 VSS.n2246 VSS.n1607 4.25072
R6173 VSS.n2407 VSS.n1547 4.2505
R6174 VSS.n2228 VSS.n1836 4.2505
R6175 VSS.n2578 VSS.n671 4.2505
R6176 VSS.n1040 VSS.n1022 4.2505
R6177 VSS.n1062 VSS.n921 4.2505
R6178 VSS.n1068 VSS.n904 4.2505
R6179 VSS.n3355 VSS.n3240 4.2505
R6180 VSS.n3219 VSS.n3207 4.2505
R6181 VSS.n3133 VSS.n605 4.2505
R6182 VSS.n2618 VSS.n2617 4.2505
R6183 VSS.n3126 VSS.n2604 4.2505
R6184 VSS.n3102 VSS.n2628 4.2505
R6185 VSS.n2336 VSS.n1547 4.2505
R6186 VSS.n2492 VSS.n853 4.2505
R6187 VSS.n2451 VSS.n1349 4.2505
R6188 VSS.n2436 VSS.n1419 4.2505
R6189 VSS.n3601 VSS.n3600 4.2505
R6190 VSS.n2215 VSS.n1573 4.25009
R6191 VSS.n2279 VSS.n1557 4.24982
R6192 VSS.n2270 VSS.n1557 4.24982
R6193 VSS.n2264 VSS.n1557 4.24982
R6194 VSS.n2261 VSS.n1557 4.24982
R6195 VSS.n2513 VSS.n1136 4.24588
R6196 VSS.n2170 VSS.n1573 4.24446
R6197 VSS.n2513 VSS.n1111 4.24368
R6198 VSS.n2513 VSS.n1099 4.24368
R6199 VSS.n2513 VSS.n1103 4.24196
R6200 VSS.n2157 VSS.n1970 4.24093
R6201 VSS.n3038 VSS.n2929 4.2393
R6202 VSS.n3057 VSS.n2750 4.23525
R6203 VSS.n2451 VSS.n1400 4.23292
R6204 VSS.n2451 VSS.n1367 4.2328
R6205 VSS.n2573 VSS.n799 4.22414
R6206 VSS.n1881 VSS.n1847 4.20389
R6207 VSS.n2067 VSS.n1571 4.19704
R6208 VSS.n2228 VSS.n1825 4.17818
R6209 VSS.n3191 VSS.n106 4.17435
R6210 VSS.n2550 VSS.n829 4.17429
R6211 VSS.n3161 VSS.n555 4.17416
R6212 VSS.t1069 VSS.n1486 4.17296
R6213 VSS.t1071 VSS.n1450 4.17296
R6214 VSS.n3578 VSS.n195 4.16794
R6215 VSS.n2197 VSS.t900 3.85159
R6216 VSS.n1932 VSS.n1700 3.85159
R6217 VSS.n1930 VSS.n1672 3.85159
R6218 VSS.n1928 VSS.n1699 3.85159
R6219 VSS.n1924 VSS.n1698 3.85159
R6220 VSS.n1922 VSS.n1674 3.85159
R6221 VSS.n1920 VSS.n1697 3.85159
R6222 VSS.n1918 VSS.n1675 3.85159
R6223 VSS.n1908 VSS.n1689 3.85159
R6224 VSS.n1906 VSS.n1678 3.85159
R6225 VSS.n1904 VSS.n1688 3.85159
R6226 VSS.n1900 VSS.n1687 3.85159
R6227 VSS.n1898 VSS.n1680 3.85159
R6228 VSS.n1896 VSS.n1686 3.85159
R6229 VSS.n1894 VSS.n1681 3.85159
R6230 VSS.n1892 VSS.n1685 3.85159
R6231 VSS.n1890 VSS.n1682 3.85159
R6232 VSS.n1889 VSS.t898 3.85159
R6233 VSS.n1885 VSS.n1683 3.85159
R6234 VSS.t120 VSS.n720 3.83192
R6235 VSS.n970 VSS.t118 3.83192
R6236 VSS.n951 VSS.t104 3.83192
R6237 VSS.n2589 VSS.n525 3.83192
R6238 VSS.n2588 VSS.n524 3.83192
R6239 VSS.n2591 VSS.n523 3.83192
R6240 VSS.n2614 VSS.n513 3.83192
R6241 VSS.n2615 VSS.n512 3.83192
R6242 VSS.n2616 VSS.n511 3.83192
R6243 VSS.n2617 VSS.n510 3.83192
R6244 VSS.n3202 VSS.n3201 3.83192
R6245 VSS.n3204 VSS.n3203 3.83192
R6246 VSS.n3206 VSS.n3205 3.83192
R6247 VSS.n3237 VSS.n3231 3.83192
R6248 VSS.n3239 VSS.n3238 3.83192
R6249 VSS.t517 VSS.n1627 3.7505
R6250 VSS.t517 VSS.n1625 3.7505
R6251 VSS.t517 VSS.n1629 3.7505
R6252 VSS.n1860 VSS.t550 3.7505
R6253 VSS.n1858 VSS.t550 3.7505
R6254 VSS.n1861 VSS.t550 3.7505
R6255 VSS.n1857 VSS.t550 3.7505
R6256 VSS.t500 VSS.n2204 3.7505
R6257 VSS.t500 VSS.n2202 3.7505
R6258 VSS.n2205 VSS.t500 3.7505
R6259 VSS.n3044 VSS.t492 3.7505
R6260 VSS.t521 VSS.n3488 3.7505
R6261 VSS.n1620 VSS.t218 3.66506
R6262 VSS.n1851 VSS.t234 3.66506
R6263 VSS.n1803 VSS.t232 3.55357
R6264 VSS.n3370 VSS.t25 3.51314
R6265 VSS.n3233 VSS.t1031 3.51314
R6266 VSS.n2593 VSS.t1026 3.51314
R6267 VSS.n3115 VSS.t278 3.51314
R6268 VSS.n897 VSS.t90 3.51314
R6269 VSS.n913 VSS.t164 3.51314
R6270 VSS.n1017 VSS.t914 3.51314
R6271 VSS.n1800 VSS.n1711 3.45358
R6272 VSS.n1804 VSS.n1710 3.45358
R6273 VSS.n1821 VSS.n1709 3.45358
R6274 VSS.n1823 VSS.n1708 3.45358
R6275 VSS.n1844 VSS.n1707 3.45358
R6276 VSS.n1846 VSS.n1844 3.45358
R6277 VSS.n1827 VSS.n1664 3.45358
R6278 VSS.n1831 VSS.n1663 3.45358
R6279 VSS.n1819 VSS.n1662 3.45358
R6280 VSS.n1802 VSS.n1661 3.45358
R6281 VSS.n1581 VSS.t217 3.44768
R6282 VSS.n1592 VSS.t214 3.44768
R6283 VSS.n1636 VSS.t213 3.44768
R6284 VSS.n1620 VSS.t216 3.44768
R6285 VSS.n1851 VSS.t229 3.44768
R6286 VSS.n1866 VSS.t228 3.44768
R6287 VSS.n1870 VSS.t233 3.44768
R6288 VSS.n1872 VSS.t236 3.44768
R6289 VSS.n2281 VSS 3.40283
R6290 VSS.n306 VSS.n303 3.401
R6291 VSS.n2221 VSS.n2220 3.40096
R6292 VSS.n2155 VSS.n1970 3.40077
R6293 VSS.n2265 VSS.t727 3.4005
R6294 VSS.n2260 VSS.t728 3.4005
R6295 VSS.n2265 VSS.t533 3.4005
R6296 VSS.n2260 VSS.t534 3.4005
R6297 VSS.n2269 VSS.t207 3.4005
R6298 VSS.n2271 VSS.t439 3.4005
R6299 VSS.n2269 VSS.t208 3.4005
R6300 VSS.n2271 VSS.t437 3.4005
R6301 VSS.n2278 VSS.t435 3.4005
R6302 VSS.n2280 VSS.t404 3.4005
R6303 VSS.n2278 VSS.t438 3.4005
R6304 VSS.n2280 VSS.t403 3.4005
R6305 VSS.n2284 VSS.t824 3.4005
R6306 VSS.n2292 VSS.t823 3.4005
R6307 VSS.n2284 VSS.t626 3.4005
R6308 VSS.n2292 VSS.t625 3.4005
R6309 VSS.n1881 VSS.n1836 3.4005
R6310 VSS.n2247 VSS.n1570 3.4005
R6311 VSS.n2407 VSS.n1432 3.4005
R6312 VSS.n2228 VSS.n1793 3.39556
R6313 VSS.n3133 VSS.n600 3.38771
R6314 VSS.n2228 VSS.n1830 3.38592
R6315 VSS.n2162 VSS.n1970 3.38382
R6316 VSS.n2114 VSS.n2072 3.38096
R6317 VSS.n2118 VSS.n2072 3.38096
R6318 VSS.n2107 VSS.n2072 3.38078
R6319 VSS.n2103 VSS.n2072 3.38078
R6320 VSS.t235 VSS.n1709 3.3702
R6321 VSS.n2573 VSS.n732 3.36673
R6322 VSS.n1070 VSS.n1068 3.36074
R6323 VSS.n2169 VSS.n1970 3.32773
R6324 VSS.n2092 VSS.n2086 3.31734
R6325 VSS.n2093 VSS.n2092 3.31734
R6326 VSS.n1059 VSS.n1058 3.30238
R6327 VSS.n2578 VSS.n2577 3.10274
R6328 VSS.n2124 VSS.n2123 3.06105
R6329 VSS.t203 VSS.n1671 2.88882
R6330 VSS.n1926 VSS.t201 2.88882
R6331 VSS.n1910 VSS.t204 2.88882
R6332 VSS.t202 VSS.n1679 2.88882
R6333 VSS.n2363 VSS.t136 2.85445
R6334 VSS.n673 VSS.t1024 2.83912
R6335 VSS.n1845 VSS.n1826 2.83461
R6336 VSS.n2220 VSS.n1840 2.83428
R6337 VSS.n1882 VSS.n1846 2.83428
R6338 VSS.n2504 VSS.n1146 2.83406
R6339 VSS.n2991 VSS.t559 2.83383
R6340 VSS.n2285 VSS.n1557 2.83174
R6341 VSS.n3038 VSS.n2931 2.82504
R6342 VSS.n2513 VSS.n1119 2.8228
R6343 VSS.n2513 VSS.n1094 2.8228
R6344 VSS.n1332 VSS.t887 2.8108
R6345 VSS.t923 VSS.n1095 2.8108
R6346 VSS.n3435 VSS.n319 2.80745
R6347 VSS.n3303 VSS.n3259 2.79881
R6348 VSS.n1691 VSS.t1016 2.73311
R6349 VSS.n1693 VSS.t901 2.73311
R6350 VSS.n1692 VSS.t1014 2.73306
R6351 VSS.n3062 VSS.n3061 2.71714
R6352 VSS.n3161 VSS.n484 2.71665
R6353 VSS.n3562 VSS.n3561 2.63078
R6354 VSS.n2985 VSS.n2984 2.62986
R6355 VSS.n1040 VSS.n1023 2.62493
R6356 VSS.n1068 VSS.n905 2.62493
R6357 VSS.n3355 VSS.n3242 2.62493
R6358 VSS.n3364 VSS.n3207 2.62493
R6359 VSS.n3108 VSS.n2618 2.62493
R6360 VSS.n3126 VSS.n2606 2.62493
R6361 VSS.t554 VSS.n2831 2.61602
R6362 VSS.t493 VSS.n2803 2.61602
R6363 VSS.n246 VSS.t544 2.61602
R6364 VSS.t511 VSS.n178 2.61602
R6365 VSS.n1062 VSS.n922 2.55535
R6366 VSS.n1377 VSS 2.52317
R6367 VSS.n1624 VSS.n1623 2.501
R6368 VSS.n1864 VSS.n1863 2.501
R6369 VSS.n1634 VSS.t517 2.5005
R6370 VSS.t517 VSS.n1630 2.5005
R6371 VSS.t517 VSS.n1622 2.5005
R6372 VSS.t517 VSS.n1631 2.5005
R6373 VSS.t517 VSS.n1621 2.5005
R6374 VSS.t517 VSS.n1633 2.5005
R6375 VSS.t550 VSS.n1854 2.5005
R6376 VSS.t550 VSS.n1853 2.5005
R6377 VSS.t550 VSS.n1855 2.5005
R6378 VSS.t550 VSS.n1852 2.5005
R6379 VSS.t550 VSS.n1856 2.5005
R6380 VSS.n2228 VSS.n1741 2.48256
R6381 VSS.n2092 VSS.n2087 2.46346
R6382 VSS.n1398 VSS.n1397 2.44571
R6383 VSS.n1393 VSS.n1388 2.44388
R6384 VSS.n2084 VSS.n2083 2.43228
R6385 VSS.n2090 VSS.n2080 2.43075
R6386 VSS.n2126 VSS.n2125 2.42993
R6387 VSS.n3618 VSS.n3617 2.42988
R6388 VSS.n3069 VSS.n583 2.42907
R6389 VSS VSS.n3059 2.41867
R6390 VSS.n2513 VSS.n1134 2.41597
R6391 VSS.n2513 VSS.n1085 2.41597
R6392 VSS.t227 VSS.n1749 2.40743
R6393 VSS.n3435 VSS.n323 2.40068
R6394 VSS.n3435 VSS.n313 2.40065
R6395 VSS.n1692 VSS.n1691 2.3611
R6396 VSS.n2094 VSS.n2080 2.35273
R6397 VSS.n3437 VSS.n3435 2.35198
R6398 VSS.n3435 VSS.n347 2.35198
R6399 VSS.n3435 VSS.n352 2.35198
R6400 VSS.n3435 VSS.n356 2.35198
R6401 VSS.n3435 VSS.n360 2.35198
R6402 VSS.n3435 VSS.n373 2.35198
R6403 VSS.n3435 VSS.n382 2.35198
R6404 VSS.n3435 VSS.n391 2.35198
R6405 VSS.n2872 VSS.n308 2.35198
R6406 VSS.n390 VSS.n308 2.35198
R6407 VSS.n385 VSS.n308 2.35198
R6408 VSS.n381 VSS.n308 2.35198
R6409 VSS.n376 VSS.n308 2.35198
R6410 VSS.n372 VSS.n308 2.35198
R6411 VSS.n367 VSS.n308 2.35198
R6412 VSS.n359 VSS.n308 2.35198
R6413 VSS.n351 VSS.n308 2.35198
R6414 VSS.n3436 VSS.n308 2.35198
R6415 VSS.n2085 VSS.n2084 2.34919
R6416 VSS.n2095 VSS.n2079 2.34462
R6417 VSS.n1945 VSS.n1573 2.34431
R6418 VSS.n1948 VSS.n1573 2.34431
R6419 VSS.n2252 VSS.n1557 2.33345
R6420 VSS.n2273 VSS.n1557 2.33345
R6421 VSS.n1693 VSS.n1692 2.3039
R6422 VSS.n2498 VSS.n1328 2.29946
R6423 VSS.n2232 VSS.n1746 2.29884
R6424 VSS.n3041 VSS.n2825 2.29353
R6425 VSS.n3106 VSS.n583 2.29333
R6426 VSS.n3572 VSS.n3570 2.29333
R6427 VSS.n2451 VSS.n1369 2.29289
R6428 VSS.n2451 VSS.n1373 2.29289
R6429 VSS.n3581 VSS.n187 2.29288
R6430 VSS.n3622 VSS.n1 2.29267
R6431 VSS.n3262 VSS.n1 2.29267
R6432 VSS.n2529 VSS.n2520 2.26577
R6433 VSS.n2533 VSS.n2532 2.26577
R6434 VSS.n2528 VSS.n2527 2.2505
R6435 VSS.n2519 VSS.n2518 2.2505
R6436 VSS.n2521 VSS.n2520 2.2505
R6437 VSS.n2527 VSS.n2526 2.2505
R6438 VSS.n2518 VSS.n2517 2.2505
R6439 VSS.n2534 VSS.n2533 2.2505
R6440 VSS.n2523 VSS.n2521 2.2505
R6441 VSS.n2526 VSS.n2525 2.2505
R6442 VSS.n2517 VSS.n2516 2.2505
R6443 VSS.n2535 VSS.n2534 2.2505
R6444 VSS.n1278 VSS.n1142 2.23179
R6445 VSS.n1176 VSS.n1142 2.23179
R6446 VSS.n1171 VSS.n1142 2.23179
R6447 VSS.n2501 VSS.n1288 2.23179
R6448 VSS.n2501 VSS.n1286 2.23179
R6449 VSS.n2501 VSS.n1285 2.23179
R6450 VSS.n2502 VSS.n2501 2.23179
R6451 VSS.n2501 VSS.n1284 2.23179
R6452 VSS.n2501 VSS.n1283 2.23179
R6453 VSS.n2501 VSS.n1282 2.23179
R6454 VSS.n2501 VSS.n1281 2.23179
R6455 VSS.n2501 VSS.n1280 2.23179
R6456 VSS.n2513 VSS.n1100 2.23179
R6457 VSS.n2513 VSS.n1097 2.23179
R6458 VSS.n2513 VSS.n1096 2.23179
R6459 VSS.n2513 VSS.n1089 2.23179
R6460 VSS.n2513 VSS.n1086 2.23179
R6461 VSS.n2513 VSS.n1084 2.23179
R6462 VSS.n2513 VSS.n1083 2.23179
R6463 VSS.n2513 VSS.n1081 2.23179
R6464 VSS.n2513 VSS.n1080 2.23179
R6465 VSS.n1239 VSS.n1142 2.23179
R6466 VSS.n1245 VSS.n1142 2.23179
R6467 VSS.n1250 VSS.n1142 2.23179
R6468 VSS.n1255 VSS.n1142 2.23179
R6469 VSS.n1156 VSS.n1142 2.23179
R6470 VSS.n1150 VSS.n1142 2.23179
R6471 VSS.n1379 VSS.n1378 2.22571
R6472 VSS.n1392 VSS.n1391 2.22571
R6473 VSS.n3059 VSS.n21 2.20233
R6474 VSS.n2531 VSS.n2530 2.2005
R6475 VSS.n1363 VSS.n1362 2.1952
R6476 VSS.n3155 VSS.n3154 2.16572
R6477 VSS.n882 VSS.n740 2.16254
R6478 VSS.n2992 VSS.t557 2.14336
R6479 VSS.n2089 VSS.n2079 2.12648
R6480 VSS.n2993 VSS.n2933 2.126
R6481 VSS.n3435 VSS.n317 2.1255
R6482 VSS.n3039 VSS.n3038 2.1255
R6483 VSS.n3644 VSS.n1 2.11756
R6484 VSS.n1869 VSS.n1573 2.10985
R6485 VSS.n1798 VSS.n1797 2.10941
R6486 VSS.n3351 VSS.n3250 2.10234
R6487 VSS.n1637 VSS 2.08317
R6488 VSS.n1258 VSS.n1138 2.0192
R6489 VSS.n1325 VSS.n1324 2.01917
R6490 VSS.n2251 VSS.n1557 2.0166
R6491 VSS.n2253 VSS.n1557 2.0166
R6492 VSS.n2098 VSS.n2078 1.99921
R6493 VSS.n3130 VSS.n583 1.97486
R6494 VSS.n3210 VSS.n1 1.97486
R6495 VSS.n2282 VSS.n1557 1.97072
R6496 VSS.n2267 VSS.n1557 1.97072
R6497 VSS.n1755 VSS.n1724 1.92605
R6498 VSS.n1754 VSS.n1650 1.92605
R6499 VSS.n1753 VSS.n1721 1.92605
R6500 VSS.n1752 VSS.n1652 1.92605
R6501 VSS.n1751 VSS.n1719 1.92605
R6502 VSS.n1750 VSS.n1654 1.92605
R6503 VSS.n1749 VSS.n1717 1.92605
R6504 VSS.n1748 VSS.n1656 1.92605
R6505 VSS.n1809 VSS.n1715 1.92605
R6506 VSS.n3050 VSS.n3049 1.89023
R6507 VSS.n2233 VSS.n2232 1.88939
R6508 VSS.n1694 VSS.n1693 1.87059
R6509 VSS.n2274 VSS 1.86794
R6510 VSS.n663 VSS.n541 1.85297
R6511 VSS.n1873 VSS.n1573 1.85055
R6512 VSS.n1058 VSS.n1057 1.84801
R6513 VSS.n2407 VSS.n1545 1.82137
R6514 VSS.n1959 VSS.n1958 1.77023
R6515 VSS.n3161 VSS.n518 1.76032
R6516 VSS.n3161 VSS.n526 1.76032
R6517 VSS.n3161 VSS.n527 1.76032
R6518 VSS.n3161 VSS.n528 1.76032
R6519 VSS.n3161 VSS.n539 1.76032
R6520 VSS.n3161 VSS.n557 1.76032
R6521 VSS.n3161 VSS.n558 1.76032
R6522 VSS.n3157 VSS.n3156 1.76032
R6523 VSS.n3157 VSS.n570 1.76032
R6524 VSS.n583 VSS.n576 1.76032
R6525 VSS.n583 VSS.n577 1.76032
R6526 VSS.n583 VSS.n578 1.76032
R6527 VSS.n583 VSS.n579 1.76032
R6528 VSS.n583 VSS.n580 1.76032
R6529 VSS.n583 VSS.n581 1.76032
R6530 VSS.n583 VSS.n573 1.76032
R6531 VSS.n583 VSS.n572 1.76032
R6532 VSS.n583 VSS.n571 1.76032
R6533 VSS.n3161 VSS.n517 1.76032
R6534 VSS.n3161 VSS.n509 1.76032
R6535 VSS.n3161 VSS.n508 1.76032
R6536 VSS.n3161 VSS.n507 1.76032
R6537 VSS.n3161 VSS.n482 1.76032
R6538 VSS.n829 VSS.n825 1.76032
R6539 VSS.n829 VSS.n826 1.76032
R6540 VSS.n829 VSS.n827 1.76032
R6541 VSS.n829 VSS.n828 1.76032
R6542 VSS.n887 VSS.n829 1.76032
R6543 VSS.n886 VSS.n829 1.76032
R6544 VSS.n889 VSS.n888 1.76032
R6545 VSS.n889 VSS.n885 1.76032
R6546 VSS.n2573 VSS.n748 1.76032
R6547 VSS.n2573 VSS.n749 1.76032
R6548 VSS.n2573 VSS.n789 1.76032
R6549 VSS.n2573 VSS.n797 1.76032
R6550 VSS.n2573 VSS.n798 1.76032
R6551 VSS.n2573 VSS.n679 1.76032
R6552 VSS.n2573 VSS.n678 1.76032
R6553 VSS.n2573 VSS.n677 1.76032
R6554 VSS.n829 VSS.n824 1.76032
R6555 VSS.n829 VSS.n823 1.76032
R6556 VSS.n829 VSS.n819 1.76032
R6557 VSS.n3609 VSS.n1 1.76032
R6558 VSS.n3608 VSS.n3607 1.76032
R6559 VSS.n3611 VSS.n3610 1.76032
R6560 VSS.n3392 VSS.n1 1.75752
R6561 VSS.n3326 VSS.n1 1.75752
R6562 VSS.n1695 VSS.n1618 1.74151
R6563 VSS.n1842 VSS.n1706 1.73063
R6564 VSS.n2213 VSS.n1666 1.73063
R6565 VSS.n2208 VSS.n1705 1.73063
R6566 VSS.n2199 VSS.n1667 1.73063
R6567 VSS.n2196 VSS.n1704 1.73063
R6568 VSS.n2193 VSS.n1668 1.73063
R6569 VSS.n1942 VSS.n1703 1.73063
R6570 VSS.n1940 VSS.n1669 1.73063
R6571 VSS.n1938 VSS.n1702 1.73063
R6572 VSS.n1936 VSS.n1670 1.73063
R6573 VSS.n1934 VSS.n1701 1.73063
R6574 VSS.n1916 VSS.n1915 1.73063
R6575 VSS.n1914 VSS.n1913 1.73063
R6576 VSS.n1912 VSS.n1911 1.73063
R6577 VSS.n1888 VSS.n1684 1.73063
R6578 VSS.n1889 VSS.n1888 1.73063
R6579 VSS.n1935 VSS.n1934 1.73063
R6580 VSS.n1937 VSS.n1936 1.73063
R6581 VSS.n1939 VSS.n1938 1.73063
R6582 VSS.n1941 VSS.n1940 1.73063
R6583 VSS.n1943 VSS.n1942 1.73063
R6584 VSS.n2194 VSS.n2193 1.73063
R6585 VSS.n2197 VSS.n2196 1.73063
R6586 VSS.n2200 VSS.n2199 1.73063
R6587 VSS.n2209 VSS.n2208 1.73063
R6588 VSS.n2214 VSS.n2213 1.73063
R6589 VSS.n2220 VSS.n1842 1.73063
R6590 VSS.n1911 VSS.n1690 1.73063
R6591 VSS.n1913 VSS.n1676 1.73063
R6592 VSS.n1915 VSS.n1696 1.73063
R6593 VSS.n3578 VSS.n196 1.71411
R6594 VSS.n2407 VSS.n1435 1.7005
R6595 VSS.n2417 VSS.n2416 1.7005
R6596 VSS.n2293 VSS.n1557 1.69725
R6597 VSS.n2187 VSS.n1573 1.69437
R6598 VSS.n3058 VSS.n3057 1.68989
R6599 VSS.n1871 VSS.n1573 1.6799
R6600 VSS.n3581 VSS.n181 1.67409
R6601 VSS.n2407 VSS.n1542 1.66651
R6602 VSS.n2407 VSS.n1515 1.66517
R6603 VSS.t891 VSS.t27 1.60178
R6604 VSS.n2416 VSS.n1494 1.58447
R6605 VSS.n3633 VSS.n1 1.57472
R6606 VSS.n2573 VSS.n806 1.57185
R6607 VSS.n1958 VSS.n1957 1.55742
R6608 VSS.n2029 VSS.n1970 1.54595
R6609 VSS.n1390 VSS 1.53317
R6610 VSS.n1411 VSS.n1259 1.48968
R6611 VSS.n583 VSS.n574 1.48366
R6612 VSS.n1326 VSS.n1320 1.46933
R6613 VSS VSS.n2405 1.4635
R6614 VSS.n1723 VSS.n1573 1.45396
R6615 VSS.n1726 VSS.n1573 1.45396
R6616 VSS.n1731 VSS.n1573 1.45396
R6617 VSS.n1736 VSS.n1573 1.45396
R6618 VSS.n1320 VSS.n1319 1.43035
R6619 VSS.n3350 VSS.n3259 1.42701
R6620 VSS.n1638 VSS.t881 1.41717
R6621 VSS.n1605 VSS.t882 1.41717
R6622 VSS.n1605 VSS.t836 1.41717
R6623 VSS.n1638 VSS.t835 1.41717
R6624 VSS.n1638 VSS.t779 1.41717
R6625 VSS.n1605 VSS.t780 1.41717
R6626 VSS.n1605 VSS.t520 1.41717
R6627 VSS.n1638 VSS.t519 1.41717
R6628 VSS.n1867 VSS.t604 1.41717
R6629 VSS.n1728 VSS.t603 1.41717
R6630 VSS.n1867 VSS.t553 1.41717
R6631 VSS.n1728 VSS.t552 1.41717
R6632 VSS.n1867 VSS.t594 1.41717
R6633 VSS.n1728 VSS.t593 1.41717
R6634 VSS.n1867 VSS.t629 1.41717
R6635 VSS.n1728 VSS.t628 1.41717
R6636 VSS.n2246 VSS.n1577 1.41717
R6637 VSS.t559 VSS.n2990 1.41344
R6638 VSS.n1057 VSS.n995 1.40613
R6639 VSS.n2228 VSS.n1818 1.37996
R6640 VSS.n3101 VSS.n3100 1.37258
R6641 VSS.n3383 VSS.n63 1.37101
R6642 VSS.n2099 VSS.n1568 1.36153
R6643 VSS.n3034 VSS.n2943 1.36081
R6644 VSS.n2562 VSS.n2561 1.35943
R6645 VSS.n2566 VSS.n2565 1.35943
R6646 VSS.n546 VSS.n545 1.34924
R6647 VSS.n545 VSS.n478 1.34893
R6648 VSS.n3629 VSS.n3628 1.33813
R6649 VSS.n2564 VSS.n2562 1.33682
R6650 VSS.n2565 VSS.n2564 1.33682
R6651 VSS.n3628 VSS.n3626 1.33544
R6652 VSS.n3132 VSS.n2584 1.33306
R6653 VSS.n1868 VSS.n1659 1.32581
R6654 VSS.n2957 VSS.t313 1.30826
R6655 VSS.n2936 VSS.t321 1.30826
R6656 VSS.t943 VSS.n225 1.30826
R6657 VSS.n209 VSS.t941 1.30826
R6658 VSS.n3626 VSS.n3625 1.30344
R6659 VSS.n19 VSS.n10 1.30077
R6660 VSS.n3057 VSS.n2743 1.29414
R6661 VSS.n3630 VSS.n3629 1.29393
R6662 VSS.n3163 VSS.n478 1.28313
R6663 VSS.n597 VSS.n546 1.28288
R6664 VSS.n3383 VSS.n3382 1.28276
R6665 VSS.n3350 VSS.n3349 1.27436
R6666 VSS.n1319 VSS.n1259 1.27312
R6667 VSS.n2030 VSS.n1573 1.27106
R6668 VSS.n2022 VSS.n1573 1.27106
R6669 VSS.n1694 VSS.n1659 1.25717
R6670 VSS VSS.n19 1.24483
R6671 VSS.n1957 VSS.n1956 1.24427
R6672 VSS.n2190 VSS.n1886 1.24053
R6673 VSS.n2247 VSS.n1573 1.21479
R6674 VSS.n2498 VSS.n1306 1.19495
R6675 VSS.n2498 VSS.n1299 1.19495
R6676 VSS.n2498 VSS.n1308 1.19472
R6677 VSS.n2540 VSS.n854 1.19166
R6678 VSS.n2540 VSS.n858 1.17575
R6679 VSS.n2413 VSS.n1513 1.17163
R6680 VSS.n2883 VSS.n2882 1.16709
R6681 VSS.n2787 VSS.n2729 1.16656
R6682 VSS.n2522 VSS.n854 1.16319
R6683 VSS.n2734 VSS.n2729 1.15249
R6684 VSS.n3132 VSS.n3131 1.14737
R6685 VSS.n858 VSS 1.1447
R6686 VSS.n2531 VSS.n2529 1.14077
R6687 VSS.n2532 VSS.n2531 1.14077
R6688 VSS.n2547 VSS.n2515 1.08547
R6689 VSS.n2033 VSS.n1573 1.063
R6690 VSS.n2246 VSS.n1600 1.063
R6691 VSS.n2112 VSS.n1568 1.06284
R6692 VSS.n2885 VSS.n2879 1.03818
R6693 VSS.n2546 VSS 1.03817
R6694 VSS.n2358 VSS 1.03217
R6695 VSS.n1695 VSS.n1694 1.01425
R6696 VSS.n2695 VSS.n583 1.0005
R6697 VSS.n2573 VSS.n561 1.0005
R6698 VSS.n3041 VSS.n2842 0.994841
R6699 VSS.n2100 VSS.n2099 0.982693
R6700 VSS.n3568 VSS.n3540 0.972167
R6701 VSS.n2232 VSS.n1764 0.968276
R6702 VSS.n2246 VSS.n1618 0.967806
R6703 VSS.n1933 VSS.t203 0.963273
R6704 VSS.t201 VSS.n1673 0.963273
R6705 VSS.t205 VSS.n1675 0.963273
R6706 VSS.t204 VSS.n1677 0.963273
R6707 VSS.n1902 VSS.t202 0.963273
R6708 VSS.n2275 VSS.n1557 0.958768
R6709 VSS.n3101 VSS.n3093 0.954854
R6710 VSS.n2113 VSS.n2112 0.954435
R6711 VSS.n1956 VSS.n1955 0.953183
R6712 VSS.n2266 VSS 0.941895
R6713 VSS.n2550 VSS 0.931191
R6714 VSS.n2982 VSS.n2942 0.928198
R6715 VSS.n1955 VSS.n1954 0.926029
R6716 VSS.n2413 VSS.n2412 0.923672
R6717 VSS.n3565 VSS.n3564 0.91637
R6718 VSS VSS.n559 0.907919
R6719 VSS.n2047 VSS.n1970 0.905526
R6720 VSS.n2568 VSS 0.884167
R6721 VSS.n2275 VSS.n2274 0.865851
R6722 VSS.n2276 VSS.n2275 0.863308
R6723 VSS.n2547 VSS.n2546 0.853655
R6724 VSS.n2982 VSS.n2981 0.851804
R6725 VSS.n2984 VSS.n2983 0.851804
R6726 VSS.n3564 VSS.n3555 0.851804
R6727 VSS.n3563 VSS.n3562 0.851804
R6728 VSS.n2577 VSS.n673 0.826398
R6729 VSS.n2170 VSS.n1886 0.823458
R6730 VSS.n1637 VSS.n1618 0.818435
R6731 VSS.n2504 VSS.n1147 0.815886
R6732 VSS.n479 VSS 0.810833
R6733 VSS VSS.n3645 0.810833
R6734 VSS.n1764 VSS.n1763 0.787922
R6735 VSS.n1398 VSS 0.78425
R6736 VSS.n2246 VSS.n1559 0.73963
R6737 VSS.n2879 VSS 0.711552
R6738 VSS.n3442 VSS.n296 0.708889
R6739 VSS.n2222 VSS.n1764 0.707187
R6740 VSS.n1514 VSS 0.691656
R6741 VSS.n3060 VSS 0.686167
R6742 VSS.n2499 VSS.n2498 0.672671
R6743 VSS.n2049 VSS.n2047 0.661309
R6744 VSS.n2240 VSS.n1695 0.656917
R6745 VSS.n2259 VSS.n1557 0.65239
R6746 VSS VSS.n1494 0.651868
R6747 VSS.n2548 VSS.n1073 0.651267
R6748 VSS.n2498 VSS.n1305 0.643288
R6749 VSS.n2498 VSS.n1304 0.643288
R6750 VSS.n2498 VSS.n1303 0.643288
R6751 VSS.n2498 VSS.n1302 0.643288
R6752 VSS.n2498 VSS.n1301 0.643288
R6753 VSS.n2498 VSS.n1300 0.643288
R6754 VSS.n2498 VSS.n1298 0.643288
R6755 VSS.n2498 VSS.n1297 0.643288
R6756 VSS.n2498 VSS.n1296 0.643288
R6757 VSS.n2451 VSS.n2450 0.607643
R6758 VSS.n2407 VSS.n1546 0.59497
R6759 VSS.n2190 VSS.n2189 0.581924
R6760 VSS.n2500 VSS.n2499 0.575612
R6761 VSS.n1327 VSS.n1295 0.55906
R6762 VSS.n1388 VSS 0.552219
R6763 VSS.n1295 VSS.n1294 0.545126
R6764 VSS.n2885 VSS 0.543167
R6765 VSS.n2100 VSS 0.543167
R6766 VSS.n2248 VSS 0.524833
R6767 VSS.n2098 VSS.n2097 0.520992
R6768 VSS.n2407 VSS.n2406 0.515652
R6769 VSS.n2282 VSS.n2281 0.513904
R6770 VSS.n2268 VSS.n2267 0.51308
R6771 VSS.n3409 VSS.n363 0.503043
R6772 VSS.n2267 VSS.n2266 0.499237
R6773 VSS.n2283 VSS.n2282 0.49658
R6774 VSS.n2498 VSS.n1295 0.494264
R6775 VSS.n1381 VSS.n1380 0.491833
R6776 VSS.n3131 VSS.n3130 0.484193
R6777 VSS.n3210 VSS.n3209 0.484193
R6778 VSS VSS.n1568 0.483778
R6779 VSS.t237 VSS.n1660 0.481886
R6780 VSS.n1957 VSS.n1954 0.465462
R6781 VSS.n1049 VSS.n1005 0.456836
R6782 VSS.n1050 VSS.n1005 0.456836
R6783 VSS.n1005 VSS.n1004 0.456836
R6784 VSS.n3351 VSS.n3257 0.456836
R6785 VSS.n3351 VSS.n3255 0.456836
R6786 VSS.n3351 VSS.n3254 0.456836
R6787 VSS.n3351 VSS.n3252 0.456836
R6788 VSS.n3133 VSS.n666 0.456836
R6789 VSS.n3133 VSS.n662 0.456836
R6790 VSS.n3133 VSS.n659 0.456836
R6791 VSS.n3133 VSS.n657 0.456836
R6792 VSS.n3102 VSS.n2685 0.456836
R6793 VSS.n3102 VSS.n2683 0.456836
R6794 VSS.n3102 VSS.n2682 0.456836
R6795 VSS.n3102 VSS.n2680 0.456836
R6796 VSS.n3401 VSS.n3397 0.456836
R6797 VSS.n3401 VSS.n3393 0.456836
R6798 VSS.n3401 VSS.n3391 0.456836
R6799 VSS.n3401 VSS.n3387 0.456836
R6800 VSS.n2064 VSS.n1970 0.456834
R6801 VSS.n2124 VSS.n2098 0.442624
R6802 VSS.n3622 VSS 0.442266
R6803 VSS.n3062 VSS.n2729 0.441631
R6804 VSS VSS.n3106 0.439526
R6805 VSS.n3262 VSS 0.4386
R6806 VSS.n2499 VSS.n1294 0.436703
R6807 VSS.n2893 VSS.n2879 0.436307
R6808 VSS.n1364 VSS.n1363 0.434493
R6809 VSS.n2189 VSS.n2188 0.431634
R6810 VSS.n2727 VSS.n484 0.431296
R6811 VSS.n1759 VSS.n1746 0.431237
R6812 VSS.n3263 VSS.n3262 0.429547
R6813 VSS.n3106 VSS.n3105 0.428698
R6814 VSS.n3570 VSS.n3569 0.428634
R6815 VSS.n3382 VSS.n106 0.42572
R6816 VSS.n3569 VSS.n187 0.424675
R6817 VSS.n3012 VSS.n2825 0.423352
R6818 VSS.n1377 VSS.n1373 0.420567
R6819 VSS.n1761 VSS.n1758 0.419875
R6820 VSS.n1760 VSS.n1759 0.419875
R6821 VSS.n1763 VSS.n1762 0.419875
R6822 VSS.n2057 VSS.n2046 0.419875
R6823 VSS.n2059 VSS.n2058 0.419875
R6824 VSS.n2056 VSS.n2055 0.419875
R6825 VSS.n1388 VSS.n1369 0.419506
R6826 VSS.n1761 VSS.n1760 0.411167
R6827 VSS.n2057 VSS.n2056 0.411167
R6828 VSS.n1056 VSS.n1055 0.407691
R6829 VSS.n2072 VSS.n2070 0.405262
R6830 VSS.n1762 VSS.n1761 0.401389
R6831 VSS.n2058 VSS.n2057 0.401389
R6832 VSS.n2088 VSS.n2078 0.400577
R6833 VSS.n2984 VSS.n2981 0.398192
R6834 VSS.n2983 VSS.n2982 0.398192
R6835 VSS.n3562 VSS.n3555 0.398192
R6836 VSS.n3564 VSS.n3563 0.398192
R6837 VSS.n2188 VSS 0.3955
R6838 VSS.n3013 VSS.n2943 0.394244
R6839 VSS.n3377 VSS.n3210 0.39333
R6840 VSS.n3130 VSS.n3129 0.39333
R6841 VSS.n2072 VSS.n2071 0.39316
R6842 VSS.n3510 VSS.n181 0.389127
R6843 VSS.n1390 VSS.n1369 0.3839
R6844 VSS.n1398 VSS.n1373 0.382839
R6845 VSS.n2548 VSS.n858 0.380819
R6846 VSS.n2237 VSS.n2236 0.378294
R6847 VSS.n3623 VSS.n3622 0.372126
R6848 VSS.n3558 VSS.n3557 0.371287
R6849 VSS.n3018 VSS.n2825 0.369618
R6850 VSS.n3510 VSS.n187 0.368217
R6851 VSS.n3570 VSS.n3506 0.368026
R6852 VSS.n2988 VSS.n2987 0.36745
R6853 VSS.n1448 VSS 0.3655
R6854 VSS.n2268 VSS.n2253 0.364604
R6855 VSS.n3100 VSS.n3099 0.363691
R6856 VSS.n3349 VSS.n3348 0.363691
R6857 VSS.n2584 VSS.n2583 0.363691
R6858 VSS.n3061 VSS 0.362694
R6859 VSS.n2281 VSS.n2251 0.361868
R6860 VSS.n2498 VSS.n1325 0.360132
R6861 VSS.n2501 VSS.n1258 0.360072
R6862 VSS.n1514 VSS 0.359217
R6863 VSS VSS.n2094 0.357214
R6864 VSS.n2283 VSS.n2251 0.353092
R6865 VSS.n1813 VSS.n1746 0.352331
R6866 VSS.n2266 VSS.n2253 0.351635
R6867 VSS.n2548 VSS.n854 0.349055
R6868 VSS.n2276 VSS.n2252 0.343822
R6869 VSS.n2060 VSS.n1571 0.343325
R6870 VSS.n2274 VSS.n2273 0.341604
R6871 VSS.n1411 VSS.n1409 0.327378
R6872 VSS.n1328 VSS.n1326 0.325494
R6873 VSS.n1328 VSS.n1327 0.322498
R6874 VSS.n2273 VSS 0.320799
R6875 VSS.n2086 VSS.n2085 0.320359
R6876 VSS.n2094 VSS.n2093 0.319126
R6877 VSS.n2181 VSS.n1948 0.318856
R6878 VSS.n999 VSS.n998 0.318749
R6879 VSS VSS.n2252 0.318581
R6880 VSS.n2583 VSS.n600 0.317064
R6881 VSS.n3401 VSS.n3383 0.315678
R6882 VSS.n484 VSS.n479 0.314321
R6883 VSS.n3351 VSS.n3350 0.31419
R6884 VSS.n3061 VSS.n3060 0.313293
R6885 VSS.n1045 VSS.n924 0.313046
R6886 VSS.n2414 VSS.n2413 0.308218
R6887 VSS.n2168 VSS.n1945 0.305387
R6888 VSS.n2225 VSS.n1739 0.301711
R6889 VSS.n2513 VSS.n1132 0.298925
R6890 VSS.n2396 VSS.n1494 0.291559
R6891 VSS.n3348 VSS.n3260 0.285354
R6892 VSS.n3099 VSS.n2624 0.285354
R6893 VSS.n2407 VSS.n1517 0.281045
R6894 VSS.n2093 VSS.n2081 0.277931
R6895 VSS.n2086 VSS.n2081 0.273555
R6896 VSS.n3600 VSS.n106 0.269762
R6897 VSS.n1948 VSS.n1947 0.267889
R6898 VSS.n2171 VSS.n2169 0.265941
R6899 VSS.n1874 VSS.n1873 0.262637
R6900 VSS.n3620 VSS.n19 0.260141
R6901 VSS.n1394 VSS.n1386 0.258083
R6902 VSS.n2233 VSS.n1738 0.254731
R6903 VSS.n2247 VSS.n2246 0.254231
R6904 VSS.n1396 VSS.n1395 0.251667
R6905 VSS.n3521 VSS.n195 0.250506
R6906 VSS.n2227 VSS.n2226 0.250378
R6907 VSS.n2226 VSS.n2225 0.250378
R6908 VSS.n2236 VSS.n1739 0.250378
R6909 VSS.n1418 VSS.n1409 0.250378
R6910 VSS.n2572 VSS.n2571 0.250092
R6911 VSS.n2283 VSS 0.248038
R6912 VSS.n3506 VSS.n245 0.247919
R6913 VSS.n2237 VSS.n1573 0.247222
R6914 VSS.n3018 VSS.n2832 0.246086
R6915 VSS.n1396 VSS.n1384 0.244333
R6916 VSS.n2181 VSS.n1945 0.244318
R6917 VSS.n1395 VSS.n1394 0.243417
R6918 VSS.n3133 VSS.n3132 0.242088
R6919 VSS.n2218 VSS.n1886 0.240675
R6920 VSS.n2570 VSS.n2569 0.237259
R6921 VSS.n2553 VSS.n2552 0.236919
R6922 VSS.n1848 VSS.n1825 0.232746
R6923 VSS.n1847 VSS.n1843 0.230917
R6924 VSS.n2375 VSS 0.229079
R6925 VSS.n1166 VSS.n1164 0.227833
R6926 VSS.n1378 VSS.n1377 0.227833
R6927 VSS.n1391 VSS.n1390 0.227833
R6928 VSS.n1362 VSS.n1361 0.227833
R6929 VSS.n591 VSS.n559 0.226259
R6930 VSS.n3568 VSS.n195 0.224839
R6931 VSS.n1365 VSS 0.222219
R6932 VSS.n1058 VSS.n994 0.220826
R6933 VSS.n2752 VSS.n2751 0.216269
R6934 VSS.n2047 VSS 0.214997
R6935 VSS.n2096 VSS.n2095 0.214713
R6936 VSS.n2407 VSS.n1516 0.212899
R6937 VSS.n591 VSS.n555 0.210562
R6938 VSS.n2989 VSS.n2988 0.207258
R6939 VSS.n2552 VSS.n2551 0.206092
R6940 VSS.n2569 VSS.n2568 0.205752
R6941 VSS VSS.n1825 0.20483
R6942 VSS.n1636 VSS.n1635 0.202821
R6943 VSS.n1866 VSS.n1865 0.202821
R6944 VSS.n1009 VSS 0.201452
R6945 VSS.n2832 VSS.n433 0.200592
R6946 VSS.n3499 VSS.n245 0.200592
R6947 VSS.n2553 VSS.n2550 0.199429
R6948 VSS.n3102 VSS.n3101 0.194374
R6949 VSS.n555 VSS.n554 0.194062
R6950 VSS.n2276 VSS 0.192578
R6951 VSS.n1055 VSS.n1054 0.187772
R6952 VSS.n1758 VSS.n1757 0.187772
R6953 VSS.n2054 VSS.n2053 0.187772
R6954 VSS.n2061 VSS.n2060 0.187772
R6955 VSS.n2451 VSS.n1370 0.185093
R6956 VSS.n2451 VSS.n1405 0.185093
R6957 VSS.n3057 VSS.n2757 0.185093
R6958 VSS.n3620 VSS.n20 0.185093
R6959 VSS.n3062 VSS.n2726 0.185093
R6960 VSS.n3630 VSS.n0 0.181531
R6961 VSS.n2240 VSS.n1659 0.178091
R6962 VSS.n2986 VSS.n2979 0.177512
R6963 VSS.n3560 VSS.n3559 0.177512
R6964 VSS.n2986 VSS.n2985 0.177511
R6965 VSS.n3561 VSS.n3560 0.177511
R6966 VSS.n2823 VSS.n2822 0.176958
R6967 VSS.n3539 VSS.n3538 0.176958
R6968 VSS.n1759 VSS.n1756 0.176759
R6969 VSS.n2169 VSS 0.170287
R6970 VSS.n2987 VSS.n2980 0.167866
R6971 VSS.n3557 VSS.n3556 0.16757
R6972 VSS.n1057 VSS.n1056 0.162092
R6973 VSS.n2562 VSS.n829 0.161292
R6974 VSS.n2565 VSS.n829 0.161292
R6975 VSS.n3009 VSS.n3008 0.155992
R6976 VSS.n1843 VSS.n1835 0.154541
R6977 VSS.n2822 VSS.n2821 0.153278
R6978 VSS.n2821 VSS.n2820 0.153278
R6979 VSS.n2820 VSS.n2819 0.153278
R6980 VSS.n2819 VSS.n2818 0.153278
R6981 VSS.n2818 VSS.n2817 0.153278
R6982 VSS.n2817 VSS.n2816 0.153278
R6983 VSS.n2816 VSS.n2815 0.153278
R6984 VSS.n2815 VSS.n2814 0.153278
R6985 VSS.n2814 VSS.n2813 0.153278
R6986 VSS.n2813 VSS.n2812 0.153278
R6987 VSS.n2812 VSS.n2811 0.153278
R6988 VSS.n2811 VSS.n2810 0.153278
R6989 VSS.n2810 VSS.n2809 0.153278
R6990 VSS.n2809 VSS.n2808 0.153278
R6991 VSS.n2808 VSS.n2807 0.153278
R6992 VSS.n3538 VSS.n3537 0.153278
R6993 VSS.n3537 VSS.n3536 0.153278
R6994 VSS.n3536 VSS.n3535 0.153278
R6995 VSS.n3535 VSS.n3534 0.153278
R6996 VSS.n3534 VSS.n3533 0.153278
R6997 VSS.n3533 VSS.n3532 0.153278
R6998 VSS.n3532 VSS.n3531 0.153278
R6999 VSS.n3531 VSS.n3530 0.153278
R7000 VSS.n3530 VSS.n3529 0.153278
R7001 VSS.n3529 VSS.n3528 0.153278
R7002 VSS.n3528 VSS.n3527 0.153278
R7003 VSS.n3527 VSS.n3526 0.153278
R7004 VSS.n3526 VSS.n3525 0.153278
R7005 VSS.n3525 VSS.n3524 0.153278
R7006 VSS.n3524 VSS.n3523 0.153278
R7007 VSS.n2190 VSS 0.151062
R7008 VSS.n3626 VSS.n1 0.150851
R7009 VSS.n2788 VSS.n2787 0.149892
R7010 VSS.n3008 VSS.n3007 0.149149
R7011 VSS.n3007 VSS.n3006 0.149149
R7012 VSS.n3006 VSS.n3005 0.149149
R7013 VSS.n3005 VSS.n3004 0.149149
R7014 VSS.n3002 VSS.n3001 0.149149
R7015 VSS.n3001 VSS.n3000 0.149149
R7016 VSS.n3000 VSS.n2999 0.149149
R7017 VSS.n2999 VSS.n2998 0.149149
R7018 VSS.n2998 VSS.n2997 0.149149
R7019 VSS.n2997 VSS.n2996 0.149149
R7020 VSS.n2996 VSS.n2995 0.149149
R7021 VSS.n2995 VSS.n2994 0.149149
R7022 VSS.n2789 VSS.n2788 0.149149
R7023 VSS.n3161 VSS.n546 0.148481
R7024 VSS.n3629 VSS.n1 0.148241
R7025 VSS.n3161 VSS.n478 0.148241
R7026 VSS.n3057 VSS.n2745 0.147192
R7027 VSS.n2189 VSS.n1573 0.141789
R7028 VSS.n1961 VSS.n1959 0.13864
R7029 VSS.n1961 VSS.n1960 0.137955
R7030 VSS.n2571 VSS.n2570 0.137919
R7031 VSS VSS.n2500 0.137329
R7032 VSS.n2988 VSS.n2979 0.136644
R7033 VSS.n2055 VSS.n2049 0.136439
R7034 VSS.n3435 VSS.n296 0.136348
R7035 VSS.n3559 VSS.n3558 0.135977
R7036 VSS.n3541 VSS.n3540 0.133198
R7037 VSS.n1868 VSS 0.133183
R7038 VSS.n3004 VSS.n3003 0.132797
R7039 VSS.n2227 VSS.n2222 0.132772
R7040 VSS.n1419 VSS.n1418 0.132772
R7041 VSS.n1758 VSS.n1756 0.132419
R7042 VSS.n1848 VSS.n1847 0.132088
R7043 VSS.n1817 VSS 0.12944
R7044 VSS.n2575 VSS 0.128407
R7045 VSS.n1448 VSS 0.127986
R7046 VSS.n2051 VSS.n2046 0.125167
R7047 VSS.n2051 VSS.n2045 0.125167
R7048 VSS.n2134 VSS.n2072 0.123492
R7049 VSS.n2139 VSS.n2072 0.123361
R7050 VSS.n2097 VSS.n2096 0.123231
R7051 VSS.n1873 VSS.n1872 0.119865
R7052 VSS.n3041 VSS.n3040 0.118799
R7053 VSS.n3060 VSS.n2742 0.117833
R7054 VSS.n554 VSS.n551 0.117833
R7055 VSS.n3162 VSS.n479 0.117833
R7056 VSS.n3624 VSS.n3623 0.117833
R7057 VSS.n1818 VSS.n1817 0.117019
R7058 VSS.n1829 VSS.n1818 0.116682
R7059 VSS.n2522 VSS 0.116542
R7060 VSS VSS.n1514 0.11654
R7061 VSS.n2574 VSS.n675 0.116
R7062 VSS.n843 VSS.n742 0.116
R7063 VSS.n1875 VSS.n1874 0.115404
R7064 VSS.n1542 VSS.n1442 0.114705
R7065 VSS.n2055 VSS.n2054 0.114439
R7066 VSS.n1763 VSS.n1757 0.114439
R7067 VSS.n1515 VSS.n1448 0.113059
R7068 VSS VSS.n1515 0.112648
R7069 VSS.n1568 VSS 0.112192
R7070 VSS.n1327 VSS 0.1105
R7071 VSS.n1542 VSS.n1541 0.110414
R7072 VSS.n2551 VSS.n840 0.107106
R7073 VSS.n2568 VSS.n2567 0.107106
R7074 VSS.n597 VSS.n551 0.103167
R7075 VSS.n3163 VSS.n3162 0.103167
R7076 VSS.n3625 VSS.n3624 0.103167
R7077 VSS.n3597 VSS.n3596 0.103071
R7078 VSS.n3092 VSS.n3091 0.102822
R7079 VSS.n3138 VSS.n3137 0.102822
R7080 VSS.n3299 VSS.n3298 0.102822
R7081 VSS VSS.n732 0.101033
R7082 VSS.n2268 VSS 0.100528
R7083 VSS.n2036 VSS.n1970 0.100511
R7084 VSS.n2037 VSS.n1970 0.100511
R7085 VSS.n2566 VSS.n839 0.0995
R7086 VSS.n2561 VSS.n2560 0.0995
R7087 VSS.n181 VSS.n180 0.0984771
R7088 VSS.n1035 VSS.n799 0.0972705
R7089 VSS.n2397 VSS.n1513 0.0950928
R7090 VSS.n2538 VSS.n2537 0.094413
R7091 VSS.n2543 VSS.n2542 0.094413
R7092 VSS.n2545 VSS.n2544 0.094413
R7093 VSS.n799 VSS 0.09419
R7094 VSS.n2247 VSS.n1571 0.0937808
R7095 VSS.n1880 VSS.n1848 0.0914184
R7096 VSS.n1063 VSS.n732 0.0908652
R7097 VSS.n2790 VSS.n2789 0.0904324
R7098 VSS.n3129 VSS.n2586 0.0888312
R7099 VSS.n3122 VSS.n3121 0.0888312
R7100 VSS.n3378 VSS.n3377 0.0888312
R7101 VSS.n3358 VSS.n3211 0.0888312
R7102 VSS.n1064 VSS.n1063 0.0888312
R7103 VSS.n1036 VSS.n1035 0.0888312
R7104 VSS.n3209 VSS.n63 0.0888312
R7105 VSS.n3558 VSS.n3540 0.0863674
R7106 VSS.n2501 VSS.n1259 0.0853948
R7107 VSS.n313 VSS.n312 0.0847113
R7108 VSS.n323 VSS.n322 0.0844888
R7109 VSS.n3164 VSS.n3163 0.083
R7110 VSS.n598 VSS.n597 0.083
R7111 VSS.n3625 VSS.n9 0.083
R7112 VSS.n3631 VSS.n3630 0.083
R7113 VSS.n319 VSS.n318 0.0828619
R7114 VSS.n320 VSS.n319 0.0828619
R7115 VSS.n324 VSS.n323 0.0819542
R7116 VSS.n314 VSS.n313 0.0817362
R7117 VSS.n2099 VSS.n2072 0.0816453
R7118 VSS.n2561 VSS.n840 0.0777723
R7119 VSS.n2567 VSS.n2566 0.0777723
R7120 VSS.n2728 VSS 0.0775
R7121 VSS.n1880 VSS.n1879 0.0768265
R7122 VSS.n1879 VSS.n1875 0.0768265
R7123 VSS.n1070 VSS 0.0765164
R7124 VSS.n369 VSS.n365 0.0764057
R7125 VSS.n1442 VSS 0.075685
R7126 VSS.n2989 VSS.n2943 0.0753847
R7127 VSS.n2061 VSS.n2059 0.0738333
R7128 VSS.n2112 VSS.n2072 0.0736569
R7129 VSS.n3300 VSS.n3259 0.0723985
R7130 VSS.n1367 VSS.n1366 0.0689026
R7131 VSS.n1400 VSS.n1376 0.0687758
R7132 VSS.n2155 VSS.n2154 0.068079
R7133 VSS.n837 VSS.n675 0.06705
R7134 VSS.n838 VSS.n830 0.06705
R7135 VSS.n844 VSS.n843 0.06705
R7136 VSS.n2559 VSS.n841 0.06705
R7137 VSS.n837 VSS.n836 0.06595
R7138 VSS.n831 VSS.n830 0.06595
R7139 VSS.n839 VSS.n838 0.06595
R7140 VSS.n869 VSS.n844 0.06595
R7141 VSS.n846 VSS.n841 0.06595
R7142 VSS.n2560 VSS.n2559 0.06595
R7143 VSS.n1872 VSS.n1871 0.0659292
R7144 VSS.n2976 VSS.n2931 0.0658426
R7145 VSS.n3416 VSS.n405 0.0652954
R7146 VSS.n2899 VSS.n2898 0.0649607
R7147 VSS.n1871 VSS.n1870 0.0649458
R7148 VSS.n2752 VSS.n2750 0.0643358
R7149 VSS.n330 VSS.n304 0.0640208
R7150 VSS.n3422 VSS.n3421 0.0640208
R7151 VSS.n2842 VSS.n2841 0.0634845
R7152 VSS.n2118 VSS.n2117 0.0628106
R7153 VSS.n1442 VSS.n1441 0.0626244
R7154 VSS.n2107 VSS.n2106 0.0625063
R7155 VSS.n1375 VSS 0.0618561
R7156 VSS.n2104 VSS.n2103 0.0617652
R7157 VSS.n2115 VSS.n2114 0.0614625
R7158 VSS.n2163 VSS.n2162 0.0611212
R7159 VSS.n2924 VSS.n2923 0.0609407
R7160 VSS.n1834 VSS.n1830 0.0601015
R7161 VSS.n2530 VSS.t1075 0.0598364
R7162 VSS.n3627 VSS 0.0592931
R7163 VSS.n2563 VSS 0.0592931
R7164 VSS.n544 VSS 0.0592931
R7165 VSS.n2994 VSS.n2790 0.0592162
R7166 VSS.n2498 VSS.n1320 0.0591735
R7167 VSS.n2975 VSS.n2929 0.0588466
R7168 VSS.n3059 VSS.n2743 0.058351
R7169 VSS.n2229 VSS.n1768 0.0580724
R7170 VSS.n1771 VSS.n1770 0.0580724
R7171 VSS.n1772 VSS.n1771 0.0580724
R7172 VSS.n1770 VSS.n1768 0.0580724
R7173 VSS.n365 VSS.n364 0.0580724
R7174 VSS.n392 VSS.n388 0.0580724
R7175 VSS.n388 VSS.n387 0.0580724
R7176 VSS.n387 VSS.n384 0.0580724
R7177 VSS.n384 VSS.n383 0.0580724
R7178 VSS.n383 VSS.n379 0.0580724
R7179 VSS.n379 VSS.n378 0.0580724
R7180 VSS.n378 VSS.n375 0.0580724
R7181 VSS.n375 VSS.n374 0.0580724
R7182 VSS.n374 VSS.n370 0.0580724
R7183 VSS.n370 VSS.n369 0.0580724
R7184 VSS.n364 VSS.n362 0.0580724
R7185 VSS.n362 VSS.n361 0.0580724
R7186 VSS.n361 VSS.n358 0.0580724
R7187 VSS.n358 VSS.n357 0.0580724
R7188 VSS.n357 VSS.n354 0.0580724
R7189 VSS.n354 VSS.n353 0.0580724
R7190 VSS.n353 VSS.n349 0.0580724
R7191 VSS.n349 VSS.n348 0.0580724
R7192 VSS.n348 VSS.n346 0.0580724
R7193 VSS.n2231 VSS.n2230 0.0571667
R7194 VSS.n1774 VSS.n1773 0.0571667
R7195 VSS.n2004 VSS.n2003 0.0571667
R7196 VSS.n2006 VSS.n1992 0.0571667
R7197 VSS.n2016 VSS.n2015 0.0571667
R7198 VSS.n3434 VSS.n3433 0.0570354
R7199 VSS.n1830 VSS.n1829 0.0568899
R7200 VSS.n2410 VSS.n2409 0.0562285
R7201 VSS.n2114 VSS.n2113 0.0561214
R7202 VSS.n3091 VSS.n3090 0.0559583
R7203 VSS.n3165 VSS.n477 0.0559583
R7204 VSS.n3139 VSS.n3138 0.0559583
R7205 VSS.n599 VSS.n596 0.0559583
R7206 VSS.n3596 VSS.n3595 0.0559583
R7207 VSS.n3594 VSS.n3593 0.0559583
R7208 VSS.n3298 VSS.n7 0.0559583
R7209 VSS.n3632 VSS.n8 0.0559583
R7210 VSS.n2103 VSS.n2102 0.0558171
R7211 VSS.n2158 VSS.n2157 0.0555735
R7212 VSS VSS.n2727 0.0555
R7213 VSS.n2572 VSS 0.0555
R7214 VSS.n2549 VSS 0.0555
R7215 VSS VSS.n2549 0.0555
R7216 VSS.n1326 VSS 0.0555
R7217 VSS.n21 VSS 0.0555
R7218 VSS VSS.n3621 0.0555
R7219 VSS.n2400 VSS.n2399 0.0553208
R7220 VSS.n2108 VSS.n2107 0.055076
R7221 VSS.n3090 VSS.n3089 0.0550417
R7222 VSS.n3087 VSS.n477 0.0550417
R7223 VSS.n3165 VSS.n3164 0.0550417
R7224 VSS.n3139 VSS.n586 0.0550417
R7225 VSS.n596 VSS.n587 0.0550417
R7226 VSS.n599 VSS.n598 0.0550417
R7227 VSS.n3595 VSS.n107 0.0550417
R7228 VSS.n3593 VSS.n108 0.0550417
R7229 VSS.n3594 VSS.n9 0.0550417
R7230 VSS.n3634 VSS.n7 0.0550417
R7231 VSS.n8 VSS.n6 0.0550417
R7232 VSS.n3632 VSS.n3631 0.0550417
R7233 VSS.n1870 VSS.n1869 0.054896
R7234 VSS.n2119 VSS.n2118 0.0547733
R7235 VSS.n3359 VSS.n3358 0.0547235
R7236 VSS.n3121 VSS.n2623 0.0547235
R7237 VSS.n1834 VSS 0.0546709
R7238 VSS.n2540 VSS.n2539 0.0539783
R7239 VSS.n1776 VSS.n1775 0.0538333
R7240 VSS.n1778 VSS.n1777 0.0538333
R7241 VSS.n1780 VSS.n1779 0.0538333
R7242 VSS.n1782 VSS.n1781 0.0538333
R7243 VSS.n1784 VSS.n1783 0.0538333
R7244 VSS.n2152 VSS.n2151 0.0538333
R7245 VSS.n2149 VSS.n1981 0.0538333
R7246 VSS.n2148 VSS.n1984 0.0538333
R7247 VSS.n1999 VSS.n1997 0.0538333
R7248 VSS.n2001 VSS.n2000 0.0538333
R7249 VSS.n2187 VSS.n2186 0.0532991
R7250 VSS.n3569 VSS.n3568 0.0528809
R7251 VSS.n2548 VSS.n2547 0.0522306
R7252 VSS.n2898 VSS.n2897 0.0520218
R7253 VSS.n2917 VSS.n2916 0.0520218
R7254 VSS.n2916 VSS.n2915 0.0520218
R7255 VSS.n3428 VSS.n3427 0.0520218
R7256 VSS.n339 VSS.n337 0.0520218
R7257 VSS.n2059 VSS.n2045 0.0518333
R7258 VSS.n1869 VSS.n1868 0.0516717
R7259 VSS.n2162 VSS.n2161 0.051372
R7260 VSS.n3013 VSS.n3012 0.0512692
R7261 VSS.n1400 VSS.n1399 0.0509817
R7262 VSS.n1389 VSS.n1367 0.0508558
R7263 VSS.n2754 VSS.n2753 0.0507073
R7264 VSS.n2990 VSS.n2989 0.050313
R7265 VSS.n836 VSS.n835 0.05
R7266 VSS.n874 VSS.n869 0.05
R7267 VSS.n2530 VSS.t1074 0.0498243
R7268 VSS.n3483 VSS.n265 0.0496308
R7269 VSS.n2109 VSS.n2108 0.0496052
R7270 VSS.n2120 VSS.n2119 0.0496052
R7271 VSS.n2537 VSS.n2536 0.0487609
R7272 VSS.n2539 VSS.n2538 0.0487609
R7273 VSS.n2542 VSS.n2541 0.0487609
R7274 VSS.n2544 VSS.n2543 0.0487609
R7275 VSS.n3055 VSS.n2743 0.0486479
R7276 VSS.n2536 VSS.n2535 0.0485435
R7277 VSS.n3363 VSS.n3362 0.0484735
R7278 VSS.n3362 VSS.n3359 0.0484735
R7279 VSS.n2622 VSS.n2619 0.0484735
R7280 VSS.n2623 VSS.n2622 0.0484735
R7281 VSS.n2095 VSS 0.0476429
R7282 VSS.n2085 VSS 0.0476429
R7283 VSS.n2500 VSS 0.0471667
R7284 VSS.n322 VSS.n321 0.0462237
R7285 VSS.n2896 VSS.n2874 0.0462237
R7286 VSS.n312 VSS.n311 0.0462237
R7287 VSS.n1789 VSS.n1788 0.0455
R7288 VSS VSS.n2168 0.045398
R7289 VSS.n1834 VSS 0.045398
R7290 VSS.n3011 VSS.n3010 0.0431753
R7291 VSS.n2546 VSS.n2545 0.0431087
R7292 VSS.n2105 VSS.n2104 0.042916
R7293 VSS.n2116 VSS.n2115 0.042916
R7294 VSS.n2750 VSS.n2749 0.0427817
R7295 VSS.n2106 VSS.n2105 0.0425075
R7296 VSS.n2117 VSS.n2116 0.0425075
R7297 VSS.n1098 VSS.n1094 0.0424007
R7298 VSS.n344 VSS.n328 0.0421667
R7299 VSS.n1578 VSS.n1576 0.0421667
R7300 VSS.n3421 VSS.n3420 0.0421478
R7301 VSS.n2753 VSS.n304 0.0421478
R7302 VSS.n1119 VSS.n1118 0.0420648
R7303 VSS.n3377 VSS.n3376 0.04175
R7304 VSS.n3375 VSS.n3374 0.04175
R7305 VSS.n3373 VSS.n3372 0.04175
R7306 VSS.n3236 VSS.n3235 0.04175
R7307 VSS.n3242 VSS.n3241 0.04175
R7308 VSS.n3129 VSS.n3128 0.04175
R7309 VSS.n3127 VSS.n2587 0.04175
R7310 VSS.n3113 VSS.n3112 0.04175
R7311 VSS.n3111 VSS.n3110 0.04175
R7312 VSS.n3109 VSS.n3108 0.04175
R7313 VSS.n3089 VSS.n3088 0.04175
R7314 VSS.n3146 VSS.n586 0.04175
R7315 VSS.n120 VSS.n107 0.04175
R7316 VSS.n3636 VSS.n3634 0.04175
R7317 VSS.n1087 VSS.n1085 0.0415222
R7318 VSS.n1063 VSS.n750 0.0414302
R7319 VSS.n909 VSS.n731 0.0414302
R7320 VSS.n912 VSS.n752 0.0414302
R7321 VSS.n1019 VSS.n794 0.0414302
R7322 VSS.n1023 VSS.n686 0.0414302
R7323 VSS.n3644 VSS.n3643 0.0412594
R7324 VSS.n1637 VSS.n1636 0.0410952
R7325 VSS.n1868 VSS.n1866 0.0410952
R7326 VSS.n1134 VSS.n1133 0.0410889
R7327 VSS.n1041 VSS.n691 0.0409846
R7328 VSS.n1788 VSS.n1787 0.0409529
R7329 VSS.n2154 VSS.n1978 0.0409529
R7330 VSS.n2541 VSS.n2540 0.0409348
R7331 VSS.n3058 VSS.n2744 0.0407743
R7332 VSS.n3009 VSS.n2931 0.0406645
R7333 VSS.n3136 VSS.n600 0.0405348
R7334 VSS.n1135 VSS.n1134 0.0401428
R7335 VSS.n2123 VSS.n2122 0.0400109
R7336 VSS.n3645 VSS.n0 0.039932
R7337 VSS.n1085 VSS.n1077 0.0397096
R7338 VSS.n1835 VSS.n1834 0.0396365
R7339 VSS.n3056 VSS.n2759 0.0395256
R7340 VSS.n1580 VSS.n1579 0.0393667
R7341 VSS.n318 VSS.n311 0.0391998
R7342 VSS.n321 VSS.n320 0.0391998
R7343 VSS.n2904 VSS.n2874 0.0391998
R7344 VSS.n2157 VSS.n2156 0.0389906
R7345 VSS.n2925 VSS.n2924 0.038896
R7346 VSS.n2923 VSS.n2922 0.038896
R7347 VSS.n2920 VSS.n2919 0.038896
R7348 VSS.n2915 VSS.n2914 0.038896
R7349 VSS.n3429 VSS.n3428 0.038896
R7350 VSS.n3425 VSS.n3424 0.038896
R7351 VSS.n3419 VSS.n3418 0.038896
R7352 VSS.n340 VSS.n339 0.038896
R7353 VSS.n334 VSS.n332 0.038896
R7354 VSS.n918 VSS 0.0388721
R7355 VSS.n1124 VSS.n1119 0.0382628
R7356 VSS.n1094 VSS.n1093 0.0379268
R7357 VSS.n3059 VSS.n3058 0.0378918
R7358 VSS.n3265 VSS.n3264 0.0378585
R7359 VSS.n3267 VSS.n3266 0.0378585
R7360 VSS.n3269 VSS.n3268 0.0378585
R7361 VSS.n613 VSS.n612 0.0378585
R7362 VSS.n609 VSS.n608 0.0378585
R7363 VSS.n2585 VSS.n607 0.0378585
R7364 VSS.n3104 VSS.n3103 0.0378585
R7365 VSS.n2677 VSS.n2625 0.0378585
R7366 VSS.n2676 VSS.n2673 0.0378585
R7367 VSS.n65 VSS.n60 0.0378585
R7368 VSS.n67 VSS.n66 0.0378585
R7369 VSS.n3208 VSS.n62 0.0378585
R7370 VSS.n898 VSS.n897 0.037593
R7371 VSS.n914 VSS.n913 0.037593
R7372 VSS.n3371 VSS.n3370 0.03675
R7373 VSS.n3115 VSS.n3114 0.03675
R7374 VSS.n2508 VSS 0.0367069
R7375 VSS.n923 VSS.n691 0.0362227
R7376 VSS VSS.n3363 0.0359735
R7377 VSS.n2619 VSS 0.0359735
R7378 VSS.n315 VSS.n314 0.0359231
R7379 VSS.n325 VSS.n324 0.0359231
R7380 VSS.n2895 VSS.n2894 0.0359231
R7381 VSS.n3054 VSS.n2760 0.0359231
R7382 VSS.n2749 VSS.n2748 0.0359231
R7383 VSS.n2102 VSS.n2101 0.0359231
R7384 VSS.n2110 VSS.n2109 0.0358183
R7385 VSS.n2121 VSS.n2120 0.0358183
R7386 VSS.n3105 VSS.n2624 0.0357621
R7387 VSS.n3263 VSS.n3260 0.0357621
R7388 VSS.n924 VSS.n923 0.0357621
R7389 VSS.n3417 VSS.n3416 0.0354836
R7390 VSS.n3522 VSS.n3521 0.0347493
R7391 VSS.n2156 VSS 0.0336658
R7392 VSS.n1103 VSS.n1102 0.0333464
R7393 VSS.n3368 VSS.n3367 0.033
R7394 VSS.n3366 VSS.n3365 0.033
R7395 VSS.n3357 VSS.n3356 0.033
R7396 VSS.n3226 VSS.n3212 0.033
R7397 VSS.n3228 VSS.n3227 0.033
R7398 VSS.n2598 VSS.n2595 0.033
R7399 VSS.n2600 VSS.n2599 0.033
R7400 VSS.n2605 VSS.n2601 0.033
R7401 VSS.n3120 VSS.n3119 0.033
R7402 VSS.n3118 VSS.n3117 0.033
R7403 VSS.n2919 VSS.n2918 0.0329501
R7404 VSS.n1787 VSS.n1784 0.0326195
R7405 VSS.n2152 VSS.n1978 0.0326195
R7406 VSS.n2001 VSS.n1995 0.0326195
R7407 VSS.n2160 VSS.n1974 0.0325603
R7408 VSS.n917 VSS.n754 0.0324767
R7409 VSS.n1013 VSS.n690 0.0324767
R7410 VSS.n1014 VSS.n792 0.0324767
R7411 VSS.n2013 VSS.n1569 0.0321667
R7412 VSS.n1947 VSS.n1946 0.0321667
R7413 VSS.n2171 VSS.n2170 0.0316795
R7414 VSS.n2342 VSS.n1442 0.0313333
R7415 VSS.n2344 VSS.n1485 0.0313333
R7416 VSS.n2346 VSS.n1484 0.0313333
R7417 VSS.n2348 VSS.n1481 0.0313333
R7418 VSS.n2350 VSS.n1480 0.0313333
R7419 VSS.n2352 VSS.n1477 0.0313333
R7420 VSS.n2354 VSS.n1476 0.0313333
R7421 VSS.n2356 VSS.n1473 0.0313333
R7422 VSS.n2378 VSS.n1453 0.0313333
R7423 VSS.n2380 VSS.n1452 0.0313333
R7424 VSS.n2382 VSS.n1449 0.0313333
R7425 VSS.n2384 VSS.n1448 0.0313333
R7426 VSS.n2575 VSS.n2574 0.0313
R7427 VSS.n1069 VSS.n742 0.0313
R7428 VSS.n901 VSS.n735 0.0311977
R7429 VSS.n902 VSS.n746 0.0311977
R7430 VSS.n1027 VSS.n684 0.0311977
R7431 VSS.n1032 VSS.n801 0.0311977
R7432 VSS.n1029 VSS.n682 0.0311977
R7433 VSS.n2375 VSS.n1456 0.0305
R7434 VSS.n2528 VSS.n2519 0.0300385
R7435 VSS.n2527 VSS.n2520 0.0300385
R7436 VSS.n2527 VSS.n2518 0.0300385
R7437 VSS.n2533 VSS.n2518 0.0300385
R7438 VSS.n2526 VSS.n2521 0.0300385
R7439 VSS.n2526 VSS.n2517 0.0300385
R7440 VSS.n2534 VSS.n2517 0.0300385
R7441 VSS.n2411 VSS.n2410 0.0300033
R7442 VSS.n3426 VSS.n3425 0.0299771
R7443 VSS.n3418 VSS.n3417 0.0299771
R7444 VSS.n335 VSS.n334 0.0299771
R7445 VSS.n2111 VSS.n2110 0.0299771
R7446 VSS.n2122 VSS.n2121 0.0299771
R7447 VSS.n1042 VSS.n1041 0.0299574
R7448 VSS.n2899 VSS.n2895 0.0298723
R7449 VSS.n3640 VSS.n3633 0.029672
R7450 VSS.n2399 VSS.n2398 0.0295228
R7451 VSS.n2793 VSS.n2777 0.0293235
R7452 VSS.n2231 VSS.n1766 0.0292862
R7453 VSS.n2230 VSS.n2229 0.0292862
R7454 VSS.n2003 VSS.n1995 0.0292862
R7455 VSS.n2014 VSS.n2013 0.0292862
R7456 VSS.n1773 VSS.n1772 0.0292862
R7457 VSS.n2222 VSS.n1766 0.0292862
R7458 VSS.n2015 VSS.n2014 0.0292862
R7459 VSS.n346 VSS.n345 0.0292862
R7460 VSS.n327 VSS.n326 0.0292862
R7461 VSS.n2007 VSS.n2004 0.0292862
R7462 VSS.n2012 VSS.n1992 0.0292862
R7463 VSS.n2007 VSS.n2006 0.0292862
R7464 VSS.n2016 VSS.n2012 0.0292862
R7465 VSS.n328 VSS.n327 0.0292862
R7466 VSS.n393 VSS.n392 0.0292862
R7467 VSS.n1294 VSS.n1103 0.0285188
R7468 VSS.n2156 VSS.n2155 0.0280348
R7469 VSS.n3012 VSS.n2823 0.028
R7470 VSS.n3569 VSS.n3539 0.028
R7471 VSS.n2407 VSS.n1544 0.0279335
R7472 VSS.n2411 VSS.n1514 0.0278179
R7473 VSS VSS.n315 0.0277474
R7474 VSS.n344 VSS.n325 0.0277474
R7475 VSS.n2894 VSS 0.0277474
R7476 VSS.n3055 VSS.n3054 0.0277474
R7477 VSS.n2748 VSS.n2744 0.0277474
R7478 VSS.n2101 VSS 0.0277474
R7479 VSS.n2398 VSS.n2396 0.027373
R7480 VSS.n833 VSS.n806 0.027296
R7481 VSS.n3233 VSS.n3232 0.02675
R7482 VSS.n2594 VSS.n2593 0.02675
R7483 VSS.n1136 VSS.n1135 0.0267361
R7484 VSS VSS.n725 0.0266989
R7485 VSS.n994 VSS.n725 0.0266989
R7486 VSS.n3271 VSS.n3270 0.0266664
R7487 VSS.n615 VSS.n614 0.0266664
R7488 VSS.n2672 VSS.n2671 0.0266664
R7489 VSS.n73 VSS.n72 0.0266664
R7490 VSS.n593 VSS.n592 0.0263804
R7491 VSS.n2342 VSS.n1485 0.0263333
R7492 VSS.n2344 VSS.n1484 0.0263333
R7493 VSS.n2346 VSS.n1481 0.0263333
R7494 VSS.n2348 VSS.n1480 0.0263333
R7495 VSS.n2350 VSS.n1477 0.0263333
R7496 VSS.n2352 VSS.n1476 0.0263333
R7497 VSS.n2354 VSS.n1473 0.0263333
R7498 VSS.n2356 VSS.n1472 0.0263333
R7499 VSS.n2378 VSS.n1456 0.0263333
R7500 VSS.n2380 VSS.n1453 0.0263333
R7501 VSS.n2382 VSS.n1452 0.0263333
R7502 VSS.n2384 VSS.n1449 0.0263333
R7503 VSS.n1017 VSS.n688 0.0260814
R7504 VSS.n2754 VSS.n2752 0.0260062
R7505 VSS.n1813 VSS.n1790 0.0259636
R7506 VSS.n2570 VSS.n816 0.0258433
R7507 VSS.n2912 VSS.n310 0.0257703
R7508 VSS.n3432 VSS.n3431 0.0257703
R7509 VSS.n343 VSS.n342 0.0257703
R7510 VSS.n326 VSS 0.0255
R7511 VSS.n2992 VSS.n2991 0.0253059
R7512 VSS.n2977 VSS.n2930 0.0249444
R7513 VSS.n919 VSS.n918 0.0248023
R7514 VSS.n1010 VSS.n1009 0.0248023
R7515 VSS.n2555 VSS.n2554 0.0242745
R7516 VSS.n2358 VSS.n1472 0.0238333
R7517 VSS.n3143 VSS.n588 0.0236448
R7518 VSS.n5 VSS.n4 0.0236448
R7519 VSS.n3274 VSS.n3273 0.0234344
R7520 VSS.n3276 VSS.n3275 0.0234344
R7521 VSS.n3281 VSS.n3280 0.0234344
R7522 VSS.n3283 VSS.n3282 0.0234344
R7523 VSS.n633 VSS.n632 0.0234344
R7524 VSS.n629 VSS.n628 0.0234344
R7525 VSS.n622 VSS.n621 0.0234344
R7526 VSS.n620 VSS.n619 0.0234344
R7527 VSS.n2669 VSS.n2666 0.0234344
R7528 VSS.n2665 VSS.n2664 0.0234344
R7529 VSS.n2658 VSS.n2657 0.0234344
R7530 VSS.n2656 VSS.n2653 0.0234344
R7531 VSS.n82 VSS.n54 0.0234344
R7532 VSS.n84 VSS.n83 0.0234344
R7533 VSS.n79 VSS.n78 0.0234344
R7534 VSS.n71 VSS.n58 0.0234344
R7535 VSS.n3600 VSS.n3599 0.0234167
R7536 VSS.n2514 VSS.n1077 0.0233936
R7537 VSS.n994 VSS.n757 0.0233571
R7538 VSS.n993 VSS.n723 0.0233571
R7539 VSS.n989 VSS.n759 0.0233571
R7540 VSS.n988 VSS.n721 0.0233571
R7541 VSS.n985 VSS.n761 0.0233571
R7542 VSS.n984 VSS.n719 0.0233571
R7543 VSS.n981 VSS.n763 0.0233571
R7544 VSS.n980 VSS.n717 0.0233571
R7545 VSS.n977 VSS.n765 0.0233571
R7546 VSS.n976 VSS.n715 0.0233571
R7547 VSS.n973 VSS.n767 0.0233571
R7548 VSS.n972 VSS.n713 0.0233571
R7549 VSS.n969 VSS.n769 0.0233571
R7550 VSS.n968 VSS.n711 0.0233571
R7551 VSS.n965 VSS.n771 0.0233571
R7552 VSS.n964 VSS.n709 0.0233571
R7553 VSS.n1813 VSS.n1793 0.0228927
R7554 VSS.n2912 VSS.n2911 0.0227973
R7555 VSS.n3431 VSS.n394 0.0227973
R7556 VSS.n342 VSS.n329 0.0227973
R7557 VSS.n2978 VSS.n2941 0.0225789
R7558 VSS.n3427 VSS.n3426 0.0225447
R7559 VSS.n337 VSS.n335 0.0225447
R7560 VSS.n3177 VSS.n3176 0.0224912
R7561 VSS.n3498 VSS.n3497 0.0224912
R7562 VSS.n1088 VSS.n1087 0.0223482
R7563 VSS.n1133 VSS.n1125 0.0220142
R7564 VSS.n834 VSS.n811 0.0217241
R7565 VSS.n871 VSS.n842 0.0217241
R7566 VSS.n2168 VSS.n2167 0.021505
R7567 VSS.n2166 VSS.n2165 0.021505
R7568 VSS.n2163 VSS.n1971 0.021505
R7569 VSS.n2525 VSS.n2516 0.0213696
R7570 VSS.n2535 VSS.n2516 0.0213696
R7571 VSS.n2942 VSS.n2929 0.021311
R7572 VSS.n1118 VSS.n1111 0.0212887
R7573 VSS.n1099 VSS.n1098 0.0212887
R7574 VSS.n467 VSS.n441 0.0211513
R7575 VSS.n3584 VSS.n34 0.0211513
R7576 VSS.n3472 VSS.n256 0.0211513
R7577 VSS.n1111 VSS.n1110 0.0209439
R7578 VSS.n1102 VSS.n1099 0.0209439
R7579 VSS.n1327 VSS 0.020622
R7580 VSS.n2851 VSS.n2775 0.0205
R7581 VSS.n960 VSS.n773 0.0205
R7582 VSS.n3062 VSS.n2740 0.0203122
R7583 VSS.n3062 VSS.n2738 0.0203122
R7584 VSS.n2451 VSS.n1372 0.0203122
R7585 VSS.n2451 VSS.n1374 0.0203122
R7586 VSS.n2451 VSS.n1401 0.0203122
R7587 VSS.n2451 VSS.n1402 0.0203122
R7588 VSS.n3620 VSS.n15 0.0203122
R7589 VSS.n3620 VSS.n17 0.0203122
R7590 VSS.n1390 VSS.n1389 0.0202656
R7591 VSS.n1388 VSS.n1387 0.0202656
R7592 VSS.n1399 VSS.n1398 0.0202656
R7593 VSS.n3057 VSS.n2747 0.0202655
R7594 VSS.n3057 VSS.n2746 0.0202655
R7595 VSS.n3057 VSS.n2755 0.0202655
R7596 VSS.n3057 VSS.n2756 0.0202655
R7597 VSS.n3063 VSS.n3062 0.0202655
R7598 VSS.n2451 VSS.n1352 0.0202655
R7599 VSS.n2451 VSS.n1359 0.0202655
R7600 VSS.n2451 VSS.n1368 0.0202655
R7601 VSS.n2850 VSS.n2849 0.0202059
R7602 VSS.n2779 VSS.n2778 0.0202059
R7603 VSS.n1252 VSS.n1248 0.0200968
R7604 VSS.n1248 VSS.n1247 0.0200968
R7605 VSS.n1247 VSS.n1243 0.0200968
R7606 VSS.n1243 VSS.n1242 0.0200968
R7607 VSS.n1242 VSS.n1163 0.0200968
R7608 VSS.n3142 VSS.n3141 0.0199098
R7609 VSS.n3639 VSS.n3638 0.0199098
R7610 VSS.n3 VSS.n2 0.0199098
R7611 VSS.n2523 VSS.n2522 0.0198478
R7612 VSS.n2791 VSS.n2782 0.0198176
R7613 VSS.n905 VSS 0.019686
R7614 VSS.n2853 VSS.n2852 0.0196176
R7615 VSS.n2781 VSS.n2780 0.0196176
R7616 VSS.n2897 VSS.n2896 0.0195717
R7617 VSS.n2918 VSS.n2917 0.0195717
R7618 VSS.n957 VSS.n707 0.0195476
R7619 VSS.n954 VSS.n775 0.0195476
R7620 VSS.n953 VSS.n705 0.0195476
R7621 VSS.n950 VSS.n777 0.0195476
R7622 VSS.n949 VSS.n703 0.0195476
R7623 VSS.n946 VSS.n779 0.0195476
R7624 VSS.n945 VSS.n701 0.0195476
R7625 VSS.n942 VSS.n781 0.0195476
R7626 VSS.n941 VSS.n699 0.0195476
R7627 VSS.n938 VSS.n783 0.0195476
R7628 VSS.n937 VSS.n697 0.0195476
R7629 VSS.n934 VSS.n785 0.0195476
R7630 VSS.n933 VSS.n695 0.0195476
R7631 VSS.n930 VSS.n787 0.0195476
R7632 VSS.n929 VSS.n693 0.0195476
R7633 VSS.n3364 VSS 0.01925
R7634 VSS VSS.n2606 0.01925
R7635 VSS.n1125 VSS.n1124 0.0192448
R7636 VSS.n2260 VSS.n2259 0.0192313
R7637 VSS.n2854 VSS.n2795 0.0192294
R7638 VSS.n3278 VSS.n3277 0.0191873
R7639 VSS.n3285 VSS.n3284 0.0191873
R7640 VSS.n635 VSS.n634 0.0191873
R7641 VSS.n626 VSS.n625 0.0191873
R7642 VSS.n2663 VSS.n2662 0.0191873
R7643 VSS.n2652 VSS.n2651 0.0191873
R7644 VSS.n89 VSS.n88 0.0191873
R7645 VSS.n77 VSS.n76 0.0191873
R7646 VSS VSS.n1977 0.019
R7647 VSS.n592 VSS.n591 0.0189143
R7648 VSS.n1093 VSS.n1088 0.0189108
R7649 VSS.n2787 VSS.n2742 0.0188333
R7650 VSS.n1583 VSS.n1582 0.0188333
R7651 VSS.n1585 VSS.n1584 0.0188333
R7652 VSS.n1587 VSS.n1586 0.0188333
R7653 VSS.n1589 VSS.n1588 0.0188333
R7654 VSS.n1591 VSS.n1590 0.0188333
R7655 VSS.n1594 VSS.n1593 0.0188333
R7656 VSS.n1596 VSS.n1595 0.0188333
R7657 VSS.n1598 VSS.n1597 0.0188333
R7658 VSS.n1637 VSS.n1599 0.0188333
R7659 VSS.n2786 VSS.n2785 0.0186412
R7660 VSS.n3599 VSS.n3597 0.0186143
R7661 VSS.n2855 VSS.n2848 0.0184412
R7662 VSS.n2784 VSS.n2783 0.0184412
R7663 VSS.n1069 VSS.n737 0.018407
R7664 VSS.n808 VSS.n807 0.0183409
R7665 VSS.n813 VSS.n812 0.0183409
R7666 VSS.n870 VSS.n847 0.0183409
R7667 VSS.n816 VSS.n815 0.0182063
R7668 VSS.n3043 VSS.n2800 0.0181471
R7669 VSS VSS.n2187 0.0180916
R7670 VSS.n1197 VSS.n1195 0.0180124
R7671 VSS.n1200 VSS.n1198 0.0180124
R7672 VSS.n1203 VSS.n1201 0.0180124
R7673 VSS.n1206 VSS.n1204 0.0180124
R7674 VSS.n1209 VSS.n1207 0.0180124
R7675 VSS.n1212 VSS.n1210 0.0180124
R7676 VSS VSS.n3261 0.018
R7677 VSS.n3107 VSS 0.018
R7678 VSS.n3569 VSS.n3522 0.0179192
R7679 VSS.n2507 VSS.n2506 0.0178945
R7680 VSS.n3300 VSS.n3299 0.017864
R7681 VSS.n3093 VSS.n3092 0.017864
R7682 VSS.n3137 VSS.n3136 0.017864
R7683 VSS.n3042 VSS.n2801 0.0177588
R7684 VSS.n835 VSS.n831 0.01755
R7685 VSS.n874 VSS.n846 0.01755
R7686 VSS.n2554 VSS.n2553 0.017428
R7687 VSS.n3150 VSS.n3149 0.0174231
R7688 VSS.n2858 VSS.n2857 0.0172647
R7689 VSS.n2524 VSS.n2523 0.0172391
R7690 VSS VSS.n796 0.0171279
R7691 VSS.n2167 VSS.n2166 0.0170829
R7692 VSS.n2165 VSS.n1971 0.0170829
R7693 VSS.n3046 VSS.n2759 0.0170263
R7694 VSS.n2577 VSS.n2576 0.017
R7695 VSS.n2576 VSS 0.017
R7696 VSS.n2843 VSS.n2799 0.0169706
R7697 VSS.n2123 VSS.n2111 0.0169703
R7698 VSS.n2859 VSS.n2797 0.0168765
R7699 VSS.n3003 VSS.n3002 0.0168514
R7700 VSS.n1377 VSS.n1371 0.0168281
R7701 VSS.n2971 VSS.n2968 0.0166085
R7702 VSS.n239 VSS.n236 0.0166085
R7703 VSS.n2760 VSS.n405 0.0165987
R7704 VSS.n2862 VSS.n2861 0.0165824
R7705 VSS.n803 VSS.n674 0.0164884
R7706 VSS.n3147 VSS.n3146 0.0164276
R7707 VSS.n3637 VSS.n3636 0.0164276
R7708 VSS.n1215 VSS.n1213 0.0163706
R7709 VSS.n3424 VSS.n400 0.0161081
R7710 VSS.n3420 VSS.n3419 0.0161081
R7711 VSS.n332 VSS.n331 0.0161081
R7712 VSS.n1375 VSS.n1253 0.016097
R7713 VSS.n2846 VSS.n2845 0.0160882
R7714 VSS.n3003 VSS.n2847 0.0160882
R7715 VSS.n878 VSS.n877 0.0160187
R7716 VSS.n3153 VSS.n3152 0.0159299
R7717 VSS.n595 VSS.n590 0.0159299
R7718 VSS.n3643 VSS.n3642 0.0159299
R7719 VSS.n3484 VSS 0.0158684
R7720 VSS.n1018 VSS.n1017 0.0158488
R7721 VSS.n2860 VSS.n2798 0.0157941
R7722 VSS.n2138 VSS.n2072 0.0157904
R7723 VSS.n2137 VSS.n2072 0.0157904
R7724 VSS.n2136 VSS.n2072 0.0157904
R7725 VSS.n2135 VSS.n2072 0.0157904
R7726 VSS.n2133 VSS.n2072 0.0157904
R7727 VSS.n2132 VSS.n2072 0.0157904
R7728 VSS.n2131 VSS.n2072 0.0157904
R7729 VSS.n2130 VSS.n2072 0.0157904
R7730 VSS.n2129 VSS.n2072 0.0157904
R7731 VSS.n2844 VSS.n2798 0.0157
R7732 VSS.n2529 VSS.n2528 0.0155778
R7733 VSS.n2532 VSS.n2519 0.0155778
R7734 VSS.n1635 VSS.n1620 0.0155595
R7735 VSS.n1865 VSS.n1851 0.0155595
R7736 VSS.n2993 VSS.n2992 0.0155462
R7737 VSS.n3433 VSS.n393 0.0155
R7738 VSS.n345 VSS.n344 0.0155
R7739 VSS.n3234 VSS.n3233 0.0155
R7740 VSS.n2593 VSS.n2592 0.0155
R7741 VSS.n1946 VSS.n1576 0.0155
R7742 VSS.n1579 VSS.n1578 0.0155
R7743 VSS.n2845 VSS.n2844 0.0154059
R7744 VSS.n3152 VSS.n584 0.0151833
R7745 VSS.n835 VSS.n809 0.0151058
R7746 VSS.n875 VSS.n874 0.0151058
R7747 VSS.n2176 VSS.n1968 0.0149856
R7748 VSS.n2184 VSS.n2183 0.0149856
R7749 VSS.n3287 VSS.n3286 0.0149402
R7750 VSS.n3288 VSS.n3287 0.0149402
R7751 VSS.n3289 VSS.n3288 0.0149402
R7752 VSS.n3290 VSS.n3289 0.0149402
R7753 VSS.n3291 VSS.n3290 0.0149402
R7754 VSS.n3294 VSS.n3293 0.0149402
R7755 VSS.n3295 VSS.n3294 0.0149402
R7756 VSS.n3296 VSS.n3295 0.0149402
R7757 VSS.n3297 VSS.n3296 0.0149402
R7758 VSS.n3302 VSS.n3297 0.0149402
R7759 VSS.n3134 VSS.n601 0.0149402
R7760 VSS.n650 VSS.n601 0.0149402
R7761 VSS.n650 VSS.n649 0.0149402
R7762 VSS.n649 VSS.n648 0.0149402
R7763 VSS.n648 VSS.n647 0.0149402
R7764 VSS.n643 VSS.n642 0.0149402
R7765 VSS.n642 VSS.n641 0.0149402
R7766 VSS.n641 VSS.n640 0.0149402
R7767 VSS.n640 VSS.n637 0.0149402
R7768 VSS.n637 VSS.n636 0.0149402
R7769 VSS.n2650 VSS.n2649 0.0149402
R7770 VSS.n2649 VSS.n2648 0.0149402
R7771 VSS.n2648 VSS.n2645 0.0149402
R7772 VSS.n2645 VSS.n2644 0.0149402
R7773 VSS.n2644 VSS.n2643 0.0149402
R7774 VSS.n2641 VSS.n2638 0.0149402
R7775 VSS.n2638 VSS.n2637 0.0149402
R7776 VSS.n2637 VSS.n2636 0.0149402
R7777 VSS.n2636 VSS.n2635 0.0149402
R7778 VSS.n2635 VSS.n2632 0.0149402
R7779 VSS.n99 VSS.n48 0.0149402
R7780 VSS.n101 VSS.n99 0.0149402
R7781 VSS.n101 VSS.n100 0.0149402
R7782 VSS.n100 VSS.n50 0.0149402
R7783 VSS.n94 VSS.n50 0.0149402
R7784 VSS.n97 VSS.n96 0.0149402
R7785 VSS.n96 VSS.n52 0.0149402
R7786 VSS.n87 VSS.n52 0.0149402
R7787 VSS.n91 VSS.n87 0.0149402
R7788 VSS.n91 VSS.n90 0.0149402
R7789 VSS.n2861 VSS.n2860 0.0149118
R7790 VSS.n441 VSS.n418 0.014905
R7791 VSS.n289 VSS.n256 0.014905
R7792 VSS.n3645 VSS.n3644 0.0148378
R7793 VSS.n3172 VSS.n3171 0.0148295
R7794 VSS.n453 VSS.n451 0.0148295
R7795 VSS.n464 VSS.n462 0.0148295
R7796 VSS.n3067 VSS.n3066 0.0148295
R7797 VSS.n166 VSS.n32 0.0148295
R7798 VSS.n3493 VSS.n3492 0.0148295
R7799 VSS.n3450 VSS.n3449 0.0148295
R7800 VSS.n3463 VSS.n3462 0.0148295
R7801 VSS.n3477 VSS.n3476 0.0148295
R7802 VSS VSS.n2575 0.0148
R7803 VSS VSS.n1069 0.0148
R7804 VSS.n922 VSS 0.0147857
R7805 VSS.n3088 VSS.n3087 0.0147083
R7806 VSS.n3146 VSS.n587 0.0147083
R7807 VSS.n120 VSS.n108 0.0147083
R7808 VSS.n3636 VSS.n6 0.0147083
R7809 VSS.n3140 VSS.n595 0.0146855
R7810 VSS.n3642 VSS.n3641 0.0146855
R7811 VSS.n1343 VSS.n1290 0.0146667
R7812 VSS.n1345 VSS.n1344 0.0146667
R7813 VSS.n815 VSS.n814 0.0146494
R7814 VSS.n881 VSS.n880 0.0146494
R7815 VSS.n2557 VSS.n848 0.0146494
R7816 VSS.n3433 VSS.n310 0.0146216
R7817 VSS.n3433 VSS.n3432 0.0146216
R7818 VSS.n344 VSS.n343 0.0146216
R7819 VSS.n417 VSS.n416 0.0146188
R7820 VSS.n469 VSS.n468 0.0146188
R7821 VSS.n3582 VSS.n155 0.0146188
R7822 VSS.n36 VSS.n35 0.0146188
R7823 VSS.n291 VSS.n290 0.0146188
R7824 VSS.n3474 VSS.n3473 0.0146188
R7825 VSS.n2846 VSS.n2797 0.0146176
R7826 VSS.n2175 VSS.n2174 0.0145329
R7827 VSS.n2185 VSS.n1944 0.0145329
R7828 VSS.n2862 VSS.n2799 0.0145235
R7829 VSS.n3586 VSS.n39 0.0144836
R7830 VSS.n2293 VSS.n2292 0.014335
R7831 VSS.n2859 VSS.n2858 0.0142294
R7832 VSS.n442 VSS.n419 0.0141973
R7833 VSS.n3065 VSS.n3064 0.0141973
R7834 VSS.n164 VSS.n154 0.0141973
R7835 VSS.n38 VSS.n37 0.0141973
R7836 VSS.n293 VSS.n292 0.0141973
R7837 VSS.n3475 VSS.n287 0.0141973
R7838 VSS.n2179 VSS.n2177 0.0141241
R7839 VSS.n2173 VSS.n2172 0.0140802
R7840 VSS.n444 VSS.n443 0.0140621
R7841 VSS.n165 VSS.n153 0.0140621
R7842 VSS.n294 VSS.n257 0.0140621
R7843 VSS.n1174 VSS.n1173 0.0140038
R7844 VSS.n1178 VSS.n1174 0.0140038
R7845 VSS.n880 VSS.n845 0.0139647
R7846 VSS.n3176 VSS.n3175 0.0138514
R7847 VSS.n3497 VSS.n3496 0.0138514
R7848 VSS.n957 VSS.n773 0.0138333
R7849 VSS.n954 VSS.n707 0.0138333
R7850 VSS.n953 VSS.n775 0.0138333
R7851 VSS.n949 VSS.n777 0.0138333
R7852 VSS.n946 VSS.n703 0.0138333
R7853 VSS.n945 VSS.n779 0.0138333
R7854 VSS.n942 VSS.n701 0.0138333
R7855 VSS.n941 VSS.n781 0.0138333
R7856 VSS.n938 VSS.n699 0.0138333
R7857 VSS.n937 VSS.n783 0.0138333
R7858 VSS.n934 VSS.n697 0.0138333
R7859 VSS.n933 VSS.n785 0.0138333
R7860 VSS.n930 VSS.n695 0.0138333
R7861 VSS.n929 VSS.n787 0.0138333
R7862 VSS.n923 VSS.n693 0.0138333
R7863 VSS.n2092 VSS.n2082 0.0138279
R7864 VSS.n2092 VSS.n2091 0.0138279
R7865 VSS.n2843 VSS.n2801 0.0137353
R7866 VSS.n2362 VSS.n1468 0.0136755
R7867 VSS.n283 VSS.n263 0.0136407
R7868 VSS.n2991 VSS.n2978 0.0135129
R7869 VSS.n832 VSS.n814 0.0135083
R7870 VSS.n2558 VSS.n2557 0.0135083
R7871 VSS.n2857 VSS.n2796 0.0134412
R7872 VSS.n2515 VSS.n2514 0.0133827
R7873 VSS.n460 VSS.n459 0.0133544
R7874 VSS.n3072 VSS.n3071 0.0133544
R7875 VSS.n169 VSS.n168 0.0133544
R7876 VSS.n3614 VSS.n40 0.0133544
R7877 VSS.n3465 VSS.n3464 0.0133544
R7878 VSS.n285 VSS.n284 0.0133544
R7879 VSS.n3043 VSS.n3042 0.0133471
R7880 VSS.n901 VSS.n744 0.0132907
R7881 VSS.n902 VSS.n735 0.0132907
R7882 VSS.n905 VSS.n746 0.0132907
R7883 VSS.n1035 VSS.n684 0.0132907
R7884 VSS.n1027 VSS.n801 0.0132907
R7885 VSS.n1032 VSS.n682 0.0132907
R7886 VSS.n1029 VSS.n803 0.0132907
R7887 VSS.n1048 VSS.n1005 0.0132449
R7888 VSS.n1005 VSS.n1003 0.0132449
R7889 VSS.n3351 VSS.n3248 0.0132449
R7890 VSS.n3133 VSS.n668 0.0132449
R7891 VSS.n3102 VSS.n2687 0.0132449
R7892 VSS.n3401 VSS.n3193 0.0132449
R7893 VSS.n170 VSS.n152 0.0132192
R7894 VSS.n3174 VSS.n434 0.0131437
R7895 VSS.n157 VSS.n148 0.0131437
R7896 VSS.n3495 VSS.n249 0.0131437
R7897 VSS.n2925 VSS.n2904 0.0131351
R7898 VSS.n2922 VSS.n2906 0.0131351
R7899 VSS.n2920 VSS.n2906 0.0131351
R7900 VSS.n2785 VSS.n2784 0.0130529
R7901 VSS.n176 VSS.n175 0.0130085
R7902 VSS.n2990 VSS.n2978 0.0129344
R7903 VSS.n3047 VSS.n2786 0.0128529
R7904 VSS.n1964 VSS.n1963 0.0127222
R7905 VSS.n2841 VSS.n2800 0.0125588
R7906 VSS.n458 VSS.n457 0.0125115
R7907 VSS.n163 VSS.n162 0.0125115
R7908 VSS.n3460 VSS.n3459 0.0125115
R7909 VSS.n456 VSS.n445 0.0123763
R7910 VSS.n161 VSS.n151 0.0123763
R7911 VSS.n3458 VSS.n258 0.0123763
R7912 VSS.n3169 VSS.n3168 0.0123008
R7913 VSS.n174 VSS.n149 0.0123008
R7914 VSS.n3490 VSS.n3489 0.0123008
R7915 VSS.n3487 VSS.n3486 0.0122895
R7916 VSS.n1185 VSS.n1183 0.0122726
R7917 VSS.n1188 VSS.n1186 0.0122726
R7918 VSS.n1966 VSS.n1965 0.0122695
R7919 VSS.n1953 VSS.n1952 0.0122695
R7920 VSS.n2848 VSS.n2795 0.0122647
R7921 VSS VSS.n853 0.0122416
R7922 VSS.n3141 VSS.n3140 0.0121949
R7923 VSS.n3641 VSS.n2 0.0121949
R7924 VSS.n1790 VSS.n1789 0.0121667
R7925 VSS.n446 VSS.n437 0.0121656
R7926 VSS.n159 VSS.n158 0.0121656
R7927 VSS.n3446 VSS.n254 0.0121656
R7928 VSS VSS.n2507 0.0120325
R7929 VSS.n917 VSS.n729 0.0120116
R7930 VSS.n919 VSS.n754 0.0120116
R7931 VSS.n1010 VSS.n690 0.0120116
R7932 VSS.n1013 VSS.n792 0.0120116
R7933 VSS.n1014 VSS.n688 0.0120116
R7934 VSS.n2854 VSS.n2853 0.0118765
R7935 VSS.n2782 VSS.n2781 0.0118765
R7936 VSS.n2366 VSS.n1464 0.011837
R7937 VSS.n2368 VSS.n1461 0.011837
R7938 VSS.n2370 VSS.n1460 0.011837
R7939 VSS.n3640 VSS.n3639 0.0116971
R7940 VSS.n3062 VSS.n2739 0.0116931
R7941 VSS.n3620 VSS.n16 0.0116931
R7942 VSS.n2791 VSS.n2783 0.0116765
R7943 VSS.n449 VSS.n448 0.0116686
R7944 VSS.n172 VSS.n171 0.0116686
R7945 VSS.n3452 VSS.n3451 0.0116686
R7946 VSS.n2885 VSS 0.0116486
R7947 VSS VSS.n2100 0.0116486
R7948 VSS.n2182 VSS.n2181 0.0116344
R7949 VSS.n1182 VSS.n1181 0.0115368
R7950 VSS.n1219 VSS.n1217 0.0115345
R7951 VSS.n1222 VSS.n1220 0.0115345
R7952 VSS.n1225 VSS.n1223 0.0115345
R7953 VSS.n1232 VSS.n1230 0.0115345
R7954 VSS.n1235 VSS.n1233 0.0115345
R7955 VSS.n173 VSS.n150 0.0115334
R7956 VSS.n454 VSS.n447 0.0114579
R7957 VSS.n160 VSS.n150 0.0114579
R7958 VSS.n3447 VSS.n259 0.0114579
R7959 VSS.n950 VSS 0.0114524
R7960 VSS.n173 VSS.n172 0.0113227
R7961 VSS.n3012 VSS.n3011 0.0112875
R7962 VSS.n832 VSS.n813 0.0112662
R7963 VSS.n2558 VSS.n847 0.0112662
R7964 VSS.n201 VSS.n196 0.0111849
R7965 VSS.n3620 VSS.n11 0.0111696
R7966 VSS.n1170 VSS.n1169 0.0111689
R7967 VSS.n1191 VSS.n1189 0.0111689
R7968 VSS.n2852 VSS.n2794 0.0110882
R7969 VSS.n3014 VSS.n2966 0.0110629
R7970 VSS.n3519 VSS.n202 0.0110629
R7971 VSS.n3542 VSS.n234 0.0110629
R7972 VSS.n1345 VSS.n1291 0.0109971
R7973 VSS.n961 VSS.n960 0.0109762
R7974 VSS.n3149 VSS.n585 0.0109525
R7975 VSS.n3154 VSS.n3153 0.0109505
R7976 VSS.n1110 VSS.n1106 0.0108448
R7977 VSS.n447 VSS.n446 0.0108257
R7978 VSS.n160 VSS.n159 0.0108257
R7979 VSS.n3447 VSS.n3446 0.0108257
R7980 VSS.n833 VSS.n807 0.0108097
R7981 VSS.n3045 VSS.n3044 0.0107105
R7982 VSS.n3286 VSS.n3285 0.0106931
R7983 VSS.n3293 VSS.n3292 0.0106931
R7984 VSS.n647 VSS.n646 0.0106931
R7985 VSS.n636 VSS.n635 0.0106931
R7986 VSS.n2651 VSS.n2650 0.0106931
R7987 VSS.n2642 VSS.n2641 0.0106931
R7988 VSS.n95 VSS.n94 0.0106931
R7989 VSS.n90 VSS.n89 0.0106931
R7990 VSS.n3168 VSS.n437 0.0106905
R7991 VSS.n158 VSS.n149 0.0106905
R7992 VSS.n3489 VSS.n254 0.0106905
R7993 VSS.n2078 VSS.n2077 0.0106352
R7994 VSS.n449 VSS.n445 0.0106149
R7995 VSS.n171 VSS.n151 0.0106149
R7996 VSS.n3452 VSS.n258 0.0106149
R7997 VSS.n3369 VSS.n3368 0.0105
R7998 VSS.n3367 VSS.n3366 0.0105
R7999 VSS.n3365 VSS.n3364 0.0105
R8000 VSS.n3358 VSS.n3357 0.0105
R8001 VSS.n3356 VSS.n3212 0.0105
R8002 VSS.n3227 VSS.n3226 0.0105
R8003 VSS.n3232 VSS.n3228 0.0105
R8004 VSS.n2792 VSS.n2779 0.0105
R8005 VSS.n2792 VSS.n2780 0.0105
R8006 VSS.n2595 VSS.n2594 0.0105
R8007 VSS.n2599 VSS.n2598 0.0105
R8008 VSS.n2601 VSS.n2600 0.0105
R8009 VSS.n2606 VSS.n2605 0.0105
R8010 VSS.n3121 VSS.n3120 0.0105
R8011 VSS.n3119 VSS.n3118 0.0105
R8012 VSS.n3117 VSS.n3116 0.0105
R8013 VSS.n457 VSS.n456 0.0104797
R8014 VSS.n162 VSS.n161 0.0104797
R8015 VSS.n3459 VSS.n3458 0.0104797
R8016 VSS.n2179 VSS.n2178 0.0104588
R8017 VSS.n1967 VSS.n1966 0.0104588
R8018 VSS.n1952 VSS.n1950 0.0104588
R8019 VSS.n2180 VSS.n1949 0.0104588
R8020 VSS.n1165 VSS.n1163 0.0102984
R8021 VSS.n1253 VSS.n1252 0.0102984
R8022 VSS.n3560 VSS.n3557 0.0102581
R8023 VSS.n1816 VSS.n1793 0.0102109
R8024 VSS.n3264 VSS.n3263 0.0101855
R8025 VSS.n3266 VSS.n3265 0.0101855
R8026 VSS.n3268 VSS.n3267 0.0101855
R8027 VSS.n3270 VSS.n3269 0.0101855
R8028 VSS.n614 VSS.n613 0.0101855
R8029 VSS.n612 VSS.n609 0.0101855
R8030 VSS.n608 VSS.n607 0.0101855
R8031 VSS.n3131 VSS.n2585 0.0101855
R8032 VSS.n3105 VSS.n3104 0.0101855
R8033 VSS.n3103 VSS.n2625 0.0101855
R8034 VSS.n2677 VSS.n2676 0.0101855
R8035 VSS.n2673 VSS.n2672 0.0101855
R8036 VSS.n72 VSS.n60 0.0101855
R8037 VSS.n67 VSS.n65 0.0101855
R8038 VSS.n66 VSS.n62 0.0101855
R8039 VSS.n3209 VSS.n3208 0.0101855
R8040 VSS.n3422 VSS.n400 0.0101622
R8041 VSS.n331 VSS.n330 0.0101622
R8042 VSS.n882 VSS.n881 0.0101251
R8043 VSS.n877 VSS.n868 0.0100851
R8044 VSS.n3488 VSS.n3487 0.0100789
R8045 VSS.n2301 VSS.n2293 0.0100459
R8046 VSS.n2508 VSS.n1136 0.0100338
R8047 VSS.n993 VSS.n757 0.0100238
R8048 VSS.n989 VSS.n723 0.0100238
R8049 VSS.n988 VSS.n759 0.0100238
R8050 VSS.n985 VSS.n721 0.0100238
R8051 VSS.n984 VSS.n761 0.0100238
R8052 VSS.n981 VSS.n719 0.0100238
R8053 VSS.n980 VSS.n763 0.0100238
R8054 VSS.n977 VSS.n717 0.0100238
R8055 VSS.n976 VSS.n765 0.0100238
R8056 VSS.n973 VSS.n715 0.0100238
R8057 VSS.n972 VSS.n767 0.0100238
R8058 VSS.n969 VSS.n713 0.0100238
R8059 VSS.n968 VSS.n769 0.0100238
R8060 VSS.n965 VSS.n711 0.0100238
R8061 VSS.n964 VSS.n771 0.0100238
R8062 VSS.n961 VSS.n709 0.0100238
R8063 VSS.n2359 VSS.n1469 0.00999861
R8064 VSS.n2362 VSS.n2361 0.00999861
R8065 VSS.n2365 VSS.n1468 0.00999861
R8066 VSS.n2365 VSS.n2364 0.00999861
R8067 VSS.n2366 VSS.n1465 0.00999861
R8068 VSS.n2368 VSS.n1464 0.00999861
R8069 VSS.n2370 VSS.n1461 0.00999861
R8070 VSS.n2373 VSS.n1460 0.00999861
R8071 VSS.n2376 VSS.n1457 0.00999861
R8072 VSS.n3169 VSS.n435 0.00998276
R8073 VSS.n175 VSS.n174 0.00998276
R8074 VSS.n3490 VSS.n252 0.00998276
R8075 VSS.n2286 VSS.n2285 0.00997549
R8076 VSS.n2987 VSS.n2986 0.00996236
R8077 VSS.n2849 VSS.n2794 0.00991177
R8078 VSS.n2793 VSS.n2775 0.00991177
R8079 VSS.n176 VSS.n148 0.00984756
R8080 VSS.n3056 VSS.n3055 0.00984135
R8081 VSS.n2744 VSS.n265 0.00984135
R8082 VSS.n465 VSS.n458 0.00977203
R8083 VSS.n163 VSS.n152 0.00977203
R8084 VSS.n3460 VSS.n260 0.00977203
R8085 VSS.n1393 VSS.n1392 0.00966667
R8086 VSS.n170 VSS.n169 0.00963683
R8087 VSS.n284 VSS.n283 0.00963683
R8088 VSS.n2177 VSS.n2176 0.00959734
R8089 VSS.n2183 VSS.n2182 0.00959734
R8090 VSS.n1228 VSS.n1226 0.00946552
R8091 VSS.n264 VSS.n263 0.00935057
R8092 VSS.n3070 VSS.n3069 0.0092794
R8093 VSS.n3615 VSS.n3613 0.0092794
R8094 VSS.n1166 VSS.n1165 0.00925622
R8095 VSS.n3551 VSS.n230 0.00924172
R8096 VSS.n3547 VSS.n224 0.00924172
R8097 VSS.n3548 VSS.n192 0.00924172
R8098 VSS.n2261 VSS.n2260 0.00918122
R8099 VSS.n2736 VSS.n2733 0.00916221
R8100 VSS.n109 VSS.n13 0.00916221
R8101 VSS.n3175 VSS.n3174 0.00913985
R8102 VSS.n180 VSS.n157 0.00913985
R8103 VSS.n3496 VSS.n3495 0.00913985
R8104 VSS.n1962 VSS.n1951 0.00910082
R8105 VSS.n922 VSS.n727 0.00907143
R8106 VSS.n1041 VSS.n790 0.00907143
R8107 VSS.n2285 VSS.n2284 0.00897828
R8108 VSS.n3071 VSS.n3070 0.00895122
R8109 VSS.n3615 VSS.n3614 0.00895122
R8110 VSS.n2264 VSS.n2263 0.00893101
R8111 VSS.n460 VSS.n444 0.00892912
R8112 VSS.n168 VSS.n153 0.00892912
R8113 VSS.n3465 VSS.n257 0.00892912
R8114 VSS.n2271 VSS.n2270 0.00887439
R8115 VSS.n1341 VSS.n1292 0.00883333
R8116 VSS.n443 VSS.n442 0.00879392
R8117 VSS.n165 VSS.n164 0.00879392
R8118 VSS.n39 VSS.n38 0.00879392
R8119 VSS.n294 VSS.n293 0.00879392
R8120 VSS.n2279 VSS.n2278 0.00862418
R8121 VSS.n3028 VSS.n2966 0.00851324
R8122 VSS.n202 VSS.n201 0.00851324
R8123 VSS.n3545 VSS.n222 0.00851324
R8124 VSS.n3177 VSS.n433 0.00850766
R8125 VSS.n3072 VSS.n440 0.00850766
R8126 VSS.n3586 VSS.n40 0.00850766
R8127 VSS.n3499 VSS.n3498 0.00850766
R8128 VSS.n285 VSS.n255 0.00850766
R8129 VSS.n418 VSS.n417 0.00837246
R8130 VSS.n290 VSS.n289 0.00837246
R8131 VSS.n3566 VSS.n3565 0.00833113
R8132 VSS.n3009 VSS.n2842 0.00816764
R8133 VSS.n1361 VSS.n1360 0.00816169
R8134 VSS.n466 VSS.n419 0.00808621
R8135 VSS.n3583 VSS.n154 0.00808621
R8136 VSS.n292 VSS.n261 0.00808621
R8137 VSS.n1307 VSS.n1290 0.00808038
R8138 VSS.n1343 VSS.n1291 0.00808038
R8139 VSS.n1319 VSS.n1307 0.00808038
R8140 VSS.n3044 VSS.n2790 0.00797368
R8141 VSS.n3645 VSS 0.00796606
R8142 VSS.n1397 VSS.n1379 0.00783333
R8143 VSS.n2734 VSS.n2728 0.00783333
R8144 VSS.n2053 VSS.n2046 0.00783333
R8145 VSS.n3621 VSS.n10 0.00783333
R8146 VSS.n3010 VSS.n2993 0.00781978
R8147 VSS.n3010 VSS.n3009 0.00781978
R8148 VSS.n30 VSS.n1 0.00774276
R8149 VSS.n470 VSS.n469 0.00766475
R8150 VSS.n3064 VSS.n470 0.00766475
R8151 VSS.n3585 VSS.n36 0.00766475
R8152 VSS.n3585 VSS.n37 0.00766475
R8153 VSS.n3474 VSS.n262 0.00766475
R8154 VSS.n287 VSS.n262 0.00766475
R8155 VSS.n2847 VSS.n2796 0.00755882
R8156 VSS.n2373 VSS.n2372 0.00754735
R8157 VSS.n3550 VSS.n3544 0.00742053
R8158 VSS.n3553 VSS.n3552 0.00742053
R8159 VSS.n3301 VSS.n3300 0.00729537
R8160 VSS.n3136 VSS.n3135 0.00729537
R8161 VSS.n3093 VSS.n2689 0.00729537
R8162 VSS.n3599 VSS.n3598 0.00729537
R8163 VSS.n1179 VSS.n1178 0.00725188
R8164 VSS.n1173 VSS.n1170 0.00725188
R8165 VSS.n466 VSS.n416 0.0072433
R8166 VSS.n3583 VSS.n3582 0.0072433
R8167 VSS.n3584 VSS.n32 0.0072433
R8168 VSS.n291 VSS.n261 0.0072433
R8169 VSS.n3145 VSS.n588 0.00721946
R8170 VSS.n3635 VSS.n5 0.00721946
R8171 VSS.n3029 VSS.n2968 0.0071898
R8172 VSS.n3554 VSS.n236 0.0071898
R8173 VSS.n1167 VSS.n1166 0.00712207
R8174 VSS.n1361 VSS.n1193 0.00712207
R8175 VSS.n1584 VSS.n1583 0.0071
R8176 VSS.n1586 VSS.n1585 0.0071
R8177 VSS.n1588 VSS.n1587 0.0071
R8178 VSS.n1590 VSS.n1589 0.0071
R8179 VSS.n1595 VSS.n1594 0.0071
R8180 VSS.n1597 VSS.n1596 0.0071
R8181 VSS.n1599 VSS.n1598 0.0071
R8182 VSS.n3024 VSS.n2962 0.00705629
R8183 VSS.n3020 VSS.n2956 0.00705629
R8184 VSS.n3022 VSS.n2954 0.00705629
R8185 VSS.n3021 VSS.n2950 0.00705629
R8186 VSS.n3513 VSS.n218 0.00705629
R8187 VSS.n3514 VSS.n214 0.00705629
R8188 VSS.n3511 VSS.n212 0.00705629
R8189 VSS.n3516 VSS.n206 0.00705629
R8190 VSS.n1422 VSS.n1143 0.00705172
R8191 VSS.n2546 VSS 0.00702174
R8192 VSS.n3147 VSS.n585 0.00697059
R8193 VSS.n3143 VSS.n3142 0.00697059
R8194 VSS.n3638 VSS.n3637 0.00697059
R8195 VSS.n4 VSS.n3 0.00697059
R8196 VSS.n3166 VSS.n474 0.00692418
R8197 VSS.n114 VSS.n113 0.00692418
R8198 VSS.n3067 VSS.n440 0.00682184
R8199 VSS.n3476 VSS.n255 0.00682184
R8200 VSS.n1294 VSS.n1106 0.0067069
R8201 VSS.n834 VSS.n810 0.00666183
R8202 VSS.n873 VSS.n842 0.00666183
R8203 VSS.n3082 VSS.n438 0.00658607
R8204 VSS.n135 VSS.n134 0.00658607
R8205 VSS.n3273 VSS.n3272 0.00644595
R8206 VSS.n3275 VSS.n3274 0.00644595
R8207 VSS.n3277 VSS.n3276 0.00644595
R8208 VSS.n3280 VSS.n3279 0.00644595
R8209 VSS.n3282 VSS.n3281 0.00644595
R8210 VSS.n3284 VSS.n3283 0.00644595
R8211 VSS.n634 VSS.n633 0.00644595
R8212 VSS.n632 VSS.n629 0.00644595
R8213 VSS.n628 VSS.n627 0.00644595
R8214 VSS.n625 VSS.n622 0.00644595
R8215 VSS.n621 VSS.n620 0.00644595
R8216 VSS.n619 VSS.n616 0.00644595
R8217 VSS.n2670 VSS.n2669 0.00644595
R8218 VSS.n2666 VSS.n2665 0.00644595
R8219 VSS.n2664 VSS.n2663 0.00644595
R8220 VSS.n2659 VSS.n2658 0.00644595
R8221 VSS.n2657 VSS.n2656 0.00644595
R8222 VSS.n2653 VSS.n2652 0.00644595
R8223 VSS.n88 VSS.n54 0.00644595
R8224 VSS.n84 VSS.n82 0.00644595
R8225 VSS.n83 VSS.n56 0.00644595
R8226 VSS.n79 VSS.n77 0.00644595
R8227 VSS.n78 VSS.n58 0.00644595
R8228 VSS.n74 VSS.n71 0.00644595
R8229 VSS.n809 VSS.n808 0.00643361
R8230 VSS.n812 VSS.n811 0.00643361
R8231 VSS.n875 VSS.n868 0.00643361
R8232 VSS.n871 VSS.n870 0.00643361
R8233 VSS.n2259 VSS 0.00642863
R8234 VSS.n1593 VSS.n1592 0.00636667
R8235 VSS.n2707 VSS.n2705 0.00636066
R8236 VSS.n2716 VSS.n2714 0.00636066
R8237 VSS.n144 VSS.n143 0.00636066
R8238 VSS.n3591 VSS.n3590 0.00636066
R8239 VSS.n1344 VSS.n1292 0.00633333
R8240 VSS.n1341 VSS.n1293 0.00633333
R8241 VSS.n3024 VSS.n2964 0.00632781
R8242 VSS.n3023 VSS.n2960 0.00632781
R8243 VSS.n3020 VSS.n2958 0.00632781
R8244 VSS.n3025 VSS.n2954 0.00632781
R8245 VSS.n3021 VSS.n2952 0.00632781
R8246 VSS.n3513 VSS.n216 0.00632781
R8247 VSS.n3512 VSS.n214 0.00632781
R8248 VSS.n3511 VSS.n210 0.00632781
R8249 VSS.n3515 VSS.n208 0.00632781
R8250 VSS.n3516 VSS.n204 0.00632781
R8251 VSS.n3485 VSS.n3484 0.00628947
R8252 VSS.n918 VSS.n727 0.00621429
R8253 VSS.n1009 VSS.n790 0.00621429
R8254 VSS.n2158 VSS.n1974 0.00602764
R8255 VSS.n1817 VSS.n1816 0.00596358
R8256 VSS.n2412 VSS.n1514 0.00596358
R8257 VSS.n2178 VSS.n1967 0.0059321
R8258 VSS.n1950 VSS.n1949 0.0059321
R8259 VSS.n2397 VSS.n2396 0.00587459
R8260 VSS.n3018 VSS.n2960 0.00578146
R8261 VSS.n3510 VSS.n208 0.00578146
R8262 VSS.n2709 VSS.n439 0.00568443
R8263 VSS.n147 VSS.n146 0.00568443
R8264 VSS.n2515 VSS 0.00567241
R8265 VSS.n3506 VSS.n228 0.00559934
R8266 VSS.n465 VSS.n464 0.00555747
R8267 VSS.n3462 VSS.n260 0.00555747
R8268 VSS.n3370 VSS.n3369 0.0055
R8269 VSS.n3116 VSS.n3115 0.0055
R8270 VSS.n2265 VSS.n2264 0.00549922
R8271 VSS.n2161 VSS.n2160 0.00547487
R8272 VSS.n3033 VSS.n2971 0.00545915
R8273 VSS.n3577 VSS.n239 0.00545915
R8274 VSS.n3171 VSS.n435 0.00534674
R8275 VSS.n3492 VSS.n252 0.00534674
R8276 VSS.n2141 VSS.n1570 0.00527938
R8277 VSS.n2142 VSS.n1573 0.00527938
R8278 VSS.n2262 VSS.n2261 0.005249
R8279 VSS.n3023 VSS.n3016 0.0052351
R8280 VSS.n3026 VSS.n3025 0.0052351
R8281 VSS.n3512 VSS.n3507 0.0052351
R8282 VSS.n3515 VSS.n3509 0.0052351
R8283 VSS.n2702 VSS.n471 0.00523361
R8284 VSS.n139 VSS.n43 0.00523361
R8285 VSS.n1365 VSS.n1364 0.00518085
R8286 VSS.n2701 VSS.n2700 0.0051209
R8287 VSS.n2730 VSS.n474 0.0051209
R8288 VSS.n141 VSS.n140 0.0051209
R8289 VSS.n113 VSS.n112 0.0051209
R8290 VSS.n2217 VSS.n2215 0.00511804
R8291 VSS.n2718 VSS.n472 0.0050082
R8292 VSS.n3587 VSS.n124 0.0050082
R8293 VSS.n1422 VSS.n1236 0.00498276
R8294 VSS.n2257 VSS.n2254 0.00494909
R8295 VSS.n2256 VSS.n2255 0.00494909
R8296 VSS.n2262 VSS.n2258 0.00494909
R8297 VSS.n2292 VSS.n2291 0.00494909
R8298 VSS.n3488 VSS.n3485 0.00492105
R8299 VSS.n3003 VSS.n2856 0.00491176
R8300 VSS.n2280 VSS.n2279 0.00488555
R8301 VSS.n3029 VSS.n3028 0.00487086
R8302 VSS.n3015 VSS.n2962 0.00487086
R8303 VSS.n3017 VSS.n2956 0.00487086
R8304 VSS.n3027 VSS.n2950 0.00487086
R8305 VSS.n3520 VSS.n218 0.00487086
R8306 VSS.n3508 VSS.n212 0.00487086
R8307 VSS.n3518 VSS.n206 0.00487086
R8308 VSS.n3566 VSS.n3554 0.00487086
R8309 VSS.n2239 VSS.n2237 0.00486694
R8310 VSS.n3079 VSS.n3078 0.0048311
R8311 VSS.n2733 VSS.n2732 0.0048311
R8312 VSS.n2736 VSS.n2735 0.0048311
R8313 VSS.n3078 VSS.n473 0.0048311
R8314 VSS.n130 VSS.n128 0.0048311
R8315 VSS.n13 VSS.n12 0.0048311
R8316 VSS.n131 VSS.n130 0.0048311
R8317 VSS.n110 VSS.n109 0.0048311
R8318 VSS.n2172 VSS.n2171 0.00480041
R8319 VSS.n2372 VSS.n1457 0.00478969
R8320 VSS.n2735 VSS.n2734 0.00478279
R8321 VSS.n12 VSS.n10 0.00478279
R8322 VSS.n3272 VSS.n3271 0.0047471
R8323 VSS.n3279 VSS.n3278 0.0047471
R8324 VSS.n3292 VSS.n3291 0.0047471
R8325 VSS.n3302 VSS.n3301 0.0047471
R8326 VSS.n3135 VSS.n3134 0.0047471
R8327 VSS.n646 VSS.n643 0.0047471
R8328 VSS.n627 VSS.n626 0.0047471
R8329 VSS.n616 VSS.n615 0.0047471
R8330 VSS.n2671 VSS.n2670 0.0047471
R8331 VSS.n2662 VSS.n2659 0.0047471
R8332 VSS.n2643 VSS.n2642 0.0047471
R8333 VSS.n2689 VSS.n2632 0.0047471
R8334 VSS.n3598 VSS.n48 0.0047471
R8335 VSS.n97 VSS.n95 0.0047471
R8336 VSS.n76 VSS.n56 0.0047471
R8337 VSS.n74 VSS.n73 0.0047471
R8338 VSS.n2711 VSS.n2710 0.00467008
R8339 VSS.n138 VSS.n137 0.00467008
R8340 VSS.n2270 VSS.n2269 0.00463533
R8341 VSS.n2525 VSS.n2524 0.00463044
R8342 VSS.n1422 VSS.n1351 0.00456009
R8343 VSS.n1353 VSS.n1351 0.00455024
R8344 VSS.n1005 VSS.n995 0.00447586
R8345 VSS.n898 VSS.n737 0.00433721
R8346 VSS.n913 VSS.n729 0.00433721
R8347 VSS.n3047 VSS.n3046 0.00432353
R8348 VSS.n2206 VSS.n2205 0.00423125
R8349 VSS.n2202 VSS.n2201 0.00423125
R8350 VSS.n2204 VSS.n2203 0.00423125
R8351 VSS.n2720 VSS.n2719 0.00421926
R8352 VSS.n118 VSS.n117 0.00421926
R8353 VSS.n1581 VSS.n1580 0.00416667
R8354 VSS.n3551 VSS.n232 0.00414238
R8355 VSS.n3546 VSS.n230 0.00414238
R8356 VSS.n3550 VSS.n228 0.00414238
R8357 VSS.n3547 VSS.n226 0.00414238
R8358 VSS.n3549 VSS.n224 0.00414238
R8359 VSS.n3552 VSS.n222 0.00414238
R8360 VSS.n3548 VSS.n220 0.00414238
R8361 VSS.n1965 VSS.n1951 0.0041214
R8362 VSS.n1964 VSS.n1962 0.0041214
R8363 VSS.n1963 VSS.n1953 0.0041214
R8364 VSS.n1356 VSS.n1354 0.00408981
R8365 VSS.n3057 VSS.n273 0.00407477
R8366 VSS.n1603 VSS.n1602 0.00398818
R8367 VSS.n1354 VSS.n1353 0.00395248
R8368 VSS.n2291 VSS.n2290 0.00395188
R8369 VSS.n2250 VSS.n2249 0.00395188
R8370 VSS.n2289 VSS.n2287 0.00395188
R8371 VSS.n2288 VSS.n2286 0.00395188
R8372 VSS.n1387 VSS.n1371 0.0039375
R8373 VSS.n2893 VSS.n2892 0.00390499
R8374 VSS.n2407 VSS.n1539 0.00389408
R8375 VSS.n454 VSS.n453 0.00387165
R8376 VSS.n3449 VSS.n259 0.00387165
R8377 VSS.n1775 VSS.n1774 0.00383333
R8378 VSS.n1777 VSS.n1776 0.00383333
R8379 VSS.n1779 VSS.n1778 0.00383333
R8380 VSS.n1781 VSS.n1780 0.00383333
R8381 VSS.n1783 VSS.n1782 0.00383333
R8382 VSS.n2151 VSS.n1981 0.00383333
R8383 VSS.n2149 VSS.n2148 0.00383333
R8384 VSS.n1997 VSS.n1984 0.00383333
R8385 VSS.n2000 VSS.n1999 0.00383333
R8386 VSS.n3568 VSS.n3567 0.00377815
R8387 VSS.n451 VSS.n448 0.00366092
R8388 VSS.n3451 VSS.n3450 0.00366092
R8389 VSS VSS.n3483 0.00365789
R8390 VSS.n2975 VSS.n2930 0.00365412
R8391 VSS.n2976 VSS.n2941 0.00365412
R8392 VSS.n2217 VSS.n2216 0.00361225
R8393 VSS.n2092 VSS.n2084 0.00355584
R8394 VSS.n3086 VSS.n3085 0.00354303
R8395 VSS.n119 VSS.n115 0.00354303
R8396 VSS.n2914 VSS.n2911 0.00347297
R8397 VSS.n3429 VSS.n394 0.00347297
R8398 VSS.n340 VSS.n329 0.00347297
R8399 VSS.n1183 VSS.n1182 0.00344314
R8400 VSS.n1582 VSS.n1581 0.00343333
R8401 VSS.n3082 VSS.n3081 0.00343033
R8402 VSS.n134 VSS.n133 0.00343033
R8403 VSS.n3027 VSS.n3013 0.00341391
R8404 VSS.n3521 VSS.n3520 0.00341391
R8405 VSS.n3543 VSS.n3506 0.00341391
R8406 VSS.n1848 VSS.n1836 0.0033875
R8407 VSS.n3085 VSS.n3084 0.00331762
R8408 VSS.n126 VSS.n115 0.00331762
R8409 VSS.n2359 VSS.n2358 0.00325766
R8410 VSS.n2211 VSS.n2210 0.00325
R8411 VSS.n3485 VSS.n264 0.00323946
R8412 VSS.n2191 VSS.n2190 0.0032
R8413 VSS.n3080 VSS.n3079 0.00309221
R8414 VSS.n132 VSS.n131 0.00309221
R8415 VSS.n3062 VSS.n2737 0.00306788
R8416 VSS.n3620 VSS.n14 0.00306788
R8417 VSS.n2216 VSS.n2212 0.00306225
R8418 VSS.n897 VSS.n744 0.00305814
R8419 VSS.n909 VSS.n750 0.00305814
R8420 VSS.n912 VSS.n731 0.00305814
R8421 VSS.n914 VSS.n752 0.00305814
R8422 VSS.n1018 VSS.n794 0.00305814
R8423 VSS.n1019 VSS.n686 0.00305814
R8424 VSS.n1023 VSS.n796 0.00305814
R8425 VSS.n3062 VSS.n2741 0.00302105
R8426 VSS.n3620 VSS.n18 0.00302105
R8427 VSS.n2181 VSS.n2180 0.00298971
R8428 VSS.n1602 VSS.n1601 0.0029316
R8429 VSS.n1607 VSS.n1606 0.0029316
R8430 VSS VSS.n705 0.00288095
R8431 VSS.n3567 VSS.n3541 0.00286755
R8432 VSS.n2731 VSS.n2730 0.0028668
R8433 VSS.n112 VSS.n111 0.0028668
R8434 VSS.n2978 VSS.n2977 0.00286559
R8435 VSS.n2301 VSS.n2248 0.00280126
R8436 VSS.n3150 VSS.n584 0.00273982
R8437 VSS.n2079 VSS.n2078 0.00268693
R8438 VSS.n1632 VSS.n1607 0.00268149
R8439 VSS.n2092 VSS.n2080 0.00266127
R8440 VSS.n2719 VSS.n2690 0.00264139
R8441 VSS.n3081 VSS.n3080 0.00264139
R8442 VSS.n121 VSS.n118 0.00264139
R8443 VSS.n133 VSS.n132 0.00264139
R8444 VSS.n1408 VSS.n1146 0.00262226
R8445 VSS.n2500 VSS.n1293 0.00258333
R8446 VSS.n1229 VSS.n1228 0.00256897
R8447 VSS.n2856 VSS.n2855 0.00255882
R8448 VSS.n2215 VSS.n1836 0.00255589
R8449 VSS.n878 VSS.n845 0.00255394
R8450 VSS.n3541 VSS.n192 0.00250331
R8451 VSS.n3046 VSS.n3045 0.0025
R8452 VSS.n2125 VSS.n2078 0.00249959
R8453 VSS.n1729 VSS.n1647 0.00243166
R8454 VSS.n2575 VSS.n674 0.0024186
R8455 VSS.n2452 VSS.n2451 0.00241417
R8456 VSS.n3178 VSS.n432 0.0023818
R8457 VSS.n3500 VSS.n247 0.0023818
R8458 VSS.n3220 VSS.n1 0.00236504
R8459 VSS.n1169 VSS.n1167 0.00233946
R8460 VSS.n2361 VSS.n1469 0.00233844
R8461 VSS.n2364 VSS.n1465 0.00233844
R8462 VSS.n3014 VSS.n2964 0.00232119
R8463 VSS.n3016 VSS.n2958 0.00232119
R8464 VSS.n3026 VSS.n2952 0.00232119
R8465 VSS.n3507 VSS.n216 0.00232119
R8466 VSS.n3509 VSS.n210 0.00232119
R8467 VSS.n3519 VSS.n204 0.00232119
R8468 VSS.n3542 VSS.n232 0.00232119
R8469 VSS.n3544 VSS.n226 0.00232119
R8470 VSS.n3553 VSS.n220 0.00232119
R8471 VSS.n2174 VSS.n2173 0.0023107
R8472 VSS.n2186 VSS.n1944 0.0023107
R8473 VSS.n2702 VSS.n2701 0.00230328
R8474 VSS.n2705 VSS.n2704 0.00230328
R8475 VSS.n2707 VSS.n2706 0.00230328
R8476 VSS.n2710 VSS.n2709 0.00230328
R8477 VSS.n2716 VSS.n2715 0.00230328
R8478 VSS.n2721 VSS.n2720 0.00230328
R8479 VSS.n140 VSS.n139 0.00230328
R8480 VSS.n143 VSS.n142 0.00230328
R8481 VSS.n144 VSS.n136 0.00230328
R8482 VSS.n146 VSS.n138 0.00230328
R8483 VSS.n3590 VSS.n3588 0.00230328
R8484 VSS.n123 VSS.n117 0.00230328
R8485 VSS.n2071 VSS.n1568 0.00226923
R8486 VSS.n2290 VSS.n2249 0.0022643
R8487 VSS.n2287 VSS.n2250 0.0022643
R8488 VSS.n2289 VSS.n2288 0.0022643
R8489 VSS.n2884 VSS.n316 0.00225
R8490 VSS.n2228 VSS.n1826 0.00224974
R8491 VSS.n1366 VSS.n1365 0.00221875
R8492 VSS.n2712 VSS.n2711 0.00219057
R8493 VSS.n137 VSS.n116 0.00219057
R8494 VSS.n3172 VSS.n434 0.00218582
R8495 VSS.n3493 VSS.n249 0.00218582
R8496 VSS.n1730 VSS.n1729 0.00218159
R8497 VSS.n2128 VSS.n2072 0.00218048
R8498 VSS.n1159 VSS.n1155 0.00213196
R8499 VSS.n3183 VSS.n415 0.002125
R8500 VSS.n3102 VSS.n2627 0.002125
R8501 VSS.n3133 VSS.n604 0.002125
R8502 VSS.n3347 VSS.n3346 0.002125
R8503 VSS.n3084 VSS.n438 0.00207787
R8504 VSS.n135 VSS.n126 0.00207787
R8505 VSS.n1735 VSS.n1734 0.00207557
R8506 VSS.n2403 VSS.n1493 0.00206901
R8507 VSS.n1549 VSS.n1501 0.00206901
R8508 VSS.n1554 VSS.n1439 0.00206901
R8509 VSS.n1385 VSS.n1357 0.00204494
R8510 VSS.n2390 VSS.n1487 0.0020266
R8511 VSS.n1713 VSS.n1657 0.00202026
R8512 VSS.n1856 VSS.n1725 0.00201855
R8513 VSS.n1852 VSS.n1649 0.00201855
R8514 VSS.n1855 VSS.n1722 0.00201855
R8515 VSS.n1853 VSS.n1651 0.00201855
R8516 VSS.n1854 VSS.n1720 0.00201855
R8517 VSS.n1857 VSS.n1718 0.00201855
R8518 VSS.n1861 VSS.n1655 0.00201855
R8519 VSS.n1858 VSS.n1716 0.00201855
R8520 VSS.n2156 VSS.n1977 0.002
R8521 VSS.n593 VSS.n590 0.00199321
R8522 VSS.n1403 VSS.n1152 0.00198881
R8523 VSS.n462 VSS.n459 0.0019751
R8524 VSS.n3464 VSS.n3463 0.0019751
R8525 VSS.n1408 VSS.n1407 0.0019734
R8526 VSS.n1406 VSS.n1148 0.0019734
R8527 VSS.n1155 VSS.n1154 0.0019734
R8528 VSS.n1154 VSS.n1152 0.0019734
R8529 VSS.n1407 VSS.n1406 0.0019734
R8530 VSS.n1404 VSS.n1148 0.0019734
R8531 VSS.n1181 VSS.n1179 0.00197157
R8532 VSS.n3019 VSS.n3015 0.00195695
R8533 VSS.n3022 VSS.n3017 0.00195695
R8534 VSS.n3514 VSS.n3508 0.00195695
R8535 VSS.n3518 VSS.n3517 0.00195695
R8536 VSS.n2450 VSS.n1422 0.00194195
R8537 VSS.n1860 VSS.n1859 0.00192535
R8538 VSS.n1625 VSS.n1616 0.00192364
R8539 VSS.n1629 VSS.n1615 0.00192364
R8540 VSS.n1623 VSS.n1614 0.00192364
R8541 VSS.n1630 VSS.n1612 0.00192364
R8542 VSS.n1622 VSS.n1611 0.00192364
R8543 VSS.n1631 VSS.n1610 0.00192364
R8544 VSS.n1621 VSS.n1609 0.00192364
R8545 VSS.n1633 VSS.n1608 0.00192364
R8546 VSS.n1569 VSS 0.00192364
R8547 VSS.n1606 VSS.n1605 0.00187619
R8548 VSS.n1730 VSS.n1728 0.00187619
R8549 VSS.n2210 VSS.n2207 0.001875
R8550 VSS.n3346 VSS.n3303 0.00187493
R8551 VSS.n2582 VSS.n604 0.00187493
R8552 VSS.n3098 VSS.n2627 0.00187493
R8553 VSS.n3183 VSS.n3182 0.00187493
R8554 VSS.n2555 VSS.n848 0.00186929
R8555 VSS.n2175 VSS.n1968 0.00185802
R8556 VSS.n2185 VSS.n2184 0.00185802
R8557 VSS.n2188 VSS 0.00185802
R8558 VSS.n3088 VSS.n2690 0.00185246
R8559 VSS.n121 VSS.n120 0.00185246
R8560 VSS.n1878 VSS.n1840 0.00183333
R8561 VSS.n1883 VSS.n1882 0.00183333
R8562 VSS.n2387 VSS.n1448 0.00181457
R8563 VSS.n2391 VSS.n1446 0.00181457
R8564 VSS.n2394 VSS.n1487 0.00181457
R8565 VSS.n2401 VSS.n1490 0.00181457
R8566 VSS.n2403 VSS.n1491 0.00181457
R8567 VSS.n2406 VSS.n1493 0.00181457
R8568 VSS.n1547 VSS.n1501 0.00181457
R8569 VSS.n1549 VSS.n1437 0.00181457
R8570 VSS.n2408 VSS.n1497 0.00181457
R8571 VSS.n1552 VSS.n1439 0.00181457
R8572 VSS.n1554 VSS.n1495 0.00181457
R8573 VSS.n2341 VSS.n1442 0.00181457
R8574 VSS.n2238 VSS.n1643 0.00180669
R8575 VSS.n1735 VSS.n1733 0.00180669
R8576 VSS.n1733 VSS.n1643 0.00180669
R8577 VSS.n2239 VSS.n2238 0.00180669
R8578 VSS.n1604 VSS.n1603 0.00180669
R8579 VSS.n2284 VSS.n2283 0.00180404
R8580 VSS.n2221 VSS.n1837 0.0018
R8581 VSS.n1376 VSS.n1375 0.00178906
R8582 VSS.n3019 VSS.n3018 0.00177483
R8583 VSS.n3517 VSS.n3510 0.00177483
R8584 VSS.n2406 VSS 0.00177217
R8585 VSS.n1547 VSS.n1514 0.00177217
R8586 VSS.n3478 VSS.n288 0.00175
R8587 VSS.n3376 VSS.n3375 0.00175
R8588 VSS.n3374 VSS.n3373 0.00175
R8589 VSS.n3372 VSS.n3371 0.00175
R8590 VSS.n3235 VSS.n3234 0.00175
R8591 VSS.n3241 VSS.n3236 0.00175
R8592 VSS.n3261 VSS.n3242 0.00175
R8593 VSS.n2235 VSS.n2234 0.00175
R8594 VSS.n2164 VSS.n1973 0.00175
R8595 VSS.n2437 VSS.n1433 0.00175
R8596 VSS.n3128 VSS.n3127 0.00175
R8597 VSS.n2592 VSS.n2587 0.00175
R8598 VSS.n3114 VSS.n3113 0.00175
R8599 VSS.n3112 VSS.n3111 0.00175
R8600 VSS.n3110 VSS.n3109 0.00175
R8601 VSS.n3108 VSS.n3107 0.00175
R8602 VSS.n3601 VSS.n44 0.00175
R8603 VSS.n2704 VSS.n2700 0.00173975
R8604 VSS.n142 VSS.n141 0.00173975
R8605 VSS.n2266 VSS.n2265 0.00172734
R8606 VSS.n2269 VSS.n2268 0.00172734
R8607 VSS.n2281 VSS.n2280 0.00172734
R8608 VSS.n1865 VSS.n1864 0.00171009
R8609 VSS.n1640 VSS.n1639 0.00168637
R8610 VSS.n1626 VSS.n1617 0.00168637
R8611 VSS.n2205 VSS.n2198 0.00166875
R8612 VSS.n2202 VSS.n2195 0.00166875
R8613 VSS.n2204 VSS.n2192 0.00166875
R8614 VSS.n3576 VSS.n3575 0.00166667
R8615 VSS.n3032 VSS.n3031 0.00166667
R8616 VSS.n2300 VSS.n1567 0.00166667
R8617 VSS.n2724 VSS.n2693 0.00166667
R8618 VSS.n341 VSS.n297 0.00166667
R8619 VSS.n2903 VSS.n2875 0.00166667
R8620 VSS.n2913 VSS.n309 0.00166667
R8621 VSS.n2011 VSS.n2010 0.00166667
R8622 VSS.n2018 VSS.n2017 0.00166667
R8623 VSS.n2066 VSS.n2040 0.00166667
R8624 VSS.n1876 VSS.n1841 0.00166667
R8625 VSS.n1849 VSS.n1573 0.00166667
R8626 VSS.n2159 VSS.n1976 0.00166667
R8627 VSS.n2335 VSS.n2334 0.00166667
R8628 VSS.n2326 VSS.n1556 0.00166667
R8629 VSS.n1507 VSS.n1499 0.00166667
R8630 VSS.n1519 VSS.n1518 0.00166667
R8631 VSS.n2449 VSS.n2448 0.00166667
R8632 VSS.n2491 VSS.n2490 0.00166667
R8633 VSS.n2472 VSS.n1350 0.00166667
R8634 VSS.n1076 VSS.n1074 0.00166667
R8635 VSS.n2153 VSS.n1979 0.00166667
R8636 VSS.n2761 VSS.n406 0.00166667
R8637 VSS.n3074 VSS.n3073 0.00166667
R8638 VSS.n3412 VSS.n404 0.00166667
R8639 VSS.n3612 VSS.n3611 0.00166667
R8640 VSS.n1514 VSS.n1500 0.00163569
R8641 VSS.n3069 VSS.n471 0.00162705
R8642 VSS.n2721 VSS.n2718 0.00162705
R8643 VSS.n3167 VSS.n473 0.00162705
R8644 VSS.n3613 VSS.n43 0.00162705
R8645 VSS.n124 VSS.n123 0.00162705
R8646 VSS.n128 VSS.n125 0.00162705
R8647 VSS.n1815 VSS.n1814 0.00162495
R8648 VSS.n3041 VSS.n432 0.00161816
R8649 VSS.n3572 VSS.n3500 0.00161816
R8650 VSS.n1635 VSS.n1634 0.00161519
R8651 VSS.n1192 VSS.n1191 0.00160368
R8652 VSS.n1360 VSS.n1195 0.00159453
R8653 VSS.n1198 VSS.n1197 0.00159453
R8654 VSS.n1201 VSS.n1200 0.00159453
R8655 VSS.n1204 VSS.n1203 0.00159453
R8656 VSS.n1207 VSS.n1206 0.00159453
R8657 VSS.n1210 VSS.n1209 0.00159453
R8658 VSS.n1213 VSS.n1212 0.00159453
R8659 VSS.n1859 VSS.n1657 0.00159316
R8660 VSS.n1714 VSS.n1713 0.00159316
R8661 VSS.n1383 VSS.n1382 0.00158797
R8662 VSS.n2272 VSS.n2271 0.00157392
R8663 VSS.n2278 VSS.n2277 0.00157392
R8664 VSS.n3617 VSS.n31 0.00157144
R8665 VSS.n3049 VSS.n2774 0.00155557
R8666 VSS.n1734 VSS.n1645 0.00153779
R8667 VSS.n1216 VSS.n1215 0.00153448
R8668 VSS.n2450 VSS 0.00152996
R8669 VSS.n2522 VSS.n853 0.00152996
R8670 VSS.n2400 VSS.n1491 0.00151773
R8671 VSS.n2714 VSS.n2713 0.00151434
R8672 VSS.n3592 VSS.n3591 0.00151434
R8673 VSS.n3146 VSS.n3145 0.00149548
R8674 VSS.n3636 VSS.n3635 0.00149548
R8675 VSS.n2548 VSS.n892 0.00147991
R8676 VSS.n3049 VSS.n3048 0.00144442
R8677 VSS.n2386 VSS.n1446 0.00143292
R8678 VSS.n2393 VSS.n1490 0.00143292
R8679 VSS.n2409 VSS.n1437 0.00143292
R8680 VSS.n1551 VSS.n1497 0.00143292
R8681 VSS.n2340 VSS.n1495 0.00143292
R8682 VSS.n3617 VSS.n3616 0.00142855
R8683 VSS.n835 VSS.n810 0.00141286
R8684 VSS.n874 VSS.n873 0.00141286
R8685 VSS.n1601 VSS.n1569 0.00140164
R8686 VSS.n2405 VSS.n1419 0.00135893
R8687 VSS.n3074 VSS.n415 0.00133332
R8688 VSS.n3412 VSS.n403 0.00133332
R8689 VSS.n3415 VSS.n406 0.00133332
R8690 VSS.n1979 VSS.n1970 0.00133332
R8691 VSS.n2548 VSS.n1074 0.00133332
R8692 VSS.n2448 VSS.n1144 0.00133332
R8693 VSS.n2492 VSS.n2491 0.00133332
R8694 VSS.n2416 VSS.n1499 0.00133332
R8695 VSS.n2336 VSS.n2335 0.00133332
R8696 VSS.n1976 VSS.n1970 0.00133332
R8697 VSS.n1850 VSS.n1841 0.00133332
R8698 VSS.n1850 VSS.n1849 0.00133332
R8699 VSS.n2010 VSS.n1570 0.00133332
R8700 VSS.n2018 VSS.n1573 0.00133332
R8701 VSS.n2067 VSS.n2066 0.00133332
R8702 VSS.n3062 VSS.n2724 0.00133332
R8703 VSS.n2327 VSS.n2326 0.00133332
R8704 VSS.n2473 VSS.n2472 0.00133332
R8705 VSS.n1518 VSS.n1433 0.00133332
R8706 VSS.n1567 VSS.n1557 0.00133332
R8707 VSS.n2926 VSS.n2903 0.00133332
R8708 VSS.n3435 VSS.n309 0.00133332
R8709 VSS.n3031 VSS.n3030 0.00133332
R8710 VSS.n308 VSS.n297 0.00133332
R8711 VSS.n3575 VSS.n190 0.00133332
R8712 VSS.n3612 VSS.n1 0.00133332
R8713 VSS.n1419 VSS.n1146 0.00132445
R8714 VSS.n1385 VSS.n1358 0.00128964
R8715 VSS.n2713 VSS.n2712 0.00128893
R8716 VSS.n3592 VSS.n116 0.00128893
R8717 VSS.n2192 VSS.n2191 0.001275
R8718 VSS.n2203 VSS.n2195 0.001275
R8719 VSS.n2201 VSS.n2198 0.001275
R8720 VSS.n2207 VSS.n2206 0.001275
R8721 VSS.n2263 VSS.n2254 0.00126708
R8722 VSS.n2257 VSS.n2256 0.00126708
R8723 VSS.n2258 VSS.n2255 0.00126708
R8724 VSS.n1970 VSS.n1969 0.00124999
R8725 VSS.n3435 VSS.n316 0.00124998
R8726 VSS.n1973 VSS.n1970 0.00124998
R8727 VSS.n2234 VSS.n1573 0.00124998
R8728 VSS.n2437 VSS.n2436 0.00124998
R8729 VSS.n3471 VSS.n288 0.00124998
R8730 VSS.n3191 VSS.n44 0.00124998
R8731 VSS.n1186 VSS.n1185 0.00123579
R8732 VSS.n1189 VSS.n1188 0.00123579
R8733 VSS.n1193 VSS.n1192 0.00123579
R8734 VSS.n1592 VSS.n1591 0.00123333
R8735 VSS.n3546 VSS.n3543 0.00122848
R8736 VSS.n3549 VSS.n3545 0.00122848
R8737 VSS.n2548 VSS.n855 0.00121641
R8738 VSS.n2228 VSS.n2221 0.00119999
R8739 VSS.n1217 VSS.n1216 0.00118965
R8740 VSS.n1220 VSS.n1219 0.00118965
R8741 VSS.n1223 VSS.n1222 0.00118965
R8742 VSS.n1226 VSS.n1225 0.00118965
R8743 VSS.n1230 VSS.n1229 0.00118965
R8744 VSS.n1233 VSS.n1232 0.00118965
R8745 VSS.n1236 VSS.n1235 0.00118965
R8746 VSS.n2506 VSS.n1143 0.00118965
R8747 VSS.n2706 VSS.n439 0.00117623
R8748 VSS.n2732 VSS.n2731 0.00117623
R8749 VSS.n147 VSS.n136 0.00117623
R8750 VSS.n111 VSS.n110 0.00117623
R8751 VSS.n3133 VSS.n602 0.00117208
R8752 VSS.n3102 VSS.n414 0.00117208
R8753 VSS.n1882 VSS.n1881 0.00116665
R8754 VSS.n1881 VSS.n1840 0.00116665
R8755 VSS.n2387 VSS.n2386 0.00113608
R8756 VSS.n2394 VSS.n2393 0.00113608
R8757 VSS.n2409 VSS.n2408 0.00113608
R8758 VSS.n1552 VSS.n1551 0.00113608
R8759 VSS.n2341 VSS.n2340 0.00113608
R8760 VSS.n1541 VSS 0.00113584
R8761 VSS.n3066 VSS.n3065 0.00113218
R8762 VSS.n3477 VSS.n3475 0.00113218
R8763 VSS.n2032 VSS.n1573 0.00108654
R8764 VSS.n3401 VSS.n3381 0.0010699
R8765 VSS.n2401 VSS.n2400 0.00105127
R8766 VSS.n2212 VSS.n2211 0.00105
R8767 VSS.n1383 VSS.n1254 0.00104399
R8768 VSS.n2247 VSS.n1569 0.00103676
R8769 VSS VSS.n2247 0.00103676
R8770 VSS.n3199 VSS.n1 0.00103026
R8771 VSS.n2246 VSS.n1574 0.00103021
R8772 VSS.n2034 VSS.n1573 0.00100914
R8773 VSS.n2306 VSS.n1557 0.0010065
R8774 VSS.n2143 VSS.n1573 0.00100193
R8775 VSS.n2308 VSS.n1557 0.00100095
R8776 VSS.n2311 VSS.n1557 0.00100095
R8777 VSS.n2309 VSS.n1557 0.00100091
R8778 VSS.n2548 VSS.n859 0.00100082
R8779 VSS.n2548 VSS.n857 0.0010006
R8780 VSS.n3304 VSS.n1 0.00100043
R8781 VSS.n2548 VSS.n860 0.00100032
R8782 VSS.n2548 VSS.n856 0.00100032
R8783 VSS.n2307 VSS.n1557 0.00100006
R8784 VSS.n2310 VSS.n1557 0.00100006
R8785 VSS.n2312 VSS.n1557 0.00100005
R8786 VSS.n2246 VSS.n1558 0.00100001
R8787 VSS.n3468 VSS.n248 0.001
R8788 VSS.n250 VSS.n248 0.001
R8789 VSS.n3494 VSS.n251 0.001
R8790 VSS.n3491 VSS.n253 0.001
R8791 VSS.n3444 VSS.n3443 0.001
R8792 VSS.n3448 VSS.n3445 0.001
R8793 VSS.n3454 VSS.n3453 0.001
R8794 VSS.n3457 VSS.n3455 0.001
R8795 VSS.n3461 VSS.n3456 0.001
R8796 VSS.n3467 VSS.n3466 0.001
R8797 VSS.n3470 VSS.n295 0.001
R8798 VSS.n3479 VSS.n286 0.001
R8799 VSS.n286 VSS.n274 0.001
R8800 VSS.n282 VSS.n275 0.001
R8801 VSS.n276 VSS.n266 0.001
R8802 VSS.n277 VSS.n267 0.001
R8803 VSS.n278 VSS.n268 0.001
R8804 VSS.n279 VSS.n269 0.001
R8805 VSS.n280 VSS.n270 0.001
R8806 VSS.n281 VSS.n271 0.001
R8807 VSS.n3481 VSS.n272 0.001
R8808 VSS.n3482 VSS.n22 0.001
R8809 VSS.n240 VSS.n238 0.001
R8810 VSS.n241 VSS.n240 0.001
R8811 VSS.n2972 VSS.n2970 0.001
R8812 VSS.n2973 VSS.n2972 0.001
R8813 VSS.n3038 VSS.n3036 0.001
R8814 VSS.n3038 VSS.n2933 0.001
R8815 VSS.n2303 VSS.n2302 0.001
R8816 VSS.n2302 VSS.n1560 0.001
R8817 VSS.n2294 VSS.n1561 0.001
R8818 VSS.n2295 VSS.n1562 0.001
R8819 VSS.n2296 VSS.n1563 0.001
R8820 VSS.n2297 VSS.n1564 0.001
R8821 VSS.n2298 VSS.n1565 0.001
R8822 VSS.n2299 VSS.n1566 0.001
R8823 VSS.n890 VSS.n883 0.001
R8824 VSS.n883 VSS.n861 0.001
R8825 VSS.n879 VSS.n862 0.001
R8826 VSS.n876 VSS.n863 0.001
R8827 VSS.n872 VSS.n865 0.001
R8828 VSS.n864 VSS.n849 0.001
R8829 VSS.n2556 VSS.n850 0.001
R8830 VSS.n866 VSS.n851 0.001
R8831 VSS.n889 VSS.n740 0.001
R8832 VSS.n829 VSS.n676 0.001
R8833 VSS.n3158 VSS.n569 0.001
R8834 VSS.n569 VSS.n562 0.001
R8835 VSS.n3151 VSS.n563 0.001
R8836 VSS.n3148 VSS.n564 0.001
R8837 VSS.n3144 VSS.n565 0.001
R8838 VSS.n589 VSS.n566 0.001
R8839 VSS.n594 VSS.n567 0.001
R8840 VSS.n3160 VSS.n560 0.001
R8841 VSS.n3157 VSS.n3155 0.001
R8842 VSS.n3161 VSS.n480 0.001
R8843 VSS.n3179 VSS.n431 0.001
R8844 VSS.n431 VSS.n421 0.001
R8845 VSS.n3173 VSS.n422 0.001
R8846 VSS.n3170 VSS.n423 0.001
R8847 VSS.n436 VSS.n424 0.001
R8848 VSS.n452 VSS.n425 0.001
R8849 VSS.n450 VSS.n426 0.001
R8850 VSS.n455 VSS.n427 0.001
R8851 VSS.n463 VSS.n428 0.001
R8852 VSS.n461 VSS.n429 0.001
R8853 VSS.n3181 VSS.n420 0.001
R8854 VSS.n3073 VSS.n2696 0.001
R8855 VSS.n3068 VSS.n2697 0.001
R8856 VSS.n2703 VSS.n2698 0.001
R8857 VSS.n2708 VSS.n2699 0.001
R8858 VSS.n2723 VSS.n2717 0.001
R8859 VSS.n2722 VSS.n2691 0.001
R8860 VSS.n3083 VSS.n2692 0.001
R8861 VSS.n3077 VSS.n3076 0.001
R8862 VSS.n3048 VSS.n2776 0.001
R8863 VSS.n2774 VSS.n2762 0.001
R8864 VSS.n2764 VSS.n2763 0.001
R8865 VSS.n2766 VSS.n2765 0.001
R8866 VSS.n2768 VSS.n2767 0.001
R8867 VSS.n2770 VSS.n2769 0.001
R8868 VSS.n2773 VSS.n2771 0.001
R8869 VSS.n2772 VSS.n2725 0.001
R8870 VSS.n341 VSS.n298 0.001
R8871 VSS.n338 VSS.n299 0.001
R8872 VSS.n336 VSS.n300 0.001
R8873 VSS.n333 VSS.n301 0.001
R8874 VSS.n3441 VSS.n302 0.001
R8875 VSS.n3057 VSS.n303 0.001
R8876 VSS.n395 VSS.n308 0.001
R8877 VSS.n3430 VSS.n396 0.001
R8878 VSS.n2870 VSS.n397 0.001
R8879 VSS.n2871 VSS.n398 0.001
R8880 VSS.n401 VSS.n399 0.001
R8881 VSS.n3423 VSS.n402 0.001
R8882 VSS.n3414 VSS.n404 0.001
R8883 VSS.n3052 VSS.n2761 0.001
R8884 VSS.n3053 VSS.n2758 0.001
R8885 VSS.n2900 VSS.n2878 0.001
R8886 VSS.n2901 VSS.n2877 0.001
R8887 VSS.n2877 VSS.n2876 0.001
R8888 VSS.n2927 VSS.n2873 0.001
R8889 VSS.n2873 VSS.n2863 0.001
R8890 VSS.n2905 VSS.n2864 0.001
R8891 VSS.n2921 VSS.n2865 0.001
R8892 VSS.n2907 VSS.n2866 0.001
R8893 VSS.n2908 VSS.n2867 0.001
R8894 VSS.n2909 VSS.n2868 0.001
R8895 VSS.n2910 VSS.n2869 0.001
R8896 VSS.n2886 VSS.n2883 0.001
R8897 VSS.n2893 VSS.n2886 0.001
R8898 VSS.n2884 VSS.n2883 0.001
R8899 VSS.n2893 VSS.n2878 0.001
R8900 VSS.n3094 VSS.n2688 0.001
R8901 VSS.n3097 VSS.n3094 0.001
R8902 VSS.n3126 VSS.n2590 0.001
R8903 VSS.n2618 VSS.n2611 0.001
R8904 VSS.n670 VSS.n669 0.001
R8905 VSS.n2581 VSS.n670 0.001
R8906 VSS.n3352 VSS.n3249 0.001
R8907 VSS.n3249 VSS.n3247 0.001
R8908 VSS.n3303 VSS.n3251 0.001
R8909 VSS.n3207 VSS.n3195 0.001
R8910 VSS.n3355 VSS.n3223 0.001
R8911 VSS.n3601 VSS.n64 0.001
R8912 VSS.n1068 VSS.n894 0.001
R8913 VSS.n1062 VSS.n908 0.001
R8914 VSS.n1040 VSS.n1008 0.001
R8915 VSS.n1034 VSS.n1025 0.001
R8916 VSS.n2578 VSS.n672 0.001
R8917 VSS.n1000 VSS.n997 0.001
R8918 VSS.n1005 VSS.n1001 0.001
R8919 VSS.n1001 VSS.n996 0.001
R8920 VSS.n1000 VSS.n996 0.001
R8921 VSS.n1053 VSS.n997 0.001
R8922 VSS.n1059 VSS.n927 0.001
R8923 VSS.n2068 VSS.n1572 0.001
R8924 VSS.n2039 VSS.n1572 0.001
R8925 VSS.n1987 VSS.n1986 0.001
R8926 VSS.n1986 VSS.n1982 0.001
R8927 VSS.n2150 VSS.n1983 0.001
R8928 VSS.n1998 VSS.n1996 0.001
R8929 VSS.n2002 VSS.n1993 0.001
R8930 VSS.n2009 VSS.n2008 0.001
R8931 VSS.n1767 VSS.n1765 0.001
R8932 VSS.n2219 VSS.n1884 0.001
R8933 VSS.n1884 VSS.n1839 0.001
R8934 VSS.n2240 VSS.n1738 0.001
R8935 VSS.n2228 VSS.n1742 0.001
R8936 VSS.n2223 VSS.n1743 0.001
R8937 VSS.n2224 VSS.n1745 0.001
R8938 VSS.n1744 VSS.n1740 0.001
R8939 VSS.n2246 VSS.n1619 0.001
R8940 VSS.n2153 VSS.n1980 0.001
R8941 VSS.n2147 VSS.n2146 0.001
R8942 VSS.n1989 VSS.n1985 0.001
R8943 VSS.n1994 VSS.n1990 0.001
R8944 VSS.n2005 VSS.n1991 0.001
R8945 VSS.n1887 VSS.n1573 0.001
R8946 VSS.n2041 VSS.n1970 0.001
R8947 VSS.n2048 VSS.n2042 0.001
R8948 VSS.n2050 VSS.n2043 0.001
R8949 VSS.n2052 VSS.n2044 0.001
R8950 VSS.n2063 VSS.n2062 0.001
R8951 VSS.n1812 VSS.n1747 0.001
R8952 VSS.n1812 VSS.n1808 0.001
R8953 VSS.n1814 VSS.n1807 0.001
R8954 VSS.n1811 VSS.n1810 0.001
R8955 VSS.n1814 VSS.n1799 0.001
R8956 VSS.n1883 VSS.n1833 0.001
R8957 VSS.n1877 VSS.n1876 0.001
R8958 VSS.n2246 VSS.n1575 0.001
R8959 VSS.n1972 VSS.n1573 0.001
R8960 VSS.n1975 VSS.n1970 0.001
R8961 VSS.t517 VSS.n1624 0.001
R8962 VSS.n2330 VSS.n1548 0.001
R8963 VSS.n2331 VSS.n2330 0.001
R8964 VSS.n2333 VSS.n2332 0.001
R8965 VSS.n2337 VSS.n2329 0.001
R8966 VSS.n2329 VSS.n2328 0.001
R8967 VSS.n2313 VSS.n1556 0.001
R8968 VSS.n2315 VSS.n2314 0.001
R8969 VSS.n2317 VSS.n2316 0.001
R8970 VSS.n2319 VSS.n2318 0.001
R8971 VSS.n2321 VSS.n2320 0.001
R8972 VSS.n2324 VSS.n2322 0.001
R8973 VSS.n2323 VSS.n1543 0.001
R8974 VSS.n1510 VSS.n1504 0.001
R8975 VSS.n1505 VSS.n1504 0.001
R8976 VSS.n1508 VSS.n1506 0.001
R8977 VSS.n2418 VSS.n1145 0.001
R8978 VSS.n2419 VSS.n2418 0.001
R8979 VSS.n2421 VSS.n2420 0.001
R8980 VSS.n2423 VSS.n2422 0.001
R8981 VSS.n2425 VSS.n2424 0.001
R8982 VSS.n2427 VSS.n2426 0.001
R8983 VSS.n2429 VSS.n2428 0.001
R8984 VSS.n2431 VSS.n2430 0.001
R8985 VSS.n2433 VSS.n2432 0.001
R8986 VSS.n2435 VSS.n1434 0.001
R8987 VSS.n1520 VSS.n1519 0.001
R8988 VSS.n1522 VSS.n1521 0.001
R8989 VSS.n1524 VSS.n1523 0.001
R8990 VSS.n1526 VSS.n1525 0.001
R8991 VSS.n1528 VSS.n1527 0.001
R8992 VSS.n1530 VSS.n1529 0.001
R8993 VSS.n1532 VSS.n1531 0.001
R8994 VSS.n1534 VSS.n1533 0.001
R8995 VSS.n1537 VSS.n1535 0.001
R8996 VSS.n1536 VSS.n1420 0.001
R8997 VSS.n2505 VSS.n1144 0.001
R8998 VSS.n2449 VSS.n1431 0.001
R8999 VSS.n2440 VSS.n1430 0.001
R9000 VSS.n2441 VSS.n1429 0.001
R9001 VSS.n2442 VSS.n1428 0.001
R9002 VSS.n2443 VSS.n1427 0.001
R9003 VSS.n2444 VSS.n1426 0.001
R9004 VSS.n2445 VSS.n1425 0.001
R9005 VSS.n2446 VSS.n1424 0.001
R9006 VSS.n1423 VSS.n1421 0.001
R9007 VSS.n2512 VSS.n1137 0.001
R9008 VSS.n1139 VSS.n1137 0.001
R9009 VSS.n2510 VSS.n1140 0.001
R9010 VSS.n2476 VSS.n1141 0.001
R9011 VSS.n2477 VSS.n2476 0.001
R9012 VSS.n2479 VSS.n2478 0.001
R9013 VSS.n2481 VSS.n2480 0.001
R9014 VSS.n2483 VSS.n2482 0.001
R9015 VSS.n2485 VSS.n2484 0.001
R9016 VSS.n2487 VSS.n2486 0.001
R9017 VSS.n2489 VSS.n2488 0.001
R9018 VSS.n2493 VSS.n2475 0.001
R9019 VSS.n2475 VSS.n2474 0.001
R9020 VSS.n2453 VSS.n1350 0.001
R9021 VSS.n2455 VSS.n2454 0.001
R9022 VSS.n2457 VSS.n2456 0.001
R9023 VSS.n2459 VSS.n2458 0.001
R9024 VSS.n2461 VSS.n2460 0.001
R9025 VSS.n2463 VSS.n2462 0.001
R9026 VSS.n2465 VSS.n2464 0.001
R9027 VSS.n2467 VSS.n2466 0.001
R9028 VSS.n2470 VSS.n2468 0.001
R9029 VSS.n2469 VSS.n852 0.001
R9030 VSS.n2501 VSS.n1256 0.001
R9031 VSS.n1346 VSS.n1322 0.001
R9032 VSS.n1347 VSS.n1346 0.001
R9033 VSS.n2497 VSS.n1342 0.001
R9034 VSS.n1412 VSS.n1289 0.001
R9035 VSS.n1414 VSS.n1412 0.001
R9036 VSS.n1413 VSS.n1410 0.001
R9037 VSS.n1417 VSS.n1416 0.001
R9038 VSS.n2513 VSS.n1079 0.001
R9039 VSS.n1323 VSS.n1075 0.001
R9040 VSS.t711 VSS.n476 0.001
R9041 VSS.t711 VSS.n475 0.001
R9042 VSS.n3155 VSS.n583 0.001
R9043 VSS.n2573 VSS.n740 0.001
R9044 VSS.n2501 VSS.n1289 0.001
R9045 VSS.n1414 VSS.n1413 0.001
R9046 VSS.n1417 VSS.n1410 0.001
R9047 VSS.n2498 VSS.n1322 0.001
R9048 VSS.n1347 VSS.n1342 0.001
R9049 VSS.n2498 VSS.n2497 0.001
R9050 VSS.n1256 VSS.n1142 0.001
R9051 VSS.n1323 VSS.n1076 0.001
R9052 VSS.n1079 VSS.n1075 0.001
R9053 VSS.n2513 VSS.n2512 0.001
R9054 VSS.n1140 VSS.n1139 0.001
R9055 VSS.n2510 VSS.n2509 0.001
R9056 VSS.n2509 VSS.n1141 0.001
R9057 VSS.n2505 VSS.n2504 0.001
R9058 VSS.n2478 VSS.n2477 0.001
R9059 VSS.n2480 VSS.n2479 0.001
R9060 VSS.n2482 VSS.n2481 0.001
R9061 VSS.n2484 VSS.n2483 0.001
R9062 VSS.n2486 VSS.n2485 0.001
R9063 VSS.n2488 VSS.n2487 0.001
R9064 VSS.n2490 VSS.n2489 0.001
R9065 VSS.n2451 VSS.n1421 0.001
R9066 VSS.n2446 VSS.n1423 0.001
R9067 VSS.n2445 VSS.n1424 0.001
R9068 VSS.n2444 VSS.n1425 0.001
R9069 VSS.n2443 VSS.n1426 0.001
R9070 VSS.n2442 VSS.n1427 0.001
R9071 VSS.n2441 VSS.n1428 0.001
R9072 VSS.n2440 VSS.n1429 0.001
R9073 VSS.n1431 VSS.n1430 0.001
R9074 VSS.n1416 VSS.n1142 0.001
R9075 VSS.n2504 VSS.n1145 0.001
R9076 VSS.n2420 VSS.n2419 0.001
R9077 VSS.n2422 VSS.n2421 0.001
R9078 VSS.n2424 VSS.n2423 0.001
R9079 VSS.n2426 VSS.n2425 0.001
R9080 VSS.n2428 VSS.n2427 0.001
R9081 VSS.n2430 VSS.n2429 0.001
R9082 VSS.n2432 VSS.n2431 0.001
R9083 VSS.n2433 VSS.n1434 0.001
R9084 VSS.n2436 VSS.n2435 0.001
R9085 VSS.n1512 VSS.n1511 0.001
R9086 VSS.n2416 VSS.n1444 0.001
R9087 VSS.n2414 VSS.n1512 0.001
R9088 VSS.n1511 VSS.n1444 0.001
R9089 VSS.n2414 VSS.n1510 0.001
R9090 VSS.n1506 VSS.n1505 0.001
R9091 VSS.n1508 VSS.n1507 0.001
R9092 VSS.n2407 VSS.n1548 0.001
R9093 VSS.n2332 VSS.n2331 0.001
R9094 VSS.n2334 VSS.n2333 0.001
R9095 VSS.n1628 VSS.n1624 0.001
R9096 VSS.n1863 VSS.t550 0.001
R9097 VSS.n1863 VSS.n1862 0.001
R9098 VSS.n2164 VSS.n1972 0.001
R9099 VSS.n2159 VSS.n1975 0.001
R9100 VSS.n1575 VSS.n1573 0.001
R9101 VSS.n2240 VSS.n1619 0.001
R9102 VSS.n2218 VSS.n1887 0.001
R9103 VSS.n1738 VSS.n1573 0.001
R9104 VSS.n2219 VSS.n2218 0.001
R9105 VSS.n1839 VSS.n1837 0.001
R9106 VSS.n2232 VSS.n1765 0.001
R9107 VSS.n2232 VSS.n1747 0.001
R9108 VSS.n1814 VSS.n1808 0.001
R9109 VSS.n1811 VSS.n1807 0.001
R9110 VSS.n2228 VSS.n1799 0.001
R9111 VSS.n1810 VSS.n1767 0.001
R9112 VSS.n2228 VSS.n1833 0.001
R9113 VSS.n1878 VSS.n1877 0.001
R9114 VSS.n2223 VSS.n1742 0.001
R9115 VSS.n2224 VSS.n1743 0.001
R9116 VSS.n1745 VSS.n1744 0.001
R9117 VSS.n2235 VSS.n1740 0.001
R9118 VSS.n1987 VSS.n1970 0.001
R9119 VSS.n2150 VSS.n1982 0.001
R9120 VSS.n1998 VSS.n1983 0.001
R9121 VSS.n2002 VSS.n1996 0.001
R9122 VSS.n2008 VSS.n1993 0.001
R9123 VSS.n2011 VSS.n2009 0.001
R9124 VSS.n2147 VSS.n1980 0.001
R9125 VSS.n2146 VSS.n1985 0.001
R9126 VSS.n1994 VSS.n1989 0.001
R9127 VSS.n2005 VSS.n1990 0.001
R9128 VSS.n2017 VSS.n1991 0.001
R9129 VSS.n2048 VSS.n2041 0.001
R9130 VSS.n2050 VSS.n2042 0.001
R9131 VSS.n2052 VSS.n2043 0.001
R9132 VSS.n2062 VSS.n2044 0.001
R9133 VSS.n2063 VSS.n2040 0.001
R9134 VSS.n2068 VSS.n2067 0.001
R9135 VSS.n2039 VSS.n1570 0.001
R9136 VSS.n1046 VSS.n927 0.001
R9137 VSS.n1034 VSS.n672 0.001
R9138 VSS.n1037 VSS.n1025 0.001
R9139 VSS.n1043 VSS.n1008 0.001
R9140 VSS.n1065 VSS.n908 0.001
R9141 VSS.n1071 VSS.n894 0.001
R9142 VSS.n3401 VSS.n64 0.001
R9143 VSS.n3245 VSS.n3223 0.001
R9144 VSS.n3379 VSS.n3195 0.001
R9145 VSS.n3351 VSS.n3251 0.001
R9146 VSS.n3123 VSS.n2611 0.001
R9147 VSS.n2607 VSS.n2590 0.001
R9148 VSS.n3053 VSS.n3052 0.001
R9149 VSS.n3068 VSS.n2696 0.001
R9150 VSS.n2703 VSS.n2697 0.001
R9151 VSS.n2708 VSS.n2698 0.001
R9152 VSS.n2717 VSS.n2699 0.001
R9153 VSS.n2723 VSS.n2722 0.001
R9154 VSS.n3083 VSS.n2691 0.001
R9155 VSS.n3077 VSS.n2692 0.001
R9156 VSS.n3076 VSS.n2693 0.001
R9157 VSS.n3158 VSS.n3157 0.001
R9158 VSS.n583 VSS.n480 0.001
R9159 VSS.n3151 VSS.n562 0.001
R9160 VSS.n3148 VSS.n563 0.001
R9161 VSS.n3144 VSS.n564 0.001
R9162 VSS.n589 VSS.n565 0.001
R9163 VSS.n594 VSS.n566 0.001
R9164 VSS.n567 VSS.n560 0.001
R9165 VSS.n3161 VSS.n3160 0.001
R9166 VSS.n2314 VSS.n2313 0.001
R9167 VSS.n2316 VSS.n2315 0.001
R9168 VSS.n2318 VSS.n2317 0.001
R9169 VSS.n2320 VSS.n2319 0.001
R9170 VSS.n2322 VSS.n2321 0.001
R9171 VSS.n2324 VSS.n2323 0.001
R9172 VSS.n2407 VSS.n1543 0.001
R9173 VSS.n890 VSS.n889 0.001
R9174 VSS.n2573 VSS.n676 0.001
R9175 VSS.n879 VSS.n861 0.001
R9176 VSS.n876 VSS.n862 0.001
R9177 VSS.n872 VSS.n863 0.001
R9178 VSS.n865 VSS.n864 0.001
R9179 VSS.n2556 VSS.n849 0.001
R9180 VSS.n851 VSS.n850 0.001
R9181 VSS.n866 VSS.n829 0.001
R9182 VSS.n2454 VSS.n2453 0.001
R9183 VSS.n2456 VSS.n2455 0.001
R9184 VSS.n2458 VSS.n2457 0.001
R9185 VSS.n2460 VSS.n2459 0.001
R9186 VSS.n2462 VSS.n2461 0.001
R9187 VSS.n2464 VSS.n2463 0.001
R9188 VSS.n2466 VSS.n2465 0.001
R9189 VSS.n2468 VSS.n2467 0.001
R9190 VSS.n2470 VSS.n2469 0.001
R9191 VSS.n2548 VSS.n852 0.001
R9192 VSS.n1521 VSS.n1520 0.001
R9193 VSS.n1523 VSS.n1522 0.001
R9194 VSS.n1525 VSS.n1524 0.001
R9195 VSS.n1527 VSS.n1526 0.001
R9196 VSS.n1529 VSS.n1528 0.001
R9197 VSS.n1531 VSS.n1530 0.001
R9198 VSS.n1533 VSS.n1532 0.001
R9199 VSS.n1535 VSS.n1534 0.001
R9200 VSS.n1537 VSS.n1536 0.001
R9201 VSS.n2451 VSS.n1420 0.001
R9202 VSS.n2303 VSS.n1557 0.001
R9203 VSS.n2294 VSS.n1560 0.001
R9204 VSS.n2295 VSS.n1561 0.001
R9205 VSS.n2296 VSS.n1562 0.001
R9206 VSS.n2297 VSS.n1563 0.001
R9207 VSS.n2298 VSS.n1564 0.001
R9208 VSS.n2299 VSS.n1565 0.001
R9209 VSS.n2300 VSS.n1566 0.001
R9210 VSS.n3352 VSS.n3351 0.001
R9211 VSS.n3347 VSS.n3247 0.001
R9212 VSS.n3133 VSS.n669 0.001
R9213 VSS.n2582 VSS.n2581 0.001
R9214 VSS.n3102 VSS.n2688 0.001
R9215 VSS.n3098 VSS.n3097 0.001
R9216 VSS.n3440 VSS.n303 0.001
R9217 VSS.n3415 VSS.n3414 0.001
R9218 VSS.n3041 VSS.n2776 0.001
R9219 VSS.n2337 VSS.n2336 0.001
R9220 VSS.n2328 VSS.n2327 0.001
R9221 VSS.n2493 VSS.n2492 0.001
R9222 VSS.n2474 VSS.n2473 0.001
R9223 VSS.n2901 VSS.n2900 0.001
R9224 VSS.n2876 VSS.n2875 0.001
R9225 VSS.n2927 VSS.n2926 0.001
R9226 VSS.n2905 VSS.n2863 0.001
R9227 VSS.n2921 VSS.n2864 0.001
R9228 VSS.n2907 VSS.n2865 0.001
R9229 VSS.n2908 VSS.n2866 0.001
R9230 VSS.n2909 VSS.n2867 0.001
R9231 VSS.n2910 VSS.n2868 0.001
R9232 VSS.n2913 VSS.n2869 0.001
R9233 VSS.n3030 VSS.n2933 0.001
R9234 VSS.n3034 VSS.n2970 0.001
R9235 VSS.n3036 VSS.n3034 0.001
R9236 VSS.n3032 VSS.n2973 0.001
R9237 VSS.n3441 VSS.n3440 0.001
R9238 VSS.n302 VSS.n301 0.001
R9239 VSS.n333 VSS.n300 0.001
R9240 VSS.n336 VSS.n299 0.001
R9241 VSS.n338 VSS.n298 0.001
R9242 VSS.n3430 VSS.n395 0.001
R9243 VSS.n397 VSS.n396 0.001
R9244 VSS.n2870 VSS.n398 0.001
R9245 VSS.n2871 VSS.n399 0.001
R9246 VSS.n3423 VSS.n401 0.001
R9247 VSS.n403 VSS.n402 0.001
R9248 VSS.n3179 VSS.n3178 0.001
R9249 VSS.n3173 VSS.n421 0.001
R9250 VSS.n3170 VSS.n422 0.001
R9251 VSS.n436 VSS.n423 0.001
R9252 VSS.n452 VSS.n424 0.001
R9253 VSS.n450 VSS.n425 0.001
R9254 VSS.n455 VSS.n426 0.001
R9255 VSS.n463 VSS.n427 0.001
R9256 VSS.n461 VSS.n428 0.001
R9257 VSS.n429 VSS.n420 0.001
R9258 VSS.n3182 VSS.n3181 0.001
R9259 VSS.n3572 VSS.n188 0.001
R9260 VSS.n3616 VSS.n33 0.001
R9261 VSS.n31 VSS.n24 0.001
R9262 VSS.n145 VSS.n25 0.001
R9263 VSS.n3589 VSS.n26 0.001
R9264 VSS.n122 VSS.n27 0.001
R9265 VSS.n127 VSS.n28 0.001
R9266 VSS.n129 VSS.n29 0.001
R9267 VSS.n3619 VSS.n23 0.001
R9268 VSS.n3581 VSS.n33 0.001
R9269 VSS.n3578 VSS.n198 0.001
R9270 VSS.n198 VSS.n190 0.001
R9271 VSS.n3581 VSS.n188 0.001
R9272 VSS.n3578 VSS.n238 0.001
R9273 VSS.n3576 VSS.n241 0.001
R9274 VSS.n3468 VSS.n247 0.001
R9275 VSS.n3494 VSS.n250 0.001
R9276 VSS.n3491 VSS.n251 0.001
R9277 VSS.n3443 VSS.n253 0.001
R9278 VSS.n3448 VSS.n3444 0.001
R9279 VSS.n3453 VSS.n3445 0.001
R9280 VSS.n3457 VSS.n3454 0.001
R9281 VSS.n3461 VSS.n3455 0.001
R9282 VSS.n3466 VSS.n3456 0.001
R9283 VSS.n3467 VSS.n295 0.001
R9284 VSS.n3471 VSS.n3470 0.001
R9285 VSS.n3479 VSS.n3478 0.001
R9286 VSS.n282 VSS.n274 0.001
R9287 VSS.n275 VSS.n266 0.001
R9288 VSS.n3057 VSS.n2758 0.001
R9289 VSS.n276 VSS.n267 0.001
R9290 VSS.n277 VSS.n268 0.001
R9291 VSS.n278 VSS.n269 0.001
R9292 VSS.n279 VSS.n270 0.001
R9293 VSS.n280 VSS.n271 0.001
R9294 VSS.n281 VSS.n272 0.001
R9295 VSS.n3482 VSS.n3481 0.001
R9296 VSS.n2773 VSS.n2772 0.001
R9297 VSS.n2771 VSS.n2770 0.001
R9298 VSS.n2769 VSS.n2768 0.001
R9299 VSS.n2767 VSS.n2766 0.001
R9300 VSS.n2765 VSS.n2764 0.001
R9301 VSS.n2763 VSS.n2762 0.001
R9302 VSS.n3620 VSS.n22 0.001
R9303 VSS.n3062 VSS.n2725 0.001
R9304 VSS.n3620 VSS.n3619 0.001
R9305 VSS.n29 VSS.n23 0.001
R9306 VSS.n129 VSS.n28 0.001
R9307 VSS.n127 VSS.n27 0.001
R9308 VSS.n122 VSS.n26 0.001
R9309 VSS.n3589 VSS.n25 0.001
R9310 VSS.n145 VSS.n24 0.001
R9311 VSS.n3607 VSS.n42 0.001
R9312 VSS.n3611 VSS.n41 0.001
R9313 VSS.n42 VSS.n1 0.001
R9314 VSS.n3607 VSS.n41 0.001
R9315 VSS.n3402 VSS.n3194 0.001
R9316 VSS.n3194 VSS.n3192 0.001
R9317 VSS.n3402 VSS.n3401 0.001
R9318 VSS.n3192 VSS.n3191 0.001
R9319 VSS.n1404 VSS.n1403 0.000958095
R9320 VSS.n3088 VSS.n3086 0.00095082
R9321 VSS.n120 VSS.n119 0.00095082
R9322 VSS.n1639 VSS.n1617 0.000927092
R9323 VSS.n1357 VSS.n1356 0.000911985
R9324 VSS.n1638 VSS.n1637 0.000879638
R9325 VSS.n1868 VSS.n1867 0.000879638
R9326 VSS.n1365 VSS.n1358 0.000843321
R9327 VSS.n1160 VSS.n1159 0.00081494
R9328 VSS.n1382 VSS.n1160 0.00081494
R9329 VSS.n1375 VSS.n1254 0.00081494
R9330 VSS.n1635 VSS.n1613 0.000808456
R9331 VSS.n1865 VSS.n1653 0.000808456
R9332 VSS.n2376 VSS.n2375 0.000806407
R9333 VSS.n2851 VSS.n2850 0.000794118
R9334 VSS.n2778 VSS.n2777 0.000794118
R9335 VSS.n1627 VSS.n1626 0.000737274
R9336 VSS.n1605 VSS.n1604 0.000737274
R9337 VSS.n1728 VSS.n1645 0.000737274
R9338 VSS.n2715 VSS.n472 0.00072541
R9339 VSS.n3588 VSS.n3587 0.00072541
R9340 VSS.n468 VSS.n467 0.000710728
R9341 VSS.n166 VSS.n155 0.000710728
R9342 VSS.n35 VSS.n34 0.000710728
R9343 VSS.n3473 VSS.n3472 0.000710728
R9344 VSS.n1627 VSS.n1616 0.000689819
R9345 VSS.n1625 VSS.n1615 0.000689819
R9346 VSS.n1629 VSS.n1614 0.000689819
R9347 VSS.n1623 VSS.n1613 0.000689819
R9348 VSS.n1634 VSS.n1612 0.000689819
R9349 VSS.n1630 VSS.n1611 0.000689819
R9350 VSS.n1622 VSS.n1610 0.000689819
R9351 VSS.n1631 VSS.n1609 0.000689819
R9352 VSS.n1621 VSS.n1608 0.000689819
R9353 VSS.n1633 VSS.n1632 0.000689819
R9354 VSS.n3565 VSS.n234 0.000682119
R9355 VSS.n2274 VSS.n2272 0.000653417
R9356 VSS.n2277 VSS.n2276 0.000653417
R9357 VSS.n3167 VSS.n3166 0.000612705
R9358 VSS.n125 VSS.n114 0.000612705
R9359 VSS.n1856 VSS.n1647 0.000594909
R9360 VSS.n1852 VSS.n1725 0.000594909
R9361 VSS.n1855 VSS.n1649 0.000594909
R9362 VSS.n1853 VSS.n1722 0.000594909
R9363 VSS.n1854 VSS.n1651 0.000594909
R9364 VSS.n1864 VSS.n1720 0.000594909
R9365 VSS.n1857 VSS.n1653 0.000594909
R9366 VSS.n1861 VSS.n1718 0.000594909
R9367 VSS.n1858 VSS.n1655 0.000594909
R9368 VSS.n1860 VSS.n1716 0.000594909
R9369 VSS.n1640 VSS.n1638 0.000547455
R9370 VSS.n1867 VSS.n1714 0.000547455
R9371 VSS.n2391 VSS.n2390 0.000542406
R9372 dw_n7292_5488.n13 dw_n7292_5488.t8 24.5358
R9373 dw_n7292_5488.t4 dw_n7292_5488.n9 17.0005
R9374 dw_n7292_5488.t4 dw_n7292_5488.n10 17.0005
R9375 dw_n7292_5488.t4 dw_n7292_5488.n11 17.0005
R9376 dw_n7292_5488.t4 dw_n7292_5488.n12 17.0005
R9377 dw_n7292_5488.t4 dw_n7292_5488.n8 17.0005
R9378 dw_n7292_5488.n15 dw_n7292_5488.n4 17.0005
R9379 dw_n7292_5488.n15 dw_n7292_5488.n5 17.0005
R9380 dw_n7292_5488.n15 dw_n7292_5488.n6 17.0005
R9381 dw_n7292_5488.n15 dw_n7292_5488.n7 17.0005
R9382 dw_n7292_5488.n15 dw_n7292_5488.n14 17.0005
R9383 dw_n7292_5488.n16 dw_n7292_5488.n15 17.0005
R9384 dw_n7292_5488.n18 dw_n7292_5488.n17 9.59883
R9385 dw_n7292_5488.n21 dw_n7292_5488.n20 5.63337
R9386 dw_n7292_5488.n13 dw_n7292_5488.t4 5.5825
R9387 dw_n7292_5488.n18 dw_n7292_5488.n0 4.83039
R9388 dw_n7292_5488.t2 dw_n7292_5488.n23 4.0459
R9389 dw_n7292_5488.n20 dw_n7292_5488.t6 3.74819
R9390 dw_n7292_5488.n16 dw_n7292_5488.t5 3.5691
R9391 dw_n7292_5488.n2 dw_n7292_5488.t7 2.5268
R9392 dw_n7292_5488.n1 dw_n7292_5488.t1 2.3576
R9393 dw_n7292_5488.n23 dw_n7292_5488.n22 2.29498
R9394 dw_n7292_5488.n19 dw_n7292_5488.n18 1.8005
R9395 dw_n7292_5488.n22 dw_n7292_5488.n1 1.29902
R9396 dw_n7292_5488.n15 dw_n7292_5488.n3 1.08722
R9397 dw_n7292_5488.n15 dw_n7292_5488.t3 0.895237
R9398 dw_n7292_5488.t0 dw_n7292_5488.n21 0.895237
R9399 dw_n7292_5488.n22 dw_n7292_5488.t0 0.895237
R9400 dw_n7292_5488.n21 dw_n7292_5488.n2 0.866995
R9401 dw_n7292_5488.n19 dw_n7292_5488.n2 0.68152
R9402 dw_n7292_5488.n17 dw_n7292_5488.n3 0.63225
R9403 dw_n7292_5488.n9 dw_n7292_5488.n3 0.630731
R9404 dw_n7292_5488.n1 dw_n7292_5488.n0 0.435339
R9405 dw_n7292_5488.n23 dw_n7292_5488.n0 0.372782
R9406 dw_n7292_5488.n14 dw_n7292_5488.n13 0.213093
R9407 dw_n7292_5488.n20 dw_n7292_5488.n19 0.145463
R9408 dw_n7292_5488.n17 dw_n7292_5488.n16 0.0588673
R9409 dw_n7292_5488.n8 dw_n7292_5488.n7 0.0230746
R9410 dw_n7292_5488.n9 dw_n7292_5488.n4 0.0210224
R9411 dw_n7292_5488.n12 dw_n7292_5488.n6 0.0193806
R9412 dw_n7292_5488.n14 dw_n7292_5488.n8 0.0189701
R9413 dw_n7292_5488.n10 dw_n7292_5488.n5 0.0169179
R9414 dw_n7292_5488.n11 dw_n7292_5488.n5 0.0156866
R9415 dw_n7292_5488.n11 dw_n7292_5488.n6 0.0132239
R9416 dw_n7292_5488.n10 dw_n7292_5488.n4 0.0119925
R9417 dw_n7292_5488.n12 dw_n7292_5488.n7 0.00952985
R9418 a_n1031_4249.t0 a_n1031_4249.t1 30.5928
R9419 VDD.n431 VDD.n430 20.1019
R9420 VDD.n421 VDD.t35 18.5233
R9421 VDD.n427 VDD.t30 18.5199
R9422 VDD.n318 VDD.t53 17.7293
R9423 VDD.n502 VDD.t84 17.7108
R9424 VDD.n824 VDD.t85 17.7108
R9425 VDD.n127 VDD.t51 17.5141
R9426 VDD.n63 VDD.t104 17.5129
R9427 VDD.n676 VDD.n675 17.2478
R9428 VDD.n424 VDD.t31 17.2308
R9429 VDD.n423 VDD.t32 17.2308
R9430 VDD.n422 VDD.t36 17.2308
R9431 VDD.n421 VDD.t34 17.2308
R9432 VDD.n427 VDD.t33 17.2274
R9433 VDD.n428 VDD.t37 17.2274
R9434 VDD.n429 VDD.t39 17.2274
R9435 VDD.n92 VDD.t198 17.0005
R9436 VDD.n89 VDD.t198 17.0005
R9437 VDD.n93 VDD.t198 17.0005
R9438 VDD.t199 VDD.n92 17.0005
R9439 VDD.t199 VDD.n89 17.0005
R9440 VDD.n93 VDD.t199 17.0005
R9441 VDD.n81 VDD.t210 17.0005
R9442 VDD.t211 VDD.n81 17.0005
R9443 VDD.t211 VDD.n80 17.0005
R9444 VDD.n82 VDD.t211 17.0005
R9445 VDD.n74 VDD.t111 17.0005
R9446 VDD.n73 VDD.t111 17.0005
R9447 VDD.n75 VDD.t111 17.0005
R9448 VDD.t112 VDD.n74 17.0005
R9449 VDD.t112 VDD.n73 17.0005
R9450 VDD.n75 VDD.t112 17.0005
R9451 VDD.n435 VDD.n88 17.0005
R9452 VDD.n435 VDD.n87 17.0005
R9453 VDD.n435 VDD.n86 17.0005
R9454 VDD.n435 VDD.n78 17.0005
R9455 VDD.n435 VDD.n76 17.0005
R9456 VDD.n435 VDD.n72 17.0005
R9457 VDD.n435 VDD.n71 17.0005
R9458 VDD.n291 VDD.t196 17.0005
R9459 VDD.n287 VDD.t196 17.0005
R9460 VDD.n286 VDD.t196 17.0005
R9461 VDD.n292 VDD.t196 17.0005
R9462 VDD.n285 VDD.t196 17.0005
R9463 VDD.n293 VDD.t196 17.0005
R9464 VDD.n289 VDD.t196 17.0005
R9465 VDD.t178 VDD.n291 17.0005
R9466 VDD.t178 VDD.n289 17.0005
R9467 VDD.n291 VDD.n290 17.0005
R9468 VDD.n290 VDD.n289 17.0005
R9469 VDD.n264 VDD.t136 17.0005
R9470 VDD.n260 VDD.t136 17.0005
R9471 VDD.n259 VDD.t136 17.0005
R9472 VDD.n265 VDD.t136 17.0005
R9473 VDD.n258 VDD.t136 17.0005
R9474 VDD.n266 VDD.t136 17.0005
R9475 VDD.n262 VDD.t136 17.0005
R9476 VDD.t124 VDD.n264 17.0005
R9477 VDD.t124 VDD.n262 17.0005
R9478 VDD.n264 VDD.n263 17.0005
R9479 VDD.n263 VDD.n262 17.0005
R9480 VDD.n425 VDD.t38 17.0005
R9481 VDD.n426 VDD.t40 17.0005
R9482 VDD.n433 VDD.n166 17.0005
R9483 VDD.n433 VDD.n165 17.0005
R9484 VDD.n433 VDD.n163 17.0005
R9485 VDD.n433 VDD.n162 17.0005
R9486 VDD.n433 VDD.n160 17.0005
R9487 VDD.n433 VDD.n159 17.0005
R9488 VDD.n433 VDD.n150 17.0005
R9489 VDD.n433 VDD.n149 17.0005
R9490 VDD.n433 VDD.n147 17.0005
R9491 VDD.n433 VDD.n146 17.0005
R9492 VDD.n433 VDD.n169 17.0005
R9493 VDD.n401 VDD.n252 17.0005
R9494 VDD.n401 VDD.n254 17.0005
R9495 VDD.n401 VDD.n255 17.0005
R9496 VDD.n401 VDD.n256 17.0005
R9497 VDD.n401 VDD.n257 17.0005
R9498 VDD.n401 VDD.n267 17.0005
R9499 VDD.n401 VDD.n268 17.0005
R9500 VDD.n401 VDD.n278 17.0005
R9501 VDD.n401 VDD.n279 17.0005
R9502 VDD.n401 VDD.n280 17.0005
R9503 VDD.n401 VDD.n281 17.0005
R9504 VDD.n401 VDD.n282 17.0005
R9505 VDD.n401 VDD.n284 17.0005
R9506 VDD.n394 VDD.n316 17.0005
R9507 VDD.n394 VDD.n344 17.0005
R9508 VDD.n341 VDD.n317 17.0005
R9509 VDD.n341 VDD.n340 17.0005
R9510 VDD.n337 VDD.n319 17.0005
R9511 VDD.n337 VDD.n336 17.0005
R9512 VDD.n418 VDD.n207 17.0005
R9513 VDD.n418 VDD.n202 17.0005
R9514 VDD.n418 VDD.n208 17.0005
R9515 VDD.n418 VDD.n201 17.0005
R9516 VDD.n418 VDD.n209 17.0005
R9517 VDD.n419 VDD.n418 17.0005
R9518 VDD.n418 VDD.n186 17.0005
R9519 VDD.t47 VDD.n139 17.0005
R9520 VDD.n418 VDD.n417 17.0005
R9521 VDD.n101 VDD.t180 17.0005
R9522 VDD.n99 VDD.t180 17.0005
R9523 VDD.n100 VDD.t180 17.0005
R9524 VDD.n101 VDD.t181 17.0005
R9525 VDD.t181 VDD.n99 17.0005
R9526 VDD.t181 VDD.n100 17.0005
R9527 VDD.n111 VDD.t192 17.0005
R9528 VDD.n111 VDD.t193 17.0005
R9529 VDD.t193 VDD.n108 17.0005
R9530 VDD.t193 VDD.n110 17.0005
R9531 VDD.n120 VDD.t213 17.0005
R9532 VDD.n118 VDD.t213 17.0005
R9533 VDD.n119 VDD.t213 17.0005
R9534 VDD.n120 VDD.t214 17.0005
R9535 VDD.t214 VDD.n118 17.0005
R9536 VDD.t214 VDD.n119 17.0005
R9537 VDD.n435 VDD.n117 17.0005
R9538 VDD.n435 VDD.n116 17.0005
R9539 VDD.n435 VDD.n115 17.0005
R9540 VDD.n435 VDD.n107 17.0005
R9541 VDD.n435 VDD.n106 17.0005
R9542 VDD.n435 VDD.n103 17.0005
R9543 VDD.n435 VDD.n102 17.0005
R9544 VDD.n435 VDD.n98 17.0005
R9545 VDD.n435 VDD.n97 17.0005
R9546 VDD.n662 VDD.t150 17.0005
R9547 VDD.n454 VDD.t150 17.0005
R9548 VDD.n661 VDD.t150 17.0005
R9549 VDD.n662 VDD.t151 17.0005
R9550 VDD.t151 VDD.n454 17.0005
R9551 VDD.t151 VDD.n661 17.0005
R9552 VDD.n450 VDD.t170 17.0005
R9553 VDD.t171 VDD.n450 17.0005
R9554 VDD.t171 VDD.n448 17.0005
R9555 VDD.n451 VDD.t171 17.0005
R9556 VDD.n668 VDD.t183 17.0005
R9557 VDD.n444 VDD.t183 17.0005
R9558 VDD.n667 VDD.t183 17.0005
R9559 VDD.n668 VDD.t184 17.0005
R9560 VDD.t184 VDD.n444 17.0005
R9561 VDD.t184 VDD.n667 17.0005
R9562 VDD.n455 VDD.n442 17.0005
R9563 VDD.n453 VDD.n442 17.0005
R9564 VDD.n663 VDD.n442 17.0005
R9565 VDD.n449 VDD.n442 17.0005
R9566 VDD.n666 VDD.n442 17.0005
R9567 VDD.n445 VDD.n442 17.0005
R9568 VDD.n443 VDD.n442 17.0005
R9569 VDD.n654 VDD.n537 17.0005
R9570 VDD.n654 VDD.t5 17.0005
R9571 VDD.n584 VDD.t217 17.0005
R9572 VDD.n582 VDD.t217 17.0005
R9573 VDD.t217 VDD.n581 17.0005
R9574 VDD.t217 VDD.n578 17.0005
R9575 VDD.t217 VDD.n580 17.0005
R9576 VDD.t217 VDD.n579 17.0005
R9577 VDD.n586 VDD.t217 17.0005
R9578 VDD.n584 VDD.t114 17.0005
R9579 VDD.n586 VDD.t114 17.0005
R9580 VDD.n585 VDD.n584 17.0005
R9581 VDD.n586 VDD.n585 17.0005
R9582 VDD.n610 VDD.t154 17.0005
R9583 VDD.n608 VDD.t154 17.0005
R9584 VDD.t154 VDD.n607 17.0005
R9585 VDD.t154 VDD.n604 17.0005
R9586 VDD.t154 VDD.n606 17.0005
R9587 VDD.t154 VDD.n605 17.0005
R9588 VDD.n612 VDD.t154 17.0005
R9589 VDD.n610 VDD.t153 17.0005
R9590 VDD.n612 VDD.t153 17.0005
R9591 VDD.n611 VDD.n610 17.0005
R9592 VDD.n612 VDD.n611 17.0005
R9593 VDD.n654 VDD.n572 17.0005
R9594 VDD.n654 VDD.n574 17.0005
R9595 VDD.n654 VDD.n575 17.0005
R9596 VDD.n654 VDD.n576 17.0005
R9597 VDD.n654 VDD.n577 17.0005
R9598 VDD.n654 VDD.n587 17.0005
R9599 VDD.n654 VDD.n588 17.0005
R9600 VDD.n654 VDD.n597 17.0005
R9601 VDD.n654 VDD.n598 17.0005
R9602 VDD.n654 VDD.n599 17.0005
R9603 VDD.n654 VDD.n600 17.0005
R9604 VDD.n654 VDD.n601 17.0005
R9605 VDD.n654 VDD.n603 17.0005
R9606 VDD.n654 VDD.n523 17.0005
R9607 VDD.n480 VDD.t165 17.0005
R9608 VDD.n458 VDD.t165 17.0005
R9609 VDD.n481 VDD.t165 17.0005
R9610 VDD.t166 VDD.n480 17.0005
R9611 VDD.t166 VDD.n458 17.0005
R9612 VDD.n481 VDD.t166 17.0005
R9613 VDD.n474 VDD.t186 17.0005
R9614 VDD.n474 VDD.t187 17.0005
R9615 VDD.t187 VDD.n471 17.0005
R9616 VDD.t187 VDD.n473 17.0005
R9617 VDD.n467 VDD.t204 17.0005
R9618 VDD.n461 VDD.t204 17.0005
R9619 VDD.n468 VDD.t204 17.0005
R9620 VDD.t205 VDD.n467 17.0005
R9621 VDD.t205 VDD.n461 17.0005
R9622 VDD.n468 VDD.t205 17.0005
R9623 VDD.n466 VDD.n442 17.0005
R9624 VDD.n460 VDD.n442 17.0005
R9625 VDD.n469 VDD.n442 17.0005
R9626 VDD.n470 VDD.n442 17.0005
R9627 VDD.n478 VDD.n442 17.0005
R9628 VDD.n479 VDD.n442 17.0005
R9629 VDD.n457 VDD.n442 17.0005
R9630 VDD.n442 VDD.n441 17.0005
R9631 VDD.n26 VDD.t116 17.0005
R9632 VDD.n25 VDD.t116 17.0005
R9633 VDD.n27 VDD.t116 17.0005
R9634 VDD.t117 VDD.n26 17.0005
R9635 VDD.t117 VDD.n25 17.0005
R9636 VDD.n27 VDD.t117 17.0005
R9637 VDD.n17 VDD.t129 17.0005
R9638 VDD.t130 VDD.n17 17.0005
R9639 VDD.t130 VDD.n16 17.0005
R9640 VDD.n18 VDD.t130 17.0005
R9641 VDD.n10 VDD.t144 17.0005
R9642 VDD.n9 VDD.t144 17.0005
R9643 VDD.n11 VDD.t144 17.0005
R9644 VDD.t145 VDD.n10 17.0005
R9645 VDD.t145 VDD.n9 17.0005
R9646 VDD.n11 VDD.t145 17.0005
R9647 VDD.n852 VDD.n24 17.0005
R9648 VDD.n852 VDD.n23 17.0005
R9649 VDD.n852 VDD.n22 17.0005
R9650 VDD.n852 VDD.n14 17.0005
R9651 VDD.n852 VDD.n12 17.0005
R9652 VDD.n852 VDD.n8 17.0005
R9653 VDD.n852 VDD.n7 17.0005
R9654 VDD.n759 VDD.n684 17.0005
R9655 VDD.t63 VDD.n684 17.0005
R9656 VDD.n811 VDD.t133 17.0005
R9657 VDD.t133 VDD.n743 17.0005
R9658 VDD.t133 VDD.n810 17.0005
R9659 VDD.t133 VDD.n744 17.0005
R9660 VDD.t133 VDD.n807 17.0005
R9661 VDD.t133 VDD.n745 17.0005
R9662 VDD.t133 VDD.n804 17.0005
R9663 VDD.n828 VDD.t190 17.0005
R9664 VDD.t190 VDD.n734 17.0005
R9665 VDD.t190 VDD.n827 17.0005
R9666 VDD.t190 VDD.n735 17.0005
R9667 VDD.t190 VDD.n822 17.0005
R9668 VDD.t190 VDD.n736 17.0005
R9669 VDD.t190 VDD.n819 17.0005
R9670 VDD.n746 VDD.n684 17.0005
R9671 VDD.n805 VDD.n684 17.0005
R9672 VDD.n809 VDD.n684 17.0005
R9673 VDD.n808 VDD.n684 17.0005
R9674 VDD.n742 VDD.n684 17.0005
R9675 VDD.n812 VDD.n684 17.0005
R9676 VDD.n741 VDD.n684 17.0005
R9677 VDD.n818 VDD.n684 17.0005
R9678 VDD.n737 VDD.n684 17.0005
R9679 VDD.n821 VDD.n684 17.0005
R9680 VDD.n820 VDD.n684 17.0005
R9681 VDD.n826 VDD.n684 17.0005
R9682 VDD.n825 VDD.n684 17.0005
R9683 VDD.n823 VDD.n684 17.0005
R9684 VDD.n733 VDD.n684 17.0005
R9685 VDD.n723 VDD.n684 17.0005
R9686 VDD.n35 VDD.t126 17.0005
R9687 VDD.n33 VDD.t126 17.0005
R9688 VDD.n34 VDD.t126 17.0005
R9689 VDD.n35 VDD.t127 17.0005
R9690 VDD.t127 VDD.n33 17.0005
R9691 VDD.t127 VDD.n34 17.0005
R9692 VDD.n42 VDD.t147 17.0005
R9693 VDD.n42 VDD.t148 17.0005
R9694 VDD.t148 VDD.n39 17.0005
R9695 VDD.t148 VDD.n41 17.0005
R9696 VDD.n51 VDD.t162 17.0005
R9697 VDD.n49 VDD.t162 17.0005
R9698 VDD.n50 VDD.t162 17.0005
R9699 VDD.n51 VDD.t163 17.0005
R9700 VDD.t163 VDD.n49 17.0005
R9701 VDD.t163 VDD.n50 17.0005
R9702 VDD.n852 VDD.n48 17.0005
R9703 VDD.n852 VDD.n47 17.0005
R9704 VDD.n852 VDD.n46 17.0005
R9705 VDD.n852 VDD.n38 17.0005
R9706 VDD.n852 VDD.n36 17.0005
R9707 VDD.n852 VDD.n32 17.0005
R9708 VDD.n852 VDD.n31 17.0005
R9709 VDD.n852 VDD.n1 17.0005
R9710 VDD.n104 VDD.t46 15.5428
R9711 VDD.n90 VDD.t44 15.5126
R9712 VDD.n228 VDD.t29 15.1459
R9713 VDD.n403 VDD.t107 15.093
R9714 VDD.n128 VDD.t45 15.0005
R9715 VDD.n131 VDD.t2 15.0005
R9716 VDD.n104 VDD.t3 15.0005
R9717 VDD.n90 VDD.t106 15.0005
R9718 VDD.t110 VDD.n84 15.0005
R9719 VDD.n85 VDD.t110 15.0005
R9720 VDD.n114 VDD.t179 15.0005
R9721 VDD.t179 VDD.n113 15.0005
R9722 VDD.n64 VDD.t43 15.0005
R9723 VDD.n67 VDD.t105 15.0005
R9724 VDD.n665 VDD.t149 15.0005
R9725 VDD.t149 VDD.n664 15.0005
R9726 VDD.t164 VDD.n476 15.0005
R9727 VDD.n477 VDD.t164 15.0005
R9728 VDD.t115 VDD.n20 15.0005
R9729 VDD.n21 VDD.t115 15.0005
R9730 VDD.n45 VDD.t125 15.0005
R9731 VDD.t125 VDD.n44 15.0005
R9732 VDD.n53 VDD.t92 10.9543
R9733 VDD.n462 VDD.t88 10.9543
R9734 VDD.n2 VDD.t98 10.9543
R9735 VDD.n53 VDD.t94 10.2126
R9736 VDD.n462 VDD.t86 10.2126
R9737 VDD.n2 VDD.t100 10.2126
R9738 VDD.n288 VDD.n287 8.501
R9739 VDD.n261 VDD.n260 8.501
R9740 VDD.n352 VDD.n250 8.501
R9741 VDD.n352 VDD.n351 8.501
R9742 VDD.n352 VDD.n350 8.501
R9743 VDD.n352 VDD.n349 8.501
R9744 VDD.n352 VDD.n348 8.501
R9745 VDD.n352 VDD.n347 8.501
R9746 VDD.n343 VDD.n342 8.501
R9747 VDD.n339 VDD.n338 8.501
R9748 VDD.n335 VDD.t52 8.501
R9749 VDD.n323 VDD.n322 8.501
R9750 VDD.n324 VDD.t48 8.501
R9751 VDD.n326 VDD.t49 8.501
R9752 VDD.n205 VDD.n204 8.501
R9753 VDD.t108 VDD.n309 8.501
R9754 VDD.t108 VDD.n310 8.501
R9755 VDD.t108 VDD.n311 8.501
R9756 VDD.t108 VDD.n300 8.501
R9757 VDD.n396 VDD.t108 8.501
R9758 VDD.n583 VDD.n582 8.501
R9759 VDD.n609 VDD.n608 8.501
R9760 VDD.n631 VDD.n570 8.501
R9761 VDD.n631 VDD.n630 8.501
R9762 VDD.n631 VDD.n629 8.501
R9763 VDD.n631 VDD.n628 8.501
R9764 VDD.n631 VDD.n627 8.501
R9765 VDD.n632 VDD.n631 8.501
R9766 VDD.n631 VDD.n615 8.501
R9767 VDD.n653 VDD.n652 8.501
R9768 VDD.n652 VDD.n651 8.501
R9769 VDD.n652 VDD.n649 8.501
R9770 VDD.n652 VDD.n647 8.501
R9771 VDD.n652 VDD.n645 8.501
R9772 VDD.n652 VDD.n643 8.501
R9773 VDD.n652 VDD.n641 8.501
R9774 VDD.n652 VDD.n639 8.501
R9775 VDD.n652 VDD.n487 8.501
R9776 VDD.n802 VDD.n754 8.501
R9777 VDD.n802 VDD.n753 8.501
R9778 VDD.n802 VDD.n752 8.501
R9779 VDD.n802 VDD.n751 8.501
R9780 VDD.n802 VDD.n750 8.501
R9781 VDD.n802 VDD.n749 8.501
R9782 VDD.n802 VDD.n748 8.501
R9783 VDD.n830 VDD.n732 8.501
R9784 VDD.n830 VDD.n731 8.501
R9785 VDD.n830 VDD.n730 8.501
R9786 VDD.n830 VDD.n729 8.501
R9787 VDD.n830 VDD.n728 8.501
R9788 VDD.n830 VDD.n727 8.501
R9789 VDD.n830 VDD.n726 8.501
R9790 VDD.n830 VDD.n725 8.501
R9791 VDD.n830 VDD.n724 8.501
R9792 VDD.n373 VDD.n363 8.50079
R9793 VDD.t178 VDD.n286 8.5005
R9794 VDD.t178 VDD.n292 8.5005
R9795 VDD.t178 VDD.n285 8.5005
R9796 VDD.n293 VDD.t178 8.5005
R9797 VDD.t124 VDD.n259 8.5005
R9798 VDD.t124 VDD.n265 8.5005
R9799 VDD.t124 VDD.n258 8.5005
R9800 VDD.n266 VDD.t124 8.5005
R9801 VDD.n342 VDD.n139 8.5005
R9802 VDD.n338 VDD.n139 8.5005
R9803 VDD.t52 VDD.n139 8.5005
R9804 VDD.n322 VDD.n139 8.5005
R9805 VDD.t48 VDD.n139 8.5005
R9806 VDD.t54 VDD.n139 8.5005
R9807 VDD.t49 VDD.n139 8.5005
R9808 VDD.n204 VDD.n139 8.5005
R9809 VDD.t54 VDD.n138 8.5005
R9810 VDD.n418 VDD.n174 8.5005
R9811 VDD.n418 VDD.n213 8.5005
R9812 VDD.n418 VDD.n214 8.5005
R9813 VDD.n418 VDD.n215 8.5005
R9814 VDD.n418 VDD.n216 8.5005
R9815 VDD.n418 VDD.n217 8.5005
R9816 VDD.n418 VDD.n218 8.5005
R9817 VDD.n418 VDD.n221 8.5005
R9818 VDD.n418 VDD.n222 8.5005
R9819 VDD.n418 VDD.n223 8.5005
R9820 VDD.n418 VDD.n224 8.5005
R9821 VDD.n654 VDD.t14 8.5005
R9822 VDD.n654 VDD.t9 8.5005
R9823 VDD.n654 VDD.t16 8.5005
R9824 VDD.n654 VDD.t8 8.5005
R9825 VDD.n654 VDD.t11 8.5005
R9826 VDD.n581 VDD.t114 8.5005
R9827 VDD.n578 VDD.t114 8.5005
R9828 VDD.n580 VDD.t114 8.5005
R9829 VDD.n579 VDD.t114 8.5005
R9830 VDD.n607 VDD.t153 8.5005
R9831 VDD.n604 VDD.t153 8.5005
R9832 VDD.n606 VDD.t153 8.5005
R9833 VDD.n605 VDD.t153 8.5005
R9834 VDD.n635 VDD.n618 8.5005
R9835 VDD.n635 VDD.n620 8.5005
R9836 VDD.n635 VDD.n622 8.5005
R9837 VDD.n635 VDD.n624 8.5005
R9838 VDD.n635 VDD.n626 8.5005
R9839 VDD.n635 VDD.n634 8.5005
R9840 VDD.n636 VDD.n635 8.5005
R9841 VDD.n614 VDD.n568 8.5005
R9842 VDD.n650 VDD.t14 8.5005
R9843 VDD.n648 VDD.t9 8.5005
R9844 VDD.n646 VDD.t16 8.5005
R9845 VDD.n644 VDD.t5 8.5005
R9846 VDD.n642 VDD.t8 8.5005
R9847 VDD.n640 VDD.t11 8.5005
R9848 VDD.n638 VDD.t0 8.5005
R9849 VDD.n654 VDD.n521 8.5005
R9850 VDD.t64 VDD.n684 8.5005
R9851 VDD.t68 VDD.n684 8.5005
R9852 VDD.t58 VDD.n684 8.5005
R9853 VDD.t61 VDD.n684 8.5005
R9854 VDD.t66 VDD.n684 8.5005
R9855 VDD.n811 VDD.t132 8.5005
R9856 VDD.n743 VDD.t132 8.5005
R9857 VDD.n810 VDD.t132 8.5005
R9858 VDD.n744 VDD.t132 8.5005
R9859 VDD.n807 VDD.t132 8.5005
R9860 VDD.n745 VDD.t132 8.5005
R9861 VDD.n804 VDD.t132 8.5005
R9862 VDD.n828 VDD.t160 8.5005
R9863 VDD.n734 VDD.t160 8.5005
R9864 VDD.n827 VDD.t160 8.5005
R9865 VDD.n735 VDD.t160 8.5005
R9866 VDD.n822 VDD.t160 8.5005
R9867 VDD.n736 VDD.t160 8.5005
R9868 VDD.n819 VDD.t160 8.5005
R9869 VDD.n800 VDD.n779 8.5005
R9870 VDD.n800 VDD.n780 8.5005
R9871 VDD.n800 VDD.n781 8.5005
R9872 VDD.n800 VDD.n782 8.5005
R9873 VDD.n800 VDD.n783 8.5005
R9874 VDD.n800 VDD.n798 8.5005
R9875 VDD.n800 VDD.n799 8.5005
R9876 VDD.n785 VDD.n784 8.5005
R9877 VDD.t64 VDD.n787 8.5005
R9878 VDD.t68 VDD.n789 8.5005
R9879 VDD.t58 VDD.n791 8.5005
R9880 VDD.t63 VDD.n793 8.5005
R9881 VDD.t61 VDD.n795 8.5005
R9882 VDD.t66 VDD.n796 8.5005
R9883 VDD.t55 VDD.n682 8.5005
R9884 VDD.n699 VDD.n684 8.5005
R9885 VDD.n380 VDD.n363 8.50037
R9886 VDD.n385 VDD.n363 8.49972
R9887 VDD.n401 VDD.n253 8.49947
R9888 VDD.n401 VDD.n283 8.49947
R9889 VDD.n401 VDD.n294 8.49947
R9890 VDD.n654 VDD.n573 8.49947
R9891 VDD.n654 VDD.n602 8.49947
R9892 VDD.n654 VDD.n613 8.49947
R9893 VDD.n806 VDD.n684 8.49947
R9894 VDD.n829 VDD.n684 8.49947
R9895 VDD.n365 VDD.n363 8.49929
R9896 VDD.n387 VDD.n363 8.49929
R9897 VDD.n418 VDD.n193 8.49929
R9898 VDD.n435 VDD.n83 8.49679
R9899 VDD.n435 VDD.n77 8.49679
R9900 VDD.n435 VDD.n112 8.49679
R9901 VDD.n452 VDD.n442 8.49679
R9902 VDD.n446 VDD.n442 8.49679
R9903 VDD.n475 VDD.n442 8.49679
R9904 VDD.n459 VDD.n442 8.49679
R9905 VDD.n852 VDD.n19 8.49679
R9906 VDD.n852 VDD.n13 8.49679
R9907 VDD.n852 VDD.n43 8.49679
R9908 VDD.n852 VDD.n37 8.49679
R9909 VDD.t210 VDD.n79 8.49667
R9910 VDD.n109 VDD.t192 8.49667
R9911 VDD.t170 VDD.n447 8.49667
R9912 VDD.n472 VDD.t186 8.49667
R9913 VDD.t129 VDD.n15 8.49667
R9914 VDD.n40 VDD.t147 8.49667
R9915 VDD.n418 VDD.n184 8.49387
R9916 VDD.n409 VDD.n139 8.49137
R9917 VDD.n413 VDD.n139 8.49137
R9918 VDD.n416 VDD.n139 8.49137
R9919 VDD.n654 VDD.n491 8.49137
R9920 VDD.n655 VDD.n654 8.49137
R9921 VDD.n836 VDD.n684 8.49137
R9922 VDD.n840 VDD.n684 8.49137
R9923 VDD.n654 VDD.n555 8.48821
R9924 VDD.n654 VDD.n564 8.48821
R9925 VDD.n760 VDD.n684 8.48821
R9926 VDD.n709 VDD.n684 8.48821
R9927 VDD.n774 VDD.n684 8.48821
R9928 VDD.n654 VDD.n536 8.47696
R9929 VDD.n401 VDD.n249 8.47359
R9930 VDD.n353 VDD.n299 8.47359
R9931 VDD.n354 VDD.n298 8.47359
R9932 VDD.n355 VDD.n303 8.47359
R9933 VDD.n358 VDD.n304 8.47359
R9934 VDD.n359 VDD.n307 8.47359
R9935 VDD.n360 VDD.n308 8.47359
R9936 VDD.n433 VDD.n140 8.46995
R9937 VDD.n334 VDD.n321 8.46995
R9938 VDD.n330 VDD.n325 8.46995
R9939 VDD.n328 VDD.n327 8.46995
R9940 VDD.n392 VDD.n312 8.46995
R9941 VDD.n391 VDD.n361 8.46995
R9942 VDD.n390 VDD.n362 8.46995
R9943 VDD.n367 VDD.n366 8.46995
R9944 VDD.n296 VDD.n295 8.46995
R9945 VDD.n398 VDD.n397 8.46995
R9946 VDD.n401 VDD.n400 8.46995
R9947 VDD.n418 VDD.n197 8.46995
R9948 VDD.n275 VDD.n273 7.501
R9949 VDD.n275 VDD.n272 7.501
R9950 VDD.n596 VDD.n590 7.501
R9951 VDD.n596 VDD.n589 7.501
R9952 VDD.n817 VDD.n739 7.501
R9953 VDD.n817 VDD.n738 7.501
R9954 VDD.n277 VDD.n269 7.5005
R9955 VDD.n277 VDD.n270 7.5005
R9956 VDD.n277 VDD.n271 7.5005
R9957 VDD.n277 VDD.t134 7.5005
R9958 VDD.t140 VDD.n231 7.5005
R9959 VDD.t140 VDD.n230 7.5005
R9960 VDD.t140 VDD.n232 7.5005
R9961 VDD.t140 VDD.n229 7.5005
R9962 VDD.t140 VDD.n233 7.5005
R9963 VDD.n240 VDD.t140 7.5005
R9964 VDD.t140 VDD.n234 7.5005
R9965 VDD.t140 VDD.n227 7.5005
R9966 VDD.t140 VDD.n239 7.5005
R9967 VDD.t140 VDD.n226 7.5005
R9968 VDD.t140 VDD.n225 7.5005
R9969 VDD.n594 VDD.n592 7.5005
R9970 VDD.n594 VDD.n593 7.5005
R9971 VDD.t118 VDD.n515 7.5005
R9972 VDD.t118 VDD.n514 7.5005
R9973 VDD.t118 VDD.n516 7.5005
R9974 VDD.t118 VDD.n513 7.5005
R9975 VDD.t118 VDD.n517 7.5005
R9976 VDD.n520 VDD.t118 7.5005
R9977 VDD.t118 VDD.n508 7.5005
R9978 VDD.t118 VDD.n512 7.5005
R9979 VDD.t118 VDD.n518 7.5005
R9980 VDD.t118 VDD.n511 7.5005
R9981 VDD.t118 VDD.n519 7.5005
R9982 VDD.n815 VDD.n813 7.5005
R9983 VDD.n815 VDD.n814 7.5005
R9984 VDD.n720 VDD.t137 7.5005
R9985 VDD.t137 VDD.n692 7.5005
R9986 VDD.t137 VDD.n695 7.5005
R9987 VDD.t137 VDD.n691 7.5005
R9988 VDD.t137 VDD.n697 7.5005
R9989 VDD.t137 VDD.n690 7.5005
R9990 VDD.t137 VDD.n700 7.5005
R9991 VDD.t137 VDD.n689 7.5005
R9992 VDD.t137 VDD.n703 7.5005
R9993 VDD.t137 VDD.n688 7.5005
R9994 VDD.t137 VDD.n719 7.5005
R9995 VDD.n126 VDD 7.244
R9996 VDD.n125 VDD 6.81542
R9997 VDD.n130 VDD 6.51433
R9998 VDD.n712 VDD.t73 6.02698
R9999 VDD.n710 VDD.t71 6.02698
R10000 VDD.n708 VDD.t77 6.02698
R10001 VDD.n706 VDD.t72 6.02698
R10002 VDD.n704 VDD.t75 6.02698
R10003 VDD.n769 VDD.t57 6.02698
R10004 VDD.n771 VDD.t67 6.02698
R10005 VDD.n773 VDD.t62 6.02698
R10006 VDD.n775 VDD.t59 6.02698
R10007 VDD.n777 VDD.t65 6.02698
R10008 VDD.n557 VDD.t21 6.02676
R10009 VDD.n556 VDD.t19 6.02676
R10010 VDD.n554 VDD.t17 6.02676
R10011 VDD.n552 VDD.t20 6.02676
R10012 VDD.n550 VDD.t18 6.02676
R10013 VDD.n559 VDD.t4 6.02676
R10014 VDD.n561 VDD.t12 6.02676
R10015 VDD.n563 VDD.t6 6.02676
R10016 VDD.n565 VDD.t13 6.02676
R10017 VDD.n566 VDD.t10 6.02676
R10018 VDD.n133 VDD 6.0065
R10019 VDD.n333 VDD.t42 5.66778
R10020 VDD.n631 VDD.n569 5.66778
R10021 VDD.n802 VDD.n747 5.66778
R10022 VDD.t42 VDD.n139 5.66717
R10023 VDD.n418 VDD.t47 5.66717
R10024 VDD.n654 VDD.n507 5.66717
R10025 VDD.n654 VDD.n506 5.66717
R10026 VDD.n654 VDD.n505 5.66717
R10027 VDD.n654 VDD.n504 5.66717
R10028 VDD.n698 VDD.n684 5.66717
R10029 VDD.n702 VDD.n684 5.66717
R10030 VDD.n701 VDD.n684 5.66717
R10031 VDD.n718 VDD.n684 5.66717
R10032 VDD.n654 VDD.n495 5.66713
R10033 VDD.n654 VDD.n496 5.66713
R10034 VDD.n654 VDD.n497 5.66713
R10035 VDD.n654 VDD.n498 5.66713
R10036 VDD.n654 VDD.n499 5.66713
R10037 VDD.n687 VDD.n684 5.66713
R10038 VDD.n694 VDD.n684 5.66713
R10039 VDD.n693 VDD.n684 5.66713
R10040 VDD.n696 VDD.n684 5.66713
R10041 VDD.n714 VDD.n684 5.66713
R10042 VDD.n401 VDD.n251 5.66505
R10043 VDD.n654 VDD.n571 5.66505
R10044 VDD.n803 VDD.n684 5.66505
R10045 VDD.n435 VDD.n70 5.6603
R10046 VDD.n435 VDD.n121 5.6603
R10047 VDD.n435 VDD.n96 5.6603
R10048 VDD.n669 VDD.n442 5.6603
R10049 VDD.n482 VDD.n442 5.6603
R10050 VDD.n852 VDD.n6 5.6603
R10051 VDD.n852 VDD.n30 5.6603
R10052 VDD.n54 VDD.t93 5.66011
R10053 VDD.n463 VDD.t87 5.66011
R10054 VDD.n3 VDD.t101 5.66011
R10055 VDD.n378 VDD.n363 5.65604
R10056 VDD.n406 VDD.n139 5.65069
R10057 VDD.n654 VDD.n489 5.65069
R10058 VDD.n654 VDD.n483 5.65069
R10059 VDD.n833 VDD.n684 5.65069
R10060 VDD.n843 VDD.n684 5.65069
R10061 VDD.n654 VDD.n551 5.64508
R10062 VDD.n654 VDD.n553 5.64508
R10063 VDD.n654 VDD.n558 5.64508
R10064 VDD.n654 VDD.n567 5.64508
R10065 VDD.n654 VDD.n562 5.64508
R10066 VDD.n654 VDD.n560 5.64508
R10067 VDD.n705 VDD.n684 5.64508
R10068 VDD.n707 VDD.n684 5.64508
R10069 VDD.n711 VDD.n684 5.64508
R10070 VDD.n776 VDD.n684 5.64508
R10071 VDD.n772 VDD.n684 5.64508
R10072 VDD.n770 VDD.n684 5.64508
R10073 VDD.n394 VDD.n393 5.62808
R10074 VDD.n332 VDD.n331 5.61281
R10075 VDD.n418 VDD.n170 5.61281
R10076 VDD.n435 VDD.n134 5.61281
R10077 VDD.n435 VDD.n69 5.61281
R10078 VDD.n670 VDD.n442 5.61281
R10079 VDD.n853 VDD.n852 5.61281
R10080 VDD.n54 VDD.n53 5.32813
R10081 VDD.n463 VDD.n462 5.32813
R10082 VDD.n3 VDD.n2 5.32813
R10083 VDD.n129 VDD 5.08087
R10084 VDD.n596 VDD.n595 5.00219
R10085 VDD.n817 VDD.n816 5.00219
R10086 VDD.n276 VDD.n275 5.00111
R10087 VDD.n277 VDD.t123 5.0005
R10088 VDD.n594 VDD.t152 5.0005
R10089 VDD.n815 VDD.t131 5.0005
R10090 VDD.n247 VDD 4.94683
R10091 VDD.n492 VDD 4.94683
R10092 VDD.n844 VDD 4.94683
R10093 VDD.n346 VDD.t250 4.86866
R10094 VDD.n345 VDD.t243 4.86866
R10095 VDD.n236 VDD.t233 4.86866
R10096 VDD.n235 VDD.t235 4.86866
R10097 VDD.n132 VDD 4.70062
R10098 VDD.n346 VDD.t246 4.69994
R10099 VDD.n345 VDD.t247 4.69994
R10100 VDD.n383 VDD.t253 4.69994
R10101 VDD.n379 VDD.t242 4.69994
R10102 VDD.n376 VDD.t241 4.69994
R10103 VDD.n374 VDD.t244 4.69994
R10104 VDD.n178 VDD.t231 4.69994
R10105 VDD.n182 VDD.t232 4.69994
R10106 VDD.n185 VDD.t236 4.69994
R10107 VDD.n190 VDD.t229 4.69994
R10108 VDD.n236 VDD.t227 4.69994
R10109 VDD.n235 VDD.t228 4.69994
R10110 VDD.t108 VDD.n304 4.25125
R10111 VDD.n626 VDD.n625 4.25119
R10112 VDD.n634 VDD.n633 4.25119
R10113 VDD.n637 VDD.n636 4.25119
R10114 VDD.n794 VDD.n783 4.25119
R10115 VDD.n798 VDD.n797 4.25119
R10116 VDD.n799 VDD.n681 4.25119
R10117 VDD.t54 VDD.n137 4.25111
R10118 VDD.n433 VDD.n164 4.251
R10119 VDD.n433 VDD.n161 4.251
R10120 VDD.n433 VDD.n157 4.251
R10121 VDD.n433 VDD.n155 4.251
R10122 VDD.n434 VDD.n433 4.251
R10123 VDD.n433 VDD.n135 4.251
R10124 VDD.n433 VDD.n154 4.251
R10125 VDD.n433 VDD.n151 4.251
R10126 VDD.n433 VDD.n148 4.251
R10127 VDD.n433 VDD.n145 4.251
R10128 VDD.n618 VDD.n617 4.251
R10129 VDD.n620 VDD.n619 4.251
R10130 VDD.n622 VDD.n621 4.251
R10131 VDD.n624 VDD.n623 4.251
R10132 VDD.n786 VDD.n779 4.251
R10133 VDD.n788 VDD.n780 4.251
R10134 VDD.n790 VDD.n781 4.251
R10135 VDD.n792 VDD.n782 4.251
R10136 VDD.t108 VDD.n299 4.2505
R10137 VDD.t108 VDD.n298 4.2505
R10138 VDD.t108 VDD.n303 4.2505
R10139 VDD.t108 VDD.n307 4.2505
R10140 VDD.t108 VDD.n308 4.2505
R10141 VDD.n418 VDD.n245 4.2505
R10142 VDD.n418 VDD.n244 4.2505
R10143 VDD.n418 VDD.n212 4.24994
R10144 VDD.n418 VDD.n187 4.24369
R10145 VDD.n382 VDD.n363 4.24356
R10146 VDD.n418 VDD.n192 4.23604
R10147 VDD.n394 VDD.n314 4.18085
R10148 VDD.n329 VDD.n138 4.15437
R10149 VDD.n371 VDD.t255 3.8397
R10150 VDD.n386 VDD.t109 3.8397
R10151 VDD.n179 VDD.t28 3.8397
R10152 VDD.n198 VDD.t50 3.8397
R10153 VDD.n534 VDD.t257 3.8397
R10154 VDD.n543 VDD.t1 3.8397
R10155 VDD.n763 VDD.t56 3.83904
R10156 VDD.n756 VDD.t256 3.83904
R10157 VDD.n275 VDD.n274 3.751
R10158 VDD.n596 VDD.n591 3.751
R10159 VDD.n817 VDD.n740 3.751
R10160 VDD.n595 VDD.n594 3.75092
R10161 VDD.n816 VDD.n815 3.75092
R10162 VDD.n675 VDD 3.70297
R10163 VDD.n143 VDD.n137 3.62297
R10164 VDD.n352 VDD.n313 3.40124
R10165 VDD.n654 VDD.n527 3.3795
R10166 VDD.n755 VDD.n684 3.3795
R10167 VDD.n654 VDD.n525 3.37933
R10168 VDD.n847 VDD.n684 3.37933
R10169 VDD.n60 VDD.t82 3.32833
R10170 VDD.n124 VDD.t226 3.32727
R10171 VDD.n418 VDD.n203 3.30365
R10172 VDD.n369 VDD.n302 3.10934
R10173 VDD.n547 VDD.n546 3.10148
R10174 VDD.n761 VDD.n679 3.10148
R10175 VDD.n381 VDD.n306 3.1003
R10176 VDD.n377 VDD.n305 3.09955
R10177 VDD.n539 VDD.n538 3.09879
R10178 VDD.n851 VDD.n850 3.09879
R10179 VDD.n141 VDD.n136 2.98936
R10180 VDD.n433 VDD.n153 2.83461
R10181 VDD.t108 VDD.n139 2.83383
R10182 VDD.n654 VDD.n500 2.83315
R10183 VDD.n717 VDD.n684 2.83315
R10184 VDD.n654 VDD.n494 2.83268
R10185 VDD.n721 VDD.n684 2.83268
R10186 VDD.n375 VDD.n363 2.82146
R10187 VDD.n418 VDD.n180 2.82135
R10188 VDD.n654 VDD.n542 2.81143
R10189 VDD.n418 VDD.n177 2.80887
R10190 VDD.n370 VDD.n363 2.80886
R10191 VDD.n68 VDD 2.76883
R10192 VDD.n433 VDD.n156 2.71665
R10193 VDD.n410 VDD 2.69
R10194 VDD.n490 VDD 2.69
R10195 VDD.n837 VDD 2.69
R10196 VDD.n123 VDD.t225 2.63359
R10197 VDD.n532 VDD.n531 2.6262
R10198 VDD.n765 VDD.n680 2.6262
R10199 VDD.n541 VDD.n540 2.62358
R10200 VDD.n758 VDD.n683 2.62358
R10201 VDD.n189 VDD.n188 2.62282
R10202 VDD.n183 VDD.n181 2.62282
R10203 VDD.n195 VDD.n194 2.62282
R10204 VDD.t54 VDD.n136 2.43008
R10205 VDD.t27 VDD.n181 2.42989
R10206 VDD.t27 VDD.n189 2.42989
R10207 VDD.n194 VDD.t27 2.42989
R10208 VDD.n433 VDD.n158 2.42957
R10209 VDD.n211 VDD.t208 2.42907
R10210 VDD.n241 VDD.t156 2.42907
R10211 VDD.n242 VDD.t156 2.42907
R10212 VDD.n211 VDD.t142 2.42907
R10213 VDD.t141 VDD.n241 2.42907
R10214 VDD.n242 VDD.t141 2.42907
R10215 VDD.n522 VDD.t176 2.42907
R10216 VDD.n510 VDD.t119 2.42907
R10217 VDD.n509 VDD.t119 2.42907
R10218 VDD.n522 VDD.t122 2.42907
R10219 VDD.n510 VDD.t121 2.42907
R10220 VDD.t121 VDD.n509 2.42907
R10221 VDD.n716 VDD.t138 2.42907
R10222 VDD.n715 VDD.t138 2.42907
R10223 VDD.n722 VDD.t139 2.42907
R10224 VDD.n716 VDD.t201 2.42907
R10225 VDD.t201 VDD.n715 2.42907
R10226 VDD.n722 VDD.t202 2.42907
R10227 VDD.n762 VDD.n684 2.40019
R10228 VDD.n685 VDD.n684 2.40019
R10229 VDD.n654 VDD.n533 2.40019
R10230 VDD.n440 VDD.n439 2.30983
R10231 VDD.n766 VDD.n684 2.30146
R10232 VDD.n404 VDD.n139 2.29333
R10233 VDD.n654 VDD.n486 2.29333
R10234 VDD.n831 VDD.n684 2.29333
R10235 VDD.n418 VDD.n172 2.29256
R10236 VDD.n654 VDD.n493 2.29256
R10237 VDD.n845 VDD.n684 2.29256
R10238 VDD.n176 VDD.n171 2.27781
R10239 VDD.n364 VDD.n297 2.2728
R10240 VDD.n65 VDD 2.2555
R10241 VDD.n57 VDD.t83 2.25306
R10242 VDD.t0 VDD.n540 2.1264
R10243 VDD.t55 VDD.n683 2.1264
R10244 VDD.t0 VDD.n539 2.12639
R10245 VDD.t55 VDD.n851 2.12639
R10246 VDD.n246 VDD.t41 2.126
R10247 VDD.t108 VDD.n301 2.126
R10248 VDD.n757 VDD.n684 2.09377
R10249 VDD.n654 VDD.n528 2.08475
R10250 VDD.n418 VDD.n220 1.9881
R10251 VDD.n654 VDD.n545 1.9822
R10252 VDD.n435 VDD.n52 1.97072
R10253 VDD.n672 VDD.n442 1.97054
R10254 VDD.n852 VDD.n5 1.97054
R10255 VDD.n389 VDD.n363 1.96204
R10256 VDD.n849 VDD.n848 1.94891
R10257 VDD.n66 VDD 1.92618
R10258 VDD.t108 VDD.n305 1.89036
R10259 VDD.n654 VDD.n501 1.88805
R10260 VDD.n435 VDD.n94 1.88181
R10261 VDD.n660 VDD.n442 1.88181
R10262 VDD.n852 VDD.n28 1.88181
R10263 VDD.n529 VDD.n528 1.87705
R10264 VDD.n654 VDD.n535 1.85188
R10265 VDD.n654 VDD.n544 1.85186
R10266 VDD.n764 VDD.n684 1.85186
R10267 VDD.n57 VDD.n56 1.82278
R10268 VDD.n849 VDD.n684 1.79237
R10269 VDD.n368 VDD.n363 1.73629
R10270 VDD.n61 VDD 1.73117
R10271 VDD.n436 VDD.n435 1.717
R10272 VDD.t108 VDD.n306 1.70155
R10273 VDD.n433 VDD.n167 1.701
R10274 VDD.n433 VDD.n168 1.701
R10275 VDD.n123 VDD.t224 1.5509
R10276 VDD.n425 VDD.n424 1.52331
R10277 VDD.n59 VDD.n56 1.51623
R10278 VDD.n439 VDD.n438 1.51172
R10279 VDD.n62 VDD 1.38569
R10280 VDD.n654 VDD.n549 1.34412
R10281 VDD.n686 VDD.n684 1.34412
R10282 VDD.n654 VDD.n530 1.34376
R10283 VDD.n768 VDD.n684 1.34376
R10284 VDD.n412 VDD 1.33241
R10285 VDD.n484 VDD 1.33241
R10286 VDD.n839 VDD 1.33241
R10287 VDD.t108 VDD.n395 1.30869
R10288 VDD.n429 VDD.n428 1.293
R10289 VDD.n428 VDD.n427 1.293
R10290 VDD.n424 VDD.n423 1.293
R10291 VDD.n423 VDD.n422 1.293
R10292 VDD.n422 VDD.n421 1.293
R10293 VDD.n433 VDD.n152 1.1851
R10294 VDD.n124 VDD.n123 1.16135
R10295 VDD.n430 VDD.n426 1.15925
R10296 VDD.n403 VDD 1.13717
R10297 VDD.n652 VDD 1.13717
R10298 VDD.n830 VDD 1.13717
R10299 VDD.n176 VDD.n173 1.13265
R10300 VDD.n433 VDD.n432 1.08488
R10301 VDD.n238 VDD.n173 1.08317
R10302 VDD.n465 VDD.n442 1.06861
R10303 VDD.n852 VDD.n678 1.06861
R10304 VDD.n433 VDD.n142 1.06386
R10305 VDD.n411 VDD.n139 1.05567
R10306 VDD.n654 VDD.n485 1.05567
R10307 VDD.n838 VDD.n684 1.05566
R10308 VDD.n403 VDD.n402 0.945444
R10309 VDD.n713 VDD.n712 0.93373
R10310 VDD.n654 VDD.n526 0.913194
R10311 VDD.n778 VDD.n684 0.913194
R10312 VDD.n557 VDD.n503 0.902436
R10313 VDD.n675 VDD.n674 0.9005
R10314 VDD.n56 VDD.t81 0.895237
R10315 VDD.n200 VDD.n199 0.874458
R10316 VDD.n219 VDD.n200 0.866838
R10317 VDD.n418 VDD.n200 0.858916
R10318 VDD.n144 VDD.n143 0.847055
R10319 VDD.n60 VDD.n59 0.842493
R10320 VDD.n142 VDD.n141 0.822735
R10321 VDD VDD.n152 0.821535
R10322 VDD.n433 VDD.n144 0.801945
R10323 VDD.n852 VDD.n29 0.796088
R10324 VDD.n435 VDD.n95 0.795512
R10325 VDD.n658 VDD.n442 0.795512
R10326 VDD.t108 VDD.n302 0.775292
R10327 VDD.n143 VDD.n142 0.774826
R10328 VDD.n437 VDD.n54 0.764286
R10329 VDD.n464 VDD.n463 0.764286
R10330 VDD.n4 VDD.n3 0.764286
R10331 VDD.n834 VDD.n29 0.756742
R10332 VDD.n407 VDD.n95 0.75414
R10333 VDD.n659 VDD.n658 0.75414
R10334 VDD.n315 VDD.n144 0.752079
R10335 VDD.n465 VDD.n464 0.740109
R10336 VDD.n368 VDD.n367 0.73635
R10337 VDD.n432 VDD.n431 0.735824
R10338 VDD.n411 VDD.n410 0.732013
R10339 VDD.n490 VDD.n485 0.732013
R10340 VDD.n839 VDD.n838 0.726269
R10341 VDD.n838 VDD.n837 0.725201
R10342 VDD.n364 VDD 0.722833
R10343 VDD.n412 VDD.n411 0.719458
R10344 VDD.n485 VDD.n484 0.719458
R10345 VDD.n566 VDD.n526 0.718064
R10346 VDD.n778 VDD.n777 0.718064
R10347 VDD.t108 VDD.n297 0.711075
R10348 VDD.n678 VDD.n677 0.696109
R10349 VDD.n390 VDD.n389 0.690081
R10350 VDD.n206 VDD.n152 0.685669
R10351 VDD VDD.n528 0.668224
R10352 VDD.n549 VDD.n548 0.663813
R10353 VDD.n848 VDD.n686 0.663813
R10354 VDD.n530 VDD.n529 0.663776
R10355 VDD.n768 VDD.n767 0.663776
R10356 VDD.n405 VDD 0.634418
R10357 VDD.n488 VDD 0.634418
R10358 VDD.n832 VDD 0.634418
R10359 VDD.n432 VDD.n420 0.621499
R10360 VDD.n59 VDD.n58 0.619295
R10361 VDD.n850 VDD.n849 0.595797
R10362 VDD.n559 VDD.n530 0.573785
R10363 VDD.n769 VDD.n768 0.573785
R10364 VDD.n550 VDD.n549 0.573728
R10365 VDD.n704 VDD.n686 0.573728
R10366 VDD.n440 VDD 0.570259
R10367 VDD.n5 VDD.n4 0.568265
R10368 VDD.n426 VDD.n425 0.560813
R10369 VDD.n438 VDD.n52 0.548737
R10370 VDD.n418 VDD.n243 0.527744
R10371 VDD.n673 VDD.n672 0.507765
R10372 VDD.n674 VDD.n440 0.507725
R10373 VDD.n676 VDD.n439 0.506825
R10374 VDD.n389 VDD.n388 0.500872
R10375 VDD.n436 VDD.n55 0.499519
R10376 VDD.n437 VDD.n436 0.498526
R10377 VDD.n654 VDD.n568 0.486214
R10378 VDD.n785 VDD.n684 0.486214
R10379 VDD.n247 VDD.n172 0.467845
R10380 VDD.n493 VDD.n492 0.467845
R10381 VDD.n845 VDD.n844 0.467845
R10382 VDD.n405 VDD.n404 0.46661
R10383 VDD.n488 VDD.n486 0.46661
R10384 VDD.n832 VDD.n831 0.46661
R10385 VDD.n330 VDD.n329 0.454911
R10386 VDD.n635 VDD.n526 0.453506
R10387 VDD.n800 VDD.n778 0.453506
R10388 VDD.n672 VDD.n671 0.444015
R10389 VDD.n5 VDD.n0 0.444015
R10390 VDD.n122 VDD.n52 0.443413
R10391 VDD.n328 VDD.n203 0.435211
R10392 VDD.n404 VDD.n403 0.428526
R10393 VDD.n652 VDD.n486 0.428526
R10394 VDD.n831 VDD.n830 0.428526
R10395 VDD.n210 VDD.n172 0.427208
R10396 VDD.n524 VDD.n493 0.427208
R10397 VDD.n846 VDD.n845 0.427208
R10398 VDD.n418 VDD.n173 0.419021
R10399 VDD.n766 VDD 0.416899
R10400 VDD.n320 VDD.n156 0.407821
R10401 VDD.n329 VDD.n328 0.400196
R10402 VDD.n237 VDD.n220 0.39593
R10403 VDD.n546 VDD.n545 0.380328
R10404 VDD.t108 VDD.n248 0.378758
R10405 VDD.n220 VDD.n219 0.374086
R10406 VDD.n548 VDD.n545 0.353718
R10407 VDD.n414 VDD.n95 0.353003
R10408 VDD.n658 VDD.n657 0.353003
R10409 VDD.n654 VDD.n503 0.351304
R10410 VDD.n841 VDD.n29 0.351202
R10411 VDD.n130 VDD.n129 0.345167
R10412 VDD.n66 VDD.n65 0.345167
R10413 VDD VDD.n68 0.3415
R10414 VDD.n133 VDD.n132 0.339667
R10415 VDD.n369 VDD.n368 0.33111
R10416 VDD.n156 VDD 0.323129
R10417 VDD.n331 VDD.n321 0.312698
R10418 VDD.n331 VDD.n330 0.312358
R10419 VDD.n430 VDD.n429 0.30675
R10420 VDD.n767 VDD.n766 0.303324
R10421 VDD.n206 VDD.n203 0.294367
R10422 VDD.n467 VDD.n465 0.284159
R10423 VDD.n678 VDD.n51 0.284159
R10424 VDD.n713 VDD.n684 0.272283
R10425 VDD.n393 VDD.n392 0.271279
R10426 VDD.n58 VDD.n57 0.264205
R10427 VDD.n393 VDD.n360 0.263017
R10428 VDD.n175 VDD 0.262283
R10429 VDD.n400 VDD.n398 0.250378
R10430 VDD.n398 VDD.n295 0.250378
R10431 VDD.n367 VDD.n295 0.250378
R10432 VDD.n392 VDD.n391 0.250378
R10433 VDD.n391 VDD.n390 0.250378
R10434 VDD.n141 VDD.n140 0.240939
R10435 VDD.n352 VDD.n314 0.240166
R10436 VDD.n105 VDD.n104 0.237977
R10437 VDD.n134 VDD.n122 0.228092
R10438 VDD.n69 VDD.n55 0.227752
R10439 VDD.n671 VDD.n670 0.227752
R10440 VDD.n853 VDD.n0 0.227752
R10441 VDD.n210 VDD 0.224139
R10442 VDD.n360 VDD.n359 0.221145
R10443 VDD.n359 VDD.n358 0.221145
R10444 VDD.n355 VDD.n354 0.221145
R10445 VDD.n354 VDD.n353 0.221145
R10446 VDD.n353 VDD.n249 0.221145
R10447 VDD.n524 VDD 0.213567
R10448 VDD.n846 VDD 0.213567
R10449 VDD.n435 VDD.t54 0.213
R10450 VDD.t0 VDD.n442 0.213
R10451 VDD.n852 VDD.t55 0.213
R10452 VDD.n420 VDD.n170 0.200549
R10453 VDD.n64 VDD.n63 0.194698
R10454 VDD.n128 VDD.n127 0.19334
R10455 VDD.n197 VDD.n195 0.187772
R10456 VDD.n210 VDD.n170 0.187419
R10457 VDD.n196 VDD 0.181275
R10458 VDD.n69 VDD 0.180425
R10459 VDD.n670 VDD 0.180425
R10460 VDD VDD.n853 0.180425
R10461 VDD.n134 VDD.n133 0.180086
R10462 VDD.t0 VDD.n531 0.176089
R10463 VDD.t55 VDD.n680 0.176089
R10464 VDD.n503 VDD.n502 0.175055
R10465 VDD.n191 VDD 0.172218
R10466 VDD.n384 VDD 0.168485
R10467 VDD.n716 VDD.n713 0.166226
R10468 VDD.n315 VDD.n314 0.161484
R10469 VDD.n356 VDD.n355 0.159352
R10470 VDD.n321 VDD.n320 0.156606
R10471 VDD.n197 VDD.n196 0.147439
R10472 VDD.n126 VDD.n125 0.139833
R10473 VDD.n62 VDD.n61 0.139833
R10474 VDD.n535 VDD.n534 0.13412
R10475 VDD.n400 VDD.n399 0.132772
R10476 VDD.n544 VDD.n543 0.131998
R10477 VDD.n764 VDD.n763 0.131785
R10478 VDD.n758 VDD.n757 0.130522
R10479 VDD.t0 VDD.n547 0.126799
R10480 VDD.t55 VDD.n679 0.126799
R10481 VDD.n372 VDD 0.126034
R10482 VDD.n757 VDD.n756 0.119974
R10483 VDD.n765 VDD.n764 0.11884
R10484 VDD.n546 VDD.n544 0.11862
R10485 VDD.t27 VDD.n171 0.117322
R10486 VDD.n370 VDD.n369 0.117242
R10487 VDD.n177 VDD.n176 0.117148
R10488 VDD.n538 VDD.n535 0.116497
R10489 VDD.n177 VDD.n175 0.115433
R10490 VDD.n431 VDD.n140 0.108939
R10491 VDD.n542 VDD.n541 0.10456
R10492 VDD.n760 VDD 0.10192
R10493 VDD.n553 VDD.n552 0.0949372
R10494 VDD.n558 VDD.n557 0.0949372
R10495 VDD.n560 VDD.n559 0.0949372
R10496 VDD.n707 VDD.n706 0.0949372
R10497 VDD.n712 VDD.n711 0.0949372
R10498 VDD.n770 VDD.n769 0.0949372
R10499 VDD.n551 VDD.n550 0.0946012
R10500 VDD.n562 VDD.n561 0.0946012
R10501 VDD.n567 VDD.n566 0.0946012
R10502 VDD.n705 VDD.n704 0.0946012
R10503 VDD.n772 VDD.n771 0.0946012
R10504 VDD.n777 VDD.n776 0.0946012
R10505 VDD.n533 VDD.n532 0.0925668
R10506 VDD.n850 VDD.n685 0.0922747
R10507 VDD.n762 VDD.n761 0.0901928
R10508 VDD.n555 VDD.n554 0.0868519
R10509 VDD.n564 VDD.n563 0.0868519
R10510 VDD.n709 VDD.n708 0.0868519
R10511 VDD.n774 VDD.n773 0.0868519
R10512 VDD.n91 VDD.n90 0.0867162
R10513 VDD.n357 VDD.n345 0.0848609
R10514 VDD.n357 VDD.n346 0.0848609
R10515 VDD.n237 VDD.n235 0.0848609
R10516 VDD.n237 VDD.n236 0.0848609
R10517 VDD.n357 VDD.n356 0.083
R10518 VDD.n238 VDD.n237 0.083
R10519 VDD.n763 VDD.n762 0.0828838
R10520 VDD.n756 VDD.n685 0.0808039
R10521 VDD.n616 VDD.n527 0.0807033
R10522 VDD.n801 VDD.n755 0.0807033
R10523 VDD.n534 VDD.n533 0.0805166
R10524 VDD.n525 VDD.n524 0.0804014
R10525 VDD.n847 VDD.n846 0.0804014
R10526 VDD VDD.n536 0.0792198
R10527 VDD.n548 VDD.n525 0.0787844
R10528 VDD.n848 VDD.n847 0.0787844
R10529 VDD.n529 VDD.n527 0.0784831
R10530 VDD.n767 VDD.n755 0.0784831
R10531 VDD.n674 VDD.n673 0.0781952
R10532 VDD.n677 VDD.n676 0.0781952
R10533 VDD.n198 VDD.n192 0.0779153
R10534 VDD.n358 VDD.n357 0.076852
R10535 VDD.n371 VDD.n370 0.0742674
R10536 VDD.n556 VDD.n555 0.0687697
R10537 VDD.n565 VDD.n564 0.0687697
R10538 VDD.n710 VDD.n709 0.0687697
R10539 VDD.n775 VDD.n774 0.0687697
R10540 VDD.n543 VDD.n542 0.0680564
R10541 VDD.n129 VDD.n128 0.0629691
R10542 VDD.n131 VDD.n130 0.0629691
R10543 VDD.n132 VDD.n131 0.0629691
R10544 VDD.n65 VDD.n64 0.0629691
R10545 VDD.n68 VDD.n67 0.0629691
R10546 VDD.n67 VDD.n66 0.0629691
R10547 VDD.n552 VDD.n551 0.0617865
R10548 VDD.n563 VDD.n562 0.0617865
R10549 VDD.n567 VDD.n565 0.0617865
R10550 VDD.n706 VDD.n705 0.0617865
R10551 VDD.n773 VDD.n772 0.0617865
R10552 VDD.n776 VDD.n775 0.0617865
R10553 VDD.n558 VDD.n556 0.0614505
R10554 VDD.n554 VDD.n553 0.0614505
R10555 VDD.n561 VDD.n560 0.0614505
R10556 VDD.n711 VDD.n710 0.0614505
R10557 VDD.n708 VDD.n707 0.0614505
R10558 VDD.n771 VDD.n770 0.0614505
R10559 VDD.n192 VDD.n191 0.0597564
R10560 VDD.n417 VDD.n416 0.0588132
R10561 VDD.n410 VDD.n409 0.0571122
R10562 VDD.n413 VDD.n412 0.0571122
R10563 VDD.n491 VDD.n490 0.0571122
R10564 VDD.n655 VDD.n484 0.0571122
R10565 VDD.n837 VDD.n836 0.0571122
R10566 VDD.n840 VDD.n839 0.0571122
R10567 VDD.n399 VDD.n249 0.0558226
R10568 VDD.n388 VDD.n387 0.055573
R10569 VDD.n195 VDD 0.0555
R10570 VDD.n656 VDD.n483 0.0554453
R10571 VDD.n843 VDD.n842 0.0554453
R10572 VDD.n375 VDD.n374 0.0547887
R10573 VDD.n408 VDD.n406 0.0545429
R10574 VDD.n489 VDD.n456 0.0545429
R10575 VDD.n835 VDD.n833 0.0545429
R10576 VDD.n58 VDD 0.0512692
R10577 VDD.n538 VDD.n536 0.0505896
R10578 VDD.n399 VDD 0.0490294
R10579 VDD.n219 VDD 0.0490294
R10580 VDD.n406 VDD.n405 0.0469401
R10581 VDD.n489 VDD.n488 0.0469401
R10582 VDD.n833 VDD.n832 0.0469401
R10583 VDD.n492 VDD.n483 0.0466048
R10584 VDD.n844 VDD.n843 0.0466048
R10585 VDD.n94 VDD.n93 0.0458571
R10586 VDD.n661 VDD.n660 0.0458571
R10587 VDD.n28 VDD.n27 0.0458571
R10588 VDD.n409 VDD.n408 0.0440709
R10589 VDD.n491 VDD.n456 0.0440709
R10590 VDD.n836 VDD.n835 0.0440709
R10591 VDD.n382 VDD.n381 0.0435391
R10592 VDD.n415 VDD.n413 0.0435039
R10593 VDD.n656 VDD.n655 0.0435039
R10594 VDD.n842 VDD.n840 0.0435039
R10595 VDD.n188 VDD.n187 0.0434139
R10596 VDD.n387 VDD.n386 0.0419295
R10597 VDD.n372 VDD.n371 0.0405775
R10598 VDD.n673 VDD.n441 0.039
R10599 VDD.n180 VDD.n179 0.0385827
R10600 VDD.n379 VDD.n378 0.0375909
R10601 VDD.n376 VDD.n375 0.0366519
R10602 VDD.n182 VDD.n180 0.0364835
R10603 VDD.n416 VDD.n415 0.0355658
R10604 VDD.n414 VDD.n96 0.0353436
R10605 VDD.n657 VDD.n482 0.0353436
R10606 VDD.n841 VDD.n30 0.0353436
R10607 VDD.n127 VDD.n126 0.0303765
R10608 VDD.n385 VDD.n384 0.0299919
R10609 VDD.n63 VDD.n62 0.0290185
R10610 VDD.n761 VDD.n760 0.0280847
R10611 VDD.n419 VDD.n169 0.0277868
R10612 VDD.n209 VDD.n146 0.0277868
R10613 VDD.n201 VDD.n147 0.0277868
R10614 VDD.n208 VDD.n149 0.0277868
R10615 VDD.n202 VDD.n150 0.0277868
R10616 VDD.n336 VDD.n160 0.0277868
R10617 VDD.n340 VDD.n163 0.0277868
R10618 VDD.n317 VDD.n165 0.0277868
R10619 VDD.n344 VDD.n166 0.0277868
R10620 VDD.n316 VDD.n315 0.0277868
R10621 VDD.n70 VDD.n55 0.027577
R10622 VDD.n122 VDD.n121 0.027577
R10623 VDD.n671 VDD.n669 0.027577
R10624 VDD.n6 VDD.n0 0.027577
R10625 VDD.n125 VDD.n124 0.0275769
R10626 VDD.n61 VDD.n60 0.0275769
R10627 VDD.n378 VDD.n377 0.0270428
R10628 VDD.n184 VDD 0.0270186
R10629 VDD.n369 VDD 0.0260814
R10630 VDD.n377 VDD.n376 0.0244313
R10631 VDD.n183 VDD.n182 0.0244313
R10632 VDD.n185 VDD.n184 0.0240796
R10633 VDD.n190 VDD.n187 0.023932
R10634 VDD.n383 VDD.n382 0.0238062
R10635 VDD.n365 VDD.n364 0.0231699
R10636 VDD.n196 VDD.n193 0.0231699
R10637 VDD.n532 VDD 0.0231027
R10638 VDD VDD.n765 0.0231027
R10639 VDD.n74 VDD.n70 0.0229562
R10640 VDD.n121 VDD.n120 0.0229562
R10641 VDD.n669 VDD.n668 0.0229562
R10642 VDD.n10 VDD.n6 0.0229562
R10643 VDD.n100 VDD.n96 0.022622
R10644 VDD.n482 VDD.n481 0.022622
R10645 VDD.n34 VDD.n30 0.022622
R10646 VDD.n464 VDD.n441 0.0225
R10647 VDD.n677 VDD.n1 0.0225
R10648 VDD.n4 VDD.n1 0.0225
R10649 VDD.n537 VDD 0.0215959
R10650 VDD VDD.n759 0.0215959
R10651 VDD.n318 VDD.n162 0.0213915
R10652 VDD.n438 VDD.n437 0.0206667
R10653 VDD.n186 VDD.n185 0.0202328
R10654 VDD.n386 VDD.n385 0.0189066
R10655 VDD.n207 VDD.n206 0.018407
R10656 VDD.n179 VDD.n178 0.016874
R10657 VDD.n84 VDD.n77 0.0151174
R10658 VDD.n114 VDD.n112 0.0151174
R10659 VDD.n665 VDD.n446 0.0151174
R10660 VDD.n476 VDD.n475 0.0151174
R10661 VDD.n20 VDD.n13 0.0151174
R10662 VDD.n45 VDD.n43 0.0151174
R10663 VDD.n81 VDD.n77 0.0138787
R10664 VDD.n83 VDD.n82 0.0138787
R10665 VDD.n112 VDD.n111 0.0138787
R10666 VDD.n450 VDD.n446 0.0138787
R10667 VDD.n452 VDD.n451 0.0138787
R10668 VDD.n475 VDD.n474 0.0138787
R10669 VDD.n473 VDD.n459 0.0138787
R10670 VDD.n17 VDD.n13 0.0138787
R10671 VDD.n19 VDD.n18 0.0138787
R10672 VDD.n43 VDD.n42 0.0138787
R10673 VDD.n41 VDD.n37 0.0138787
R10674 VDD.n85 VDD.n83 0.013631
R10675 VDD.n664 VDD.n452 0.013631
R10676 VDD.n477 VDD.n459 0.013631
R10677 VDD.n21 VDD.n19 0.013631
R10678 VDD.n44 VDD.n37 0.013631
R10679 VDD.n262 VDD.n251 0.0132054
R10680 VDD.n579 VDD.n571 0.0132054
R10681 VDD.n804 VDD.n803 0.0132054
R10682 VDD.n86 VDD.n85 0.0131351
R10683 VDD.n113 VDD.n102 0.0131351
R10684 VDD.n664 VDD.n663 0.0131351
R10685 VDD.n478 VDD.n477 0.0131351
R10686 VDD.n22 VDD.n21 0.0131351
R10687 VDD.n44 VDD.n36 0.0131351
R10688 VDD VDD.n183 0.0130954
R10689 VDD.n407 VDD.n94 0.0129679
R10690 VDD.n660 VDD.n659 0.0129679
R10691 VDD.n834 VDD.n28 0.0129679
R10692 VDD.n74 VDD.n71 0.0128874
R10693 VDD.n81 VDD.n78 0.0128874
R10694 VDD.n93 VDD.n88 0.0128874
R10695 VDD.n120 VDD.n117 0.0128874
R10696 VDD.n111 VDD.n107 0.0128874
R10697 VDD.n100 VDD.n97 0.0128874
R10698 VDD.n668 VDD.n443 0.0128874
R10699 VDD.n450 VDD.n449 0.0128874
R10700 VDD.n661 VDD.n455 0.0128874
R10701 VDD.n467 VDD.n466 0.0128874
R10702 VDD.n474 VDD.n470 0.0128874
R10703 VDD.n481 VDD.n457 0.0128874
R10704 VDD.n10 VDD.n7 0.0128874
R10705 VDD.n17 VDD.n14 0.0128874
R10706 VDD.n27 VDD.n24 0.0128874
R10707 VDD.n51 VDD.n48 0.0128874
R10708 VDD.n42 VDD.n38 0.0128874
R10709 VDD.n34 VDD.n31 0.0128874
R10710 VDD.n73 VDD.n72 0.0123919
R10711 VDD.n89 VDD.n87 0.0123919
R10712 VDD.n118 VDD.n116 0.0123919
R10713 VDD.n99 VDD.n98 0.0123919
R10714 VDD.n445 VDD.n444 0.0123919
R10715 VDD.n454 VDD.n453 0.0123919
R10716 VDD.n461 VDD.n460 0.0123919
R10717 VDD.n479 VDD.n458 0.0123919
R10718 VDD.n9 VDD.n8 0.0123919
R10719 VDD.n25 VDD.n23 0.0123919
R10720 VDD.n49 VDD.n47 0.0123919
R10721 VDD.n33 VDD.n32 0.0123919
R10722 VDD.n380 VDD 0.0123358
R10723 VDD.n243 VDD.n225 0.0122551
R10724 VDD.n76 VDD.n75 0.0118964
R10725 VDD.n119 VDD.n115 0.0118964
R10726 VDD.n102 VDD.n101 0.0118964
R10727 VDD.n667 VDD.n666 0.0118964
R10728 VDD.n663 VDD.n662 0.0118964
R10729 VDD.n469 VDD.n468 0.0118964
R10730 VDD.n480 VDD.n478 0.0118964
R10731 VDD.n12 VDD.n11 0.0118964
R10732 VDD.n26 VDD.n22 0.0118964
R10733 VDD.n50 VDD.n46 0.0118964
R10734 VDD.n36 VDD.n35 0.0118964
R10735 VDD.n502 VDD.n501 0.0116611
R10736 VDD.n84 VDD.n76 0.0116486
R10737 VDD.n115 VDD.n114 0.0116486
R10738 VDD.n106 VDD.n105 0.0116486
R10739 VDD.n666 VDD.n665 0.0116486
R10740 VDD.n476 VDD.n469 0.0116486
R10741 VDD.n20 VDD.n12 0.0116486
R10742 VDD.n46 VDD.n45 0.0116486
R10743 VDD.n92 VDD.n91 0.0111532
R10744 VDD VDD.n379 0.0101565
R10745 VDD.n80 VDD.n79 0.00966675
R10746 VDD.n82 VDD.n79 0.00966675
R10747 VDD.n109 VDD.n108 0.00966675
R10748 VDD.n110 VDD.n109 0.00966675
R10749 VDD.n448 VDD.n447 0.00966675
R10750 VDD.n451 VDD.n447 0.00966675
R10751 VDD.n472 VDD.n471 0.00966675
R10752 VDD.n473 VDD.n472 0.00966675
R10753 VDD.n16 VDD.n15 0.00966675
R10754 VDD.n18 VDD.n15 0.00966675
R10755 VDD.n40 VDD.n39 0.00966675
R10756 VDD.n41 VDD.n40 0.00966675
R10757 VDD.n294 VDD.n293 0.00947486
R10758 VDD.n613 VDD.n612 0.00947486
R10759 VDD.n829 VDD.n828 0.00947486
R10760 VDD.n199 VDD.n198 0.00902713
R10761 VDD.n509 VDD.n501 0.00872759
R10762 VDD.n515 VDD.n494 0.00811991
R10763 VDD.n721 VDD.n720 0.00811991
R10764 VDD.n231 VDD.n212 0.00810172
R10765 VDD.n408 VDD.n407 0.00793243
R10766 VDD.n415 VDD.n414 0.00793243
R10767 VDD.n659 VDD.n456 0.00793243
R10768 VDD.n657 VDD.n656 0.00793243
R10769 VDD.n835 VDD.n834 0.00793243
R10770 VDD.n842 VDD.n841 0.00793243
R10771 VDD.n509 VDD.n500 0.00776545
R10772 VDD.n717 VDD.n716 0.00776545
R10773 VDD.n294 VDD 0.00749125
R10774 VDD VDD.n613 0.00749125
R10775 VDD VDD.n829 0.00749125
R10776 VDD.n352 VDD.n251 0.00746192
R10777 VDD.n631 VDD.n571 0.00746192
R10778 VDD.n803 VDD.n802 0.00746192
R10779 VDD.n417 VDD.n247 0.00730412
R10780 VDD.n522 VDD.n494 0.00727552
R10781 VDD.n722 VDD.n721 0.00727552
R10782 VDD.n384 VDD.n383 0.00721756
R10783 VDD.n191 VDD.n190 0.00721756
R10784 VDD.n319 VDD.n318 0.00689535
R10785 VDD.n363 VDD.n297 0.00675031
R10786 VDD.n285 VDD.n284 0.00645082
R10787 VDD.n260 VDD.n254 0.00645082
R10788 VDD.n610 VDD.n603 0.00645082
R10789 VDD.n578 VDD.n574 0.00645082
R10790 VDD.n734 VDD.n733 0.00645082
R10791 VDD.n807 VDD.n805 0.00645082
R10792 VDD.n292 VDD.n282 0.00636066
R10793 VDD.n264 VDD.n252 0.00636066
R10794 VDD.n608 VDD.n601 0.00636066
R10795 VDD.n580 VDD.n572 0.00636066
R10796 VDD.n827 VDD.n826 0.00636066
R10797 VDD.n746 VDD.n745 0.00636066
R10798 VDD.n363 VDD.n302 0.00626652
R10799 VDD.n105 VDD.n103 0.0061982
R10800 VDD.n320 VDD.n159 0.00604264
R10801 VDD.n374 VDD.n373 0.00603816
R10802 VDD.n178 VDD.n174 0.00595802
R10803 VDD.n75 VDD.n72 0.00595045
R10804 VDD.n92 VDD.n87 0.00595045
R10805 VDD.n119 VDD.n116 0.00595045
R10806 VDD.n101 VDD.n98 0.00595045
R10807 VDD.n667 VDD.n445 0.00595045
R10808 VDD.n662 VDD.n453 0.00595045
R10809 VDD.n468 VDD.n460 0.00595045
R10810 VDD.n480 VDD.n479 0.00595045
R10811 VDD.n11 VDD.n8 0.00595045
R10812 VDD.n26 VDD.n23 0.00595045
R10813 VDD.n50 VDD.n47 0.00595045
R10814 VDD.n35 VDD.n32 0.00595045
R10815 VDD.n286 VDD.n281 0.00590984
R10816 VDD.n259 VDD.n255 0.00590984
R10817 VDD.n607 VDD.n600 0.00590984
R10818 VDD.n581 VDD.n575 0.00590984
R10819 VDD.n820 VDD.n735 0.00590984
R10820 VDD.n809 VDD.n744 0.00590984
R10821 VDD.n212 VDD.n211 0.00576287
R10822 VDD.n824 VDD.n823 0.00572951
R10823 VDD.n265 VDD.n256 0.00545902
R10824 VDD.n582 VDD.n576 0.00545902
R10825 VDD.n810 VDD.n808 0.00545902
R10826 VDD.n73 VDD.n71 0.00545496
R10827 VDD.n80 VDD.n78 0.00545496
R10828 VDD.n89 VDD.n88 0.00545496
R10829 VDD.n118 VDD.n117 0.00545496
R10830 VDD.n108 VDD.n107 0.00545496
R10831 VDD.n99 VDD.n97 0.00545496
R10832 VDD.n444 VDD.n443 0.00545496
R10833 VDD.n449 VDD.n448 0.00545496
R10834 VDD.n455 VDD.n454 0.00545496
R10835 VDD.n466 VDD.n461 0.00545496
R10836 VDD.n471 VDD.n470 0.00545496
R10837 VDD.n458 VDD.n457 0.00545496
R10838 VDD.n9 VDD.n7 0.00545496
R10839 VDD.n16 VDD.n14 0.00545496
R10840 VDD.n25 VDD.n24 0.00545496
R10841 VDD.n49 VDD.n48 0.00545496
R10842 VDD.n39 VDD.n38 0.00545496
R10843 VDD.n33 VDD.n31 0.00545496
R10844 VDD.n287 VDD.n280 0.00536885
R10845 VDD.n604 VDD.n599 0.00536885
R10846 VDD.n822 VDD.n821 0.00536885
R10847 VDD.n258 VDD.n257 0.0050082
R10848 VDD.n584 VDD.n577 0.0050082
R10849 VDD.n743 VDD.n742 0.0050082
R10850 VDD.n519 VDD.n500 0.00496514
R10851 VDD.n719 VDD.n717 0.00496514
R10852 VDD.n110 VDD.n106 0.00495946
R10853 VDD.n291 VDD.n279 0.00491803
R10854 VDD.n606 VDD.n598 0.00491803
R10855 VDD.n737 VDD.n736 0.00491803
R10856 VDD.n113 VDD.n103 0.00471171
R10857 VDD.n289 VDD.n278 0.00446721
R10858 VDD.n267 VDD.n266 0.00446721
R10859 VDD.n605 VDD.n597 0.00446721
R10860 VDD.n587 VDD.n586 0.00446721
R10861 VDD.n819 VDD.n818 0.00446721
R10862 VDD.n812 VDD.n811 0.00446721
R10863 VDD.n388 VDD.n365 0.00441017
R10864 VDD.n199 VDD.n193 0.00441017
R10865 VDD.n278 VDD.n277 0.00437705
R10866 VDD.n275 VDD.n268 0.00437705
R10867 VDD.n597 VDD.n596 0.00437705
R10868 VDD.n594 VDD.n588 0.00437705
R10869 VDD.n818 VDD.n817 0.00437705
R10870 VDD.n815 VDD.n741 0.00437705
R10871 VDD.n514 VDD.n495 0.00435532
R10872 VDD.n516 VDD.n496 0.00435532
R10873 VDD.n513 VDD.n497 0.00435532
R10874 VDD.n517 VDD.n498 0.00435532
R10875 VDD.n692 VDD.n687 0.00435532
R10876 VDD.n695 VDD.n694 0.00435532
R10877 VDD.n693 VDD.n691 0.00435532
R10878 VDD.n697 VDD.n696 0.00435532
R10879 VDD.n225 VDD.n224 0.0043486
R10880 VDD.n226 VDD.n223 0.0043486
R10881 VDD.n227 VDD.n221 0.0043486
R10882 VDD.n234 VDD.n218 0.0043486
R10883 VDD.n233 VDD.n216 0.0043486
R10884 VDD.n232 VDD.n214 0.0043486
R10885 VDD.n230 VDD.n213 0.0043486
R10886 VDD.n292 VDD.n283 0.00433551
R10887 VDD.n264 VDD.n253 0.00433551
R10888 VDD.n608 VDD.n602 0.00433551
R10889 VDD.n580 VDD.n573 0.00433551
R10890 VDD.n806 VDD.n745 0.00433551
R10891 VDD.n285 VDD.n283 0.00424535
R10892 VDD.n260 VDD.n253 0.00424535
R10893 VDD.n610 VDD.n602 0.00424535
R10894 VDD.n578 VDD.n573 0.00424535
R10895 VDD.n807 VDD.n806 0.00424535
R10896 VDD.n275 VDD.n267 0.00419672
R10897 VDD.n594 VDD.n587 0.00419672
R10898 VDD.n815 VDD.n812 0.00419672
R10899 VDD.n519 VDD.n504 0.00416667
R10900 VDD.n511 VDD.n505 0.00416667
R10901 VDD.n518 VDD.n506 0.00416667
R10902 VDD.n512 VDD.n507 0.00416667
R10903 VDD.n521 VDD.n508 0.00416667
R10904 VDD.n719 VDD.n718 0.00416667
R10905 VDD.n701 VDD.n688 0.00416667
R10906 VDD.n703 VDD.n702 0.00416667
R10907 VDD.n698 VDD.n689 0.00416667
R10908 VDD.n700 VDD.n699 0.00416667
R10909 VDD.n239 VDD.n238 0.0040687
R10910 VDD.n510 VDD.n499 0.00402199
R10911 VDD.n715 VDD.n714 0.00402199
R10912 VDD.n631 VDD.n616 0.00401639
R10913 VDD.n635 VDD.n616 0.00401639
R10914 VDD.n802 VDD.n801 0.00401639
R10915 VDD.n801 VDD.n800 0.00401639
R10916 VDD.n241 VDD.n217 0.00399873
R10917 VDD.n363 VDD.n306 0.00331398
R10918 VDD.n403 VDD 0.00320492
R10919 VDD.n356 VDD.n352 0.00320492
R10920 VDD.n652 VDD 0.00320492
R10921 VDD.n830 VDD 0.00320492
R10922 VDD.n517 VDD.n499 0.0031776
R10923 VDD.n513 VDD.n498 0.0031776
R10924 VDD.n516 VDD.n497 0.0031776
R10925 VDD.n514 VDD.n496 0.0031776
R10926 VDD.n515 VDD.n495 0.0031776
R10927 VDD.n714 VDD.n697 0.0031776
R10928 VDD.n696 VDD.n691 0.0031776
R10929 VDD.n695 VDD.n693 0.0031776
R10930 VDD.n694 VDD.n692 0.0031776
R10931 VDD.n720 VDD.n687 0.0031776
R10932 VDD.n229 VDD.n228 0.00308906
R10933 VDD.n363 VDD.n305 0.00307157
R10934 VDD.n188 VDD.n186 0.00301908
R10935 VDD.n654 VDD.n539 0.00283091
R10936 VDD.n851 VDD.n684 0.00283091
R10937 VDD.n654 VDD.n540 0.00281835
R10938 VDD.n684 VDD.n683 0.00281835
R10939 VDD.n277 VDD.n268 0.0027541
R10940 VDD.n596 VDD.n588 0.0027541
R10941 VDD.n817 VDD.n741 0.0027541
R10942 VDD.n433 VDD.n136 0.00269423
R10943 VDD.n373 VDD.n372 0.00267938
R10944 VDD.n289 VDD.n279 0.00266393
R10945 VDD.n266 VDD.n257 0.00266393
R10946 VDD.n605 VDD.n598 0.00266393
R10947 VDD.n586 VDD.n577 0.00266393
R10948 VDD.n819 VDD.n737 0.00266393
R10949 VDD.n811 VDD.n742 0.00266393
R10950 VDD.n418 VDD.n194 0.00257843
R10951 VDD.n418 VDD.n189 0.00257843
R10952 VDD.n418 VDD.n181 0.00257843
R10953 VDD.n381 VDD.n380 0.00225945
R10954 VDD.n291 VDD.n280 0.00221311
R10955 VDD.n606 VDD.n599 0.00221311
R10956 VDD.n821 VDD.n736 0.00221311
R10957 VDD.n420 VDD.n419 0.00220543
R10958 VDD.n209 VDD.n169 0.00220543
R10959 VDD.n201 VDD.n146 0.00220543
R10960 VDD.n208 VDD.n147 0.00220543
R10961 VDD.n202 VDD.n149 0.00220543
R10962 VDD.n207 VDD.n150 0.00220543
R10963 VDD.n336 VDD.n159 0.00220543
R10964 VDD.n319 VDD.n160 0.00220543
R10965 VDD.n340 VDD.n162 0.00220543
R10966 VDD.n317 VDD.n163 0.00220543
R10967 VDD.n344 VDD.n165 0.00220543
R10968 VDD.n316 VDD.n166 0.00220543
R10969 VDD.n258 VDD.n256 0.00212295
R10970 VDD.n584 VDD.n576 0.00212295
R10971 VDD.n808 VDD.n743 0.00212295
R10972 VDD.n541 VDD.n537 0.00200685
R10973 VDD.n759 VDD.n758 0.00200685
R10974 VDD.n397 VDD.n248 0.00197775
R10975 VDD.n243 VDD.n242 0.00189891
R10976 VDD.n433 VDD.n137 0.00182343
R10977 VDD.n287 VDD.n281 0.0017623
R10978 VDD.n604 VDD.n600 0.0017623
R10979 VDD.n822 VDD.n820 0.0017623
R10980 VDD.n175 VDD.n174 0.00175954
R10981 VDD.n228 VDD.n215 0.00175954
R10982 VDD.n274 VDD.n269 0.00175
R10983 VDD.n592 VDD.n591 0.00175
R10984 VDD.n813 VDD.n740 0.00175
R10985 VDD.n265 VDD.n255 0.00167213
R10986 VDD.n582 VDD.n575 0.00167213
R10987 VDD.n810 VDD.n809 0.00167213
R10988 VDD.n276 VDD.n271 0.00166667
R10989 VDD.n334 VDD.n333 0.00166667
R10990 VDD.n636 VDD.n569 0.00166667
R10991 VDD.n799 VDD.n747 0.00166667
R10992 VDD.n637 VDD.t11 0.00162501
R10993 VDD.n633 VDD.t8 0.00162501
R10994 VDD.n625 VDD.t5 0.00162501
R10995 VDD.t66 VDD.n681 0.00162501
R10996 VDD.n797 VDD.t61 0.00162501
R10997 VDD.n794 VDD.t63 0.00162501
R10998 VDD.n211 VDD.n210 0.00161959
R10999 VDD.n313 VDD.n308 0.00160001
R11000 VDD.n204 VDD.n153 0.00158334
R11001 VDD.n595 VDD.t113 0.00158326
R11002 VDD.n816 VDD.t159 0.00158326
R11003 VDD.t41 VDD.n153 0.00141665
R11004 VDD.n226 VDD.n224 0.00140967
R11005 VDD.n239 VDD.n223 0.00140967
R11006 VDD.n227 VDD.n222 0.00140967
R11007 VDD.n234 VDD.n221 0.00140967
R11008 VDD.n240 VDD.n218 0.00140967
R11009 VDD.n233 VDD.n217 0.00140967
R11010 VDD.n229 VDD.n216 0.00140967
R11011 VDD.n232 VDD.n215 0.00140967
R11012 VDD.n230 VDD.n214 0.00140967
R11013 VDD.n231 VDD.n213 0.00140967
R11014 VDD.n825 VDD.n824 0.00140164
R11015 VDD.n394 VDD.n313 0.00139998
R11016 VDD.n625 VDD.t8 0.00137498
R11017 VDD.n633 VDD.t11 0.00137498
R11018 VDD.t0 VDD.n637 0.00137498
R11019 VDD.t61 VDD.n794 0.00137498
R11020 VDD.n797 VDD.t66 0.00137498
R11021 VDD.t55 VDD.n681 0.00137498
R11022 VDD.n511 VDD.n504 0.00136667
R11023 VDD.n518 VDD.n505 0.00136667
R11024 VDD.n512 VDD.n506 0.00136667
R11025 VDD.n508 VDD.n507 0.00136667
R11026 VDD.n521 VDD.n520 0.00136667
R11027 VDD.n718 VDD.n688 0.00136667
R11028 VDD.n703 VDD.n701 0.00136667
R11029 VDD.n702 VDD.n689 0.00136667
R11030 VDD.n700 VDD.n698 0.00136667
R11031 VDD.n699 VDD.n690 0.00136667
R11032 VDD.n333 VDD.n332 0.00133332
R11033 VDD.n654 VDD.n569 0.00133332
R11034 VDD.n747 VDD.n684 0.00133332
R11035 VDD.t134 VDD.n276 0.00133332
R11036 VDD.n274 VDD.t123 0.00124998
R11037 VDD.t152 VDD.n591 0.00124998
R11038 VDD.t131 VDD.n740 0.00124998
R11039 VDD.n91 VDD.n86 0.00124324
R11040 VDD.n293 VDD.n284 0.00122131
R11041 VDD.n286 VDD.n282 0.00122131
R11042 VDD.n259 VDD.n254 0.00122131
R11043 VDD.n262 VDD.n252 0.00122131
R11044 VDD.n612 VDD.n603 0.00122131
R11045 VDD.n607 VDD.n601 0.00122131
R11046 VDD.n581 VDD.n574 0.00122131
R11047 VDD.n579 VDD.n572 0.00122131
R11048 VDD.n828 VDD.n733 0.00122131
R11049 VDD.n826 VDD.n735 0.00122131
R11050 VDD.n805 VDD.n744 0.00122131
R11051 VDD.n804 VDD.n746 0.00122131
R11052 VDD.n654 VDD.n531 0.00119094
R11053 VDD.n684 VDD.n680 0.00119094
R11054 VDD.n524 VDD.n523 0.00116667
R11055 VDD.n846 VDD.n723 0.00116667
R11056 VDD.n654 VDD.n547 0.00113793
R11057 VDD.n684 VDD.n679 0.00113793
R11058 VDD.n418 VDD.n171 0.00112635
R11059 VDD.n401 VDD.n248 0.00102222
R11060 VDD.n418 VDD.n246 0.001
R11061 VDD.n402 VDD.n401 0.001
R11062 VDD.n397 VDD.n396 0.001
R11063 VDD.n300 VDD.n296 0.001
R11064 VDD.n366 VDD.n301 0.001
R11065 VDD.n327 VDD.n205 0.001
R11066 VDD.n326 VDD.n138 0.001
R11067 VDD.n325 VDD.n324 0.001
R11068 VDD.n332 VDD.n323 0.001
R11069 VDD.n337 VDD.n335 0.001
R11070 VDD.n341 VDD.n339 0.001
R11071 VDD.n394 VDD.n343 0.001
R11072 VDD.n347 VDD.n308 0.001
R11073 VDD.n348 VDD.n307 0.001
R11074 VDD.n349 VDD.n304 0.001
R11075 VDD.n350 VDD.n303 0.001
R11076 VDD.n351 VDD.n298 0.001
R11077 VDD.n299 VDD.n250 0.001
R11078 VDD.n395 VDD.n312 0.001
R11079 VDD.n312 VDD.n309 0.001
R11080 VDD.n361 VDD.n310 0.001
R11081 VDD.n362 VDD.n311 0.001
R11082 VDD.n272 VDD.n271 0.001
R11083 VDD.n273 VDD.n270 0.001
R11084 VDD.t124 VDD.n261 0.001
R11085 VDD.t178 VDD.n288 0.001
R11086 VDD.n290 VDD.n288 0.001
R11087 VDD.n263 VDD.n261 0.001
R11088 VDD.n273 VDD.n269 0.001
R11089 VDD.n272 VDD.n270 0.001
R11090 VDD.n363 VDD.n301 0.001
R11091 VDD.n244 VDD.n168 0.001
R11092 VDD.n244 VDD.n145 0.001
R11093 VDD.n245 VDD.n148 0.001
R11094 VDD.t47 VDD.n151 0.001
R11095 VDD.n204 VDD.n154 0.001
R11096 VDD.t49 VDD.n135 0.001
R11097 VDD.t54 VDD.n434 0.001
R11098 VDD.n155 VDD.t48 0.001
R11099 VDD.n322 VDD.n157 0.001
R11100 VDD.t42 VDD.n158 0.001
R11101 VDD.t52 VDD.n161 0.001
R11102 VDD.n338 VDD.n164 0.001
R11103 VDD.n342 VDD.n167 0.001
R11104 VDD.n342 VDD.n164 0.001
R11105 VDD.n338 VDD.n161 0.001
R11106 VDD.t52 VDD.n158 0.001
R11107 VDD.t42 VDD.n157 0.001
R11108 VDD.n322 VDD.n155 0.001
R11109 VDD.n434 VDD.t48 0.001
R11110 VDD.t54 VDD.n135 0.001
R11111 VDD.t49 VDD.n154 0.001
R11112 VDD.t41 VDD.n151 0.001
R11113 VDD.t47 VDD.n148 0.001
R11114 VDD.n245 VDD.n145 0.001
R11115 VDD.t108 VDD.n167 0.001
R11116 VDD.t27 VDD.n168 0.001
R11117 VDD.n402 VDD.n139 0.001
R11118 VDD.n401 VDD.n250 0.001
R11119 VDD.n351 VDD.n299 0.001
R11120 VDD.n350 VDD.n298 0.001
R11121 VDD.n349 VDD.n303 0.001
R11122 VDD.n348 VDD.n304 0.001
R11123 VDD.n347 VDD.n307 0.001
R11124 VDD.n343 VDD.n341 0.001
R11125 VDD.n339 VDD.n337 0.001
R11126 VDD.n335 VDD.n334 0.001
R11127 VDD.n325 VDD.n323 0.001
R11128 VDD.n324 VDD.n138 0.001
R11129 VDD.n327 VDD.n326 0.001
R11130 VDD.n418 VDD.n205 0.001
R11131 VDD.n395 VDD.n394 0.001
R11132 VDD.n361 VDD.n309 0.001
R11133 VDD.n362 VDD.n310 0.001
R11134 VDD.n363 VDD.n311 0.001
R11135 VDD.n366 VDD.n300 0.001
R11136 VDD.n396 VDD.n296 0.001
R11137 VDD.n246 VDD.n139 0.001
R11138 VDD.n609 VDD.t153 0.001
R11139 VDD.t113 VDD.n589 0.001
R11140 VDD.n593 VDD.n590 0.001
R11141 VDD.n583 VDD.t114 0.001
R11142 VDD.n636 VDD.n615 0.001
R11143 VDD.n634 VDD.n632 0.001
R11144 VDD.n627 VDD.n626 0.001
R11145 VDD.n628 VDD.n624 0.001
R11146 VDD.n629 VDD.n622 0.001
R11147 VDD.n630 VDD.n620 0.001
R11148 VDD.n618 VDD.n570 0.001
R11149 VDD.n623 VDD.t16 0.001
R11150 VDD.n621 VDD.t9 0.001
R11151 VDD.n619 VDD.t14 0.001
R11152 VDD.n617 VDD.n568 0.001
R11153 VDD.n585 VDD.n583 0.001
R11154 VDD.n592 VDD.n590 0.001
R11155 VDD.n593 VDD.n589 0.001
R11156 VDD.n611 VDD.n609 0.001
R11157 VDD.n654 VDD.n570 0.001
R11158 VDD.n630 VDD.n618 0.001
R11159 VDD.n629 VDD.n620 0.001
R11160 VDD.n628 VDD.n622 0.001
R11161 VDD.n627 VDD.n624 0.001
R11162 VDD.n632 VDD.n626 0.001
R11163 VDD.n634 VDD.n615 0.001
R11164 VDD.n617 VDD.t14 0.001
R11165 VDD.n619 VDD.t9 0.001
R11166 VDD.n621 VDD.t16 0.001
R11167 VDD.n623 VDD.t5 0.001
R11168 VDD.n654 VDD.n487 0.001
R11169 VDD.n639 VDD.n638 0.001
R11170 VDD.n641 VDD.n640 0.001
R11171 VDD.n643 VDD.n642 0.001
R11172 VDD.n645 VDD.n644 0.001
R11173 VDD.n647 VDD.n646 0.001
R11174 VDD.n649 VDD.n648 0.001
R11175 VDD.n651 VDD.n650 0.001
R11176 VDD.n653 VDD.n614 0.001
R11177 VDD.n654 VDD.n653 0.001
R11178 VDD.n651 VDD.n614 0.001
R11179 VDD.n650 VDD.n649 0.001
R11180 VDD.n648 VDD.n647 0.001
R11181 VDD.n646 VDD.n645 0.001
R11182 VDD.n644 VDD.n643 0.001
R11183 VDD.n642 VDD.n641 0.001
R11184 VDD.n640 VDD.n639 0.001
R11185 VDD.n638 VDD.n487 0.001
R11186 VDD.t159 VDD.n738 0.001
R11187 VDD.n814 VDD.n739 0.001
R11188 VDD.n799 VDD.n748 0.001
R11189 VDD.n798 VDD.n749 0.001
R11190 VDD.n783 VDD.n750 0.001
R11191 VDD.n782 VDD.n751 0.001
R11192 VDD.n781 VDD.n752 0.001
R11193 VDD.n780 VDD.n753 0.001
R11194 VDD.n779 VDD.n754 0.001
R11195 VDD.n792 VDD.t58 0.001
R11196 VDD.n790 VDD.t68 0.001
R11197 VDD.n788 VDD.t64 0.001
R11198 VDD.n786 VDD.n785 0.001
R11199 VDD.n813 VDD.n739 0.001
R11200 VDD.n814 VDD.n738 0.001
R11201 VDD.n754 VDD.n684 0.001
R11202 VDD.n779 VDD.n753 0.001
R11203 VDD.n780 VDD.n752 0.001
R11204 VDD.n781 VDD.n751 0.001
R11205 VDD.n782 VDD.n750 0.001
R11206 VDD.n783 VDD.n749 0.001
R11207 VDD.n798 VDD.n748 0.001
R11208 VDD.t64 VDD.n786 0.001
R11209 VDD.t68 VDD.n788 0.001
R11210 VDD.t58 VDD.n790 0.001
R11211 VDD.t63 VDD.n792 0.001
R11212 VDD.n724 VDD.n684 0.001
R11213 VDD.n725 VDD.n682 0.001
R11214 VDD.n796 VDD.n726 0.001
R11215 VDD.n795 VDD.n727 0.001
R11216 VDD.n793 VDD.n728 0.001
R11217 VDD.n791 VDD.n729 0.001
R11218 VDD.n789 VDD.n730 0.001
R11219 VDD.n787 VDD.n731 0.001
R11220 VDD.n784 VDD.n732 0.001
R11221 VDD.n732 VDD.n684 0.001
R11222 VDD.n784 VDD.n731 0.001
R11223 VDD.n787 VDD.n730 0.001
R11224 VDD.n789 VDD.n729 0.001
R11225 VDD.n791 VDD.n728 0.001
R11226 VDD.n793 VDD.n727 0.001
R11227 VDD.n795 VDD.n726 0.001
R11228 VDD.n796 VDD.n725 0.001
R11229 VDD.n724 VDD.n682 0.001
R11230 VDD.n523 VDD.n522 0.0009
R11231 VDD.n723 VDD.n722 0.0009
R11232 VDD.n241 VDD.n240 0.000849873
R11233 VDD.n520 VDD.n510 0.000833333
R11234 VDD.n715 VDD.n690 0.000833333
R11235 VDD.n238 VDD.n222 0.000779898
R11236 VDD.n827 VDD.n825 0.000770492
R11237 VDD.n823 VDD.n734 0.000680328
R11238 current_source_1mA_0.current_source_1mA_2_stage_0.vcp.n0 current_source_1mA_0.current_source_1mA_2_stage_0.vcp.t6 24.2053
R11239 current_source_1mA_0.current_source_1mA_2_stage_0.vcp current_source_1mA_0.current_source_1mA_2_stage_0.vcp.t2 17.4676
R11240 current_source_1mA_0.current_source_1mA_2_stage_0.vcp.n0 current_source_1mA_0.current_source_1mA_2_stage_0.vcp.t7 12.782
R11241 current_source_1mA_0.current_source_1mA_2_stage_0.vcp.n2 current_source_1mA_0.current_source_1mA_2_stage_0.vcp.t1 9.66447
R11242 current_source_1mA_0.current_source_1mA_2_stage_0.vcp.n2 current_source_1mA_0.current_source_1mA_2_stage_0.vcp.t3 8.80402
R11243 current_source_1mA_0.current_source_1mA_2_stage_0.vcp.n3 current_source_1mA_0.current_source_1mA_2_stage_0.vcp.t4 8.80402
R11244 current_source_1mA_0.current_source_1mA_2_stage_0.vcp.n4 current_source_1mA_0.current_source_1mA_2_stage_0.vcp.t5 8.80402
R11245 current_source_1mA_0.current_source_1mA_2_stage_0.vcp.n5 current_source_1mA_0.current_source_1mA_2_stage_0.vcp.t0 8.55905
R11246 current_source_1mA_0.current_source_1mA_2_stage_0.vcp.n6 current_source_1mA_0.current_source_1mA_2_stage_0.vcp.n5 5.06376
R11247 current_source_1mA_0.current_source_1mA_2_stage_0.vcp current_source_1mA_0.current_source_1mA_2_stage_0.vcp.n0 2.9111
R11248 current_source_1mA_0.current_source_1mA_2_stage_0.vcp.n6 current_source_1mA_0.current_source_1mA_2_stage_0.vcp 1.03733
R11249 current_source_1mA_0.current_source_1mA_2_stage_0.vcp.n5 current_source_1mA_0.current_source_1mA_2_stage_0.vcp.n4 1.02598
R11250 current_source_1mA_0.current_source_1mA_2_stage_0.vcp.n3 current_source_1mA_0.current_source_1mA_2_stage_0.vcp.n2 0.860944
R11251 current_source_1mA_0.current_source_1mA_2_stage_0.vcp.n4 current_source_1mA_0.current_source_1mA_2_stage_0.vcp.n3 0.860944
R11252 current_source_1mA_0.current_source_1mA_2_stage_0.vcp.n1 current_source_1mA_0.current_source_1mA_2_stage_0.vcp 0.472738
R11253 current_source_1mA_0.current_source_1mA_2_stage_0.vcp current_source_1mA_0.current_source_1mA_2_stage_0.vcp.n1 0.0309951
R11254 current_source_1mA_0.current_source_1mA_2_stage_0.vcp.n1 current_source_1mA_0.current_source_1mA_2_stage_0.vcp 0.0281571
R11255 current_source_1mA_0.current_source_1mA_2_stage_0.vcp current_source_1mA_0.current_source_1mA_2_stage_0.vcp.n6 0.0179257
R11256 current_source_1mA_0.ota_med_hv_gmid_0.ota_med_hv_gmid_mirror_0.Iref.n0 current_source_1mA_0.ota_med_hv_gmid_0.ota_med_hv_gmid_mirror_0.Iref.t3 10.9202
R11257 current_source_1mA_0.ota_med_hv_gmid_0.ota_med_hv_gmid_mirror_0.Iref.n0 current_source_1mA_0.ota_med_hv_gmid_0.ota_med_hv_gmid_mirror_0.Iref.t4 5.98993
R11258 current_source_1mA_0.ota_med_hv_gmid_0.ota_med_hv_gmid_mirror_0.Iref.n1 current_source_1mA_0.ota_med_hv_gmid_0.ota_med_hv_gmid_mirror_0.Iref.t2 4.13955
R11259 current_source_1mA_0.ota_med_hv_gmid_0.ota_med_hv_gmid_mirror_0.Iref current_source_1mA_0.ota_med_hv_gmid_0.ota_med_hv_gmid_mirror_0.Iref.n2 3.96924
R11260 current_source_1mA_0.ota_med_hv_gmid_0.ota_med_hv_gmid_mirror_0.Iref.n2 current_source_1mA_0.ota_med_hv_gmid_0.ota_med_hv_gmid_mirror_0.Iref.t1 3.27217
R11261 current_source_1mA_0.ota_med_hv_gmid_0.ota_med_hv_gmid_mirror_0.Iref.n1 current_source_1mA_0.ota_med_hv_gmid_0.ota_med_hv_gmid_mirror_0.Iref.t0 1.29639
R11262 current_source_1mA_0.ota_med_hv_gmid_0.ota_med_hv_gmid_mirror_0.Iref.n2 current_source_1mA_0.ota_med_hv_gmid_0.ota_med_hv_gmid_mirror_0.Iref.n1 0.891929
R11263 current_source_1mA_0.ota_med_hv_gmid_0.ota_med_hv_gmid_mirror_0.Iref current_source_1mA_0.ota_med_hv_gmid_0.ota_med_hv_gmid_mirror_0.Iref.n0 0.426671
R11264 current_source_1mA_0.ota_med_hv_gmid_0.ota_med_hv_gmid_tail_0.tail.n0 current_source_1mA_0.ota_med_hv_gmid_0.ota_med_hv_gmid_tail_0.tail.t2 8.83925
R11265 current_source_1mA_0.ota_med_hv_gmid_0.ota_med_hv_gmid_tail_0.tail.n0 current_source_1mA_0.ota_med_hv_gmid_0.ota_med_hv_gmid_tail_0.tail.t3 5.63708
R11266 current_source_1mA_0.ota_med_hv_gmid_0.ota_med_hv_gmid_tail_0.tail.n3 current_source_1mA_0.ota_med_hv_gmid_0.ota_med_hv_gmid_tail_0.tail.n0 5.45789
R11267 current_source_1mA_0.ota_med_hv_gmid_0.ota_med_hv_gmid_tail_0.tail.n2 current_source_1mA_0.ota_med_hv_gmid_0.ota_med_hv_gmid_tail_0.tail.n1 4.42018
R11268 current_source_1mA_0.ota_med_hv_gmid_0.ota_med_hv_gmid_tail_0.tail.n1 current_source_1mA_0.ota_med_hv_gmid_0.ota_med_hv_gmid_tail_0.tail.t1 4.35553
R11269 current_source_1mA_0.ota_med_hv_gmid_0.ota_med_hv_gmid_tail_0.tail.n1 current_source_1mA_0.ota_med_hv_gmid_0.ota_med_hv_gmid_tail_0.tail.t0 1.88191
R11270 current_source_1mA_0.ota_med_hv_gmid_0.ota_med_hv_gmid_tail_0.tail.n3 current_source_1mA_0.ota_med_hv_gmid_0.ota_med_hv_gmid_tail_0.tail 0.3327
R11271 current_source_1mA_0.ota_med_hv_gmid_0.ota_med_hv_gmid_tail_0.tail.n3 current_source_1mA_0.ota_med_hv_gmid_0.ota_med_hv_gmid_tail_0.tail 0.0577
R11272 current_source_1mA_0.ota_med_hv_gmid_0.ota_med_hv_gmid_tail_0.tail.n2 current_source_1mA_0.ota_med_hv_gmid_0.ota_med_hv_gmid_tail_0.tail 0.0522647
R11273 current_source_1mA_0.ota_med_hv_gmid_0.ota_med_hv_gmid_tail_0.tail current_source_1mA_0.ota_med_hv_gmid_0.ota_med_hv_gmid_tail_0.tail.n2 0.0445
R11274 current_source_1mA_0.ota_med_hv_gmid_0.ota_med_hv_gmid_tail_0.tail current_source_1mA_0.ota_med_hv_gmid_0.ota_med_hv_gmid_tail_0.tail.n3 0.0445
R11275 two_stage_instrumentation_amplifier_0.ota_slow_gmid_1.en_n.n0 two_stage_instrumentation_amplifier_0.ota_slow_gmid_1.en_n.t3 26.7483
R11276 two_stage_instrumentation_amplifier_0.ota_slow_gmid_1.en_n.n0 two_stage_instrumentation_amplifier_0.ota_slow_gmid_1.en_n.t2 26.7219
R11277 two_stage_instrumentation_amplifier_0.ota_slow_gmid_1.ota_slow_gmid_ctrl_buff_0.ota_slow_gmid_ctrl_inv_0.x two_stage_instrumentation_amplifier_0.ota_slow_gmid_1.en_n.t4 15.2608
R11278 two_stage_instrumentation_amplifier_0.ota_slow_gmid_1.en_n.n2 two_stage_instrumentation_amplifier_0.ota_slow_gmid_1.en_n.n0 5.57606
R11279 two_stage_instrumentation_amplifier_0.ota_slow_gmid_1.en_n.n1 two_stage_instrumentation_amplifier_0.ota_slow_gmid_1.en_n.t1 3.55057
R11280 two_stage_instrumentation_amplifier_0.ota_slow_gmid_1.en_n.n1 two_stage_instrumentation_amplifier_0.ota_slow_gmid_1.en_n.t0 3.47311
R11281 two_stage_instrumentation_amplifier_0.ota_slow_gmid_1.en_n.n2 two_stage_instrumentation_amplifier_0.ota_slow_gmid_1.ota_slow_gmid_ctrl_buff_0.ota_slow_gmid_ctrl_inv_1.y 0.3745
R11282 two_stage_instrumentation_amplifier_0.ota_slow_gmid_1.ota_slow_gmid_ctrl_buff_0.ota_slow_gmid_ctrl_inv_0.x two_stage_instrumentation_amplifier_0.ota_slow_gmid_1.en_n.n2 0.299333
R11283 two_stage_instrumentation_amplifier_0.ota_slow_gmid_1.ota_slow_gmid_ctrl_buff_0.ota_slow_gmid_ctrl_inv_1.y two_stage_instrumentation_amplifier_0.ota_slow_gmid_1.en_n.n1 0.204
R11284 two_stage_instrumentation_amplifier_0.ota_slow_gmid_1.vout1.n6 two_stage_instrumentation_amplifier_0.ota_slow_gmid_1.vout1.t14 31.5136
R11285 two_stage_instrumentation_amplifier_0.ota_slow_gmid_1.vout1.n17 two_stage_instrumentation_amplifier_0.ota_slow_gmid_1.vout1.t19 31.3583
R11286 two_stage_instrumentation_amplifier_0.ota_slow_gmid_1.vout1.n18 two_stage_instrumentation_amplifier_0.ota_slow_gmid_1.vout1.t18 28.3719
R11287 two_stage_instrumentation_amplifier_0.ota_slow_gmid_1.vout1.n6 two_stage_instrumentation_amplifier_0.ota_slow_gmid_1.vout1.t15 17.0903
R11288 two_stage_instrumentation_amplifier_0.ota_slow_gmid_1.vout1.n7 two_stage_instrumentation_amplifier_0.ota_slow_gmid_1.vout1.t16 17.0903
R11289 two_stage_instrumentation_amplifier_0.ota_slow_gmid_1.vout1.n8 two_stage_instrumentation_amplifier_0.ota_slow_gmid_1.vout1.t17 17.01
R11290 two_stage_instrumentation_amplifier_0.ota_slow_gmid_1.vout1.n8 two_stage_instrumentation_amplifier_0.ota_slow_gmid_1.vout1.n7 14.4641
R11291 two_stage_instrumentation_amplifier_0.ota_slow_gmid_1.vout1.n10 two_stage_instrumentation_amplifier_0.ota_slow_gmid_1.vout1.n9 12.8293
R11292 two_stage_instrumentation_amplifier_0.ota_slow_gmid_1.vout1.n17 two_stage_instrumentation_amplifier_0.ota_slow_gmid_1.vout1.n16 12.6923
R11293 two_stage_instrumentation_amplifier_0.ota_slow_gmid_1.vout1 two_stage_instrumentation_amplifier_0.ota_slow_gmid_1.vout1.n8 9.40045
R11294 two_stage_instrumentation_amplifier_0.ota_slow_gmid_1.vout1.n0 two_stage_instrumentation_amplifier_0.ota_slow_gmid_1.vout1.t13 7.70967
R11295 two_stage_instrumentation_amplifier_0.ota_slow_gmid_1.vout1.n11 two_stage_instrumentation_amplifier_0.ota_slow_gmid_1.vout1.t6 6.76573
R11296 two_stage_instrumentation_amplifier_0.ota_slow_gmid_1.vout1.n1 two_stage_instrumentation_amplifier_0.ota_slow_gmid_1.vout1.t5 6.76573
R11297 two_stage_instrumentation_amplifier_0.ota_slow_gmid_1.vout1.n15 two_stage_instrumentation_amplifier_0.ota_slow_gmid_1.vout1.t4 6.09448
R11298 two_stage_instrumentation_amplifier_0.ota_slow_gmid_1.vout1.n5 two_stage_instrumentation_amplifier_0.ota_slow_gmid_1.vout1.t11 6.09448
R11299 two_stage_instrumentation_amplifier_0.ota_slow_gmid_1.vout1.n14 two_stage_instrumentation_amplifier_0.ota_slow_gmid_1.vout1.t9 6.06448
R11300 two_stage_instrumentation_amplifier_0.ota_slow_gmid_1.vout1.n13 two_stage_instrumentation_amplifier_0.ota_slow_gmid_1.vout1.t0 6.06448
R11301 two_stage_instrumentation_amplifier_0.ota_slow_gmid_1.vout1.n12 two_stage_instrumentation_amplifier_0.ota_slow_gmid_1.vout1.t1 6.06448
R11302 two_stage_instrumentation_amplifier_0.ota_slow_gmid_1.vout1.n11 two_stage_instrumentation_amplifier_0.ota_slow_gmid_1.vout1.t10 6.06448
R11303 two_stage_instrumentation_amplifier_0.ota_slow_gmid_1.vout1.n2 two_stage_instrumentation_amplifier_0.ota_slow_gmid_1.vout1.t8 6.06448
R11304 two_stage_instrumentation_amplifier_0.ota_slow_gmid_1.vout1.n3 two_stage_instrumentation_amplifier_0.ota_slow_gmid_1.vout1.t2 6.06448
R11305 two_stage_instrumentation_amplifier_0.ota_slow_gmid_1.vout1.n4 two_stage_instrumentation_amplifier_0.ota_slow_gmid_1.vout1.t7 6.06448
R11306 two_stage_instrumentation_amplifier_0.ota_slow_gmid_1.vout1.n1 two_stage_instrumentation_amplifier_0.ota_slow_gmid_1.vout1.t3 6.06383
R11307 two_stage_instrumentation_amplifier_0.ota_slow_gmid_1.vout1 two_stage_instrumentation_amplifier_0.ota_slow_gmid_1.vout1.n0 5.9369
R11308 two_stage_instrumentation_amplifier_0.ota_slow_gmid_1.vout1.n0 two_stage_instrumentation_amplifier_0.ota_slow_gmid_1.vout1.t12 5.64781
R11309 two_stage_instrumentation_amplifier_0.ota_slow_gmid_1.vout1.n10 two_stage_instrumentation_amplifier_0.ota_slow_gmid_1.vout1.n5 5.5059
R11310 two_stage_instrumentation_amplifier_0.ota_slow_gmid_1.vout1.n16 two_stage_instrumentation_amplifier_0.ota_slow_gmid_1.vout1.n10 4.6623
R11311 two_stage_instrumentation_amplifier_0.ota_slow_gmid_1.vout1.n16 two_stage_instrumentation_amplifier_0.ota_slow_gmid_1.vout1.n15 4.5005
R11312 two_stage_instrumentation_amplifier_0.ota_slow_gmid_1.vout1.n18 two_stage_instrumentation_amplifier_0.ota_slow_gmid_1.vout1.n17 1.76476
R11313 two_stage_instrumentation_amplifier_0.ota_slow_gmid_1.vout1.n7 two_stage_instrumentation_amplifier_0.ota_slow_gmid_1.vout1.n6 1.69241
R11314 two_stage_instrumentation_amplifier_0.ota_slow_gmid_1.vout1.n12 two_stage_instrumentation_amplifier_0.ota_slow_gmid_1.vout1.n11 0.70175
R11315 two_stage_instrumentation_amplifier_0.ota_slow_gmid_1.vout1.n13 two_stage_instrumentation_amplifier_0.ota_slow_gmid_1.vout1.n12 0.70175
R11316 two_stage_instrumentation_amplifier_0.ota_slow_gmid_1.vout1.n14 two_stage_instrumentation_amplifier_0.ota_slow_gmid_1.vout1.n13 0.70175
R11317 two_stage_instrumentation_amplifier_0.ota_slow_gmid_1.vout1.n4 two_stage_instrumentation_amplifier_0.ota_slow_gmid_1.vout1.n3 0.70175
R11318 two_stage_instrumentation_amplifier_0.ota_slow_gmid_1.vout1.n3 two_stage_instrumentation_amplifier_0.ota_slow_gmid_1.vout1.n2 0.70175
R11319 two_stage_instrumentation_amplifier_0.ota_slow_gmid_1.vout1.n2 two_stage_instrumentation_amplifier_0.ota_slow_gmid_1.vout1.n1 0.70175
R11320 two_stage_instrumentation_amplifier_0.ota_slow_gmid_1.vout1.n15 two_stage_instrumentation_amplifier_0.ota_slow_gmid_1.vout1.n14 0.594875
R11321 two_stage_instrumentation_amplifier_0.ota_slow_gmid_1.vout1.n5 two_stage_instrumentation_amplifier_0.ota_slow_gmid_1.vout1.n4 0.594875
R11322 two_stage_instrumentation_amplifier_0.ota_slow_gmid_1.vout1.n9 two_stage_instrumentation_amplifier_0.ota_slow_gmid_1.vout1 0.1281
R11323 two_stage_instrumentation_amplifier_0.ota_slow_gmid_1.vout1.n9 two_stage_instrumentation_amplifier_0.ota_slow_gmid_1.vout1 0.0445
R11324 two_stage_instrumentation_amplifier_0.ota_slow_gmid_1.vout1 two_stage_instrumentation_amplifier_0.ota_slow_gmid_1.vout1.n18 0.0042931
R11325 non_inverting_amplifier_hv_0.ota_hv_slow_gmid_0.ota_hv_slow_gmid_pairs_0.vref non_inverting_amplifier_hv_0.ota_hv_slow_gmid_0.ota_hv_slow_gmid_mirror_0.vref 14.1135
R11326 non_inverting_amplifier_hv_0.ota_hv_slow_gmid_0.vref.n0 non_inverting_amplifier_hv_0.ota_hv_slow_gmid_0.vref.t1 13.4033
R11327 non_inverting_amplifier_hv_0.ota_hv_slow_gmid_0.vref.n0 non_inverting_amplifier_hv_0.ota_hv_slow_gmid_0.vref.t0 8.54893
R11328 non_inverting_amplifier_hv_0.ota_hv_slow_gmid_0.ota_hv_slow_gmid_mirror_0.vref non_inverting_amplifier_hv_0.ota_hv_slow_gmid_0.vref.n2 4.96492
R11329 non_inverting_amplifier_hv_0.ota_hv_slow_gmid_0.vref.n1 non_inverting_amplifier_hv_0.ota_hv_slow_gmid_0.vref.t3 3.33263
R11330 non_inverting_amplifier_hv_0.ota_hv_slow_gmid_0.vref.n2 non_inverting_amplifier_hv_0.ota_hv_slow_gmid_0.vref.n1 1.83957
R11331 non_inverting_amplifier_hv_0.ota_hv_slow_gmid_0.vref.n2 non_inverting_amplifier_hv_0.ota_hv_slow_gmid_0.vref.t4 1.38302
R11332 non_inverting_amplifier_hv_0.ota_hv_slow_gmid_0.ota_hv_slow_gmid_pairs_0.vref non_inverting_amplifier_hv_0.ota_hv_slow_gmid_0.vref.n0 0.106205
R11333 non_inverting_amplifier_hv_0.ota_hv_slow_gmid_0.vref.n1 non_inverting_amplifier_hv_0.ota_hv_slow_gmid_0.vref.t2 0.0101438
R11334 VBIAS.n19 VBIAS 38.7607
R11335 VBIAS.n19 VBIAS.n18 34.0073
R11336 VBIAS.n18 VBIAS.n16 14.184
R11337 VBIAS.n31 VBIAS.n30 14.184
R11338 VBIAS.n16 VBIAS.n10 10.1677
R11339 VBIAS.n30 VBIAS.n24 10.1677
R11340 VBIAS.n5 VBIAS 9.50662
R11341 VBIAS.n1 VBIAS.t25 9.25218
R11342 VBIAS.n2 VBIAS.t27 9.25218
R11343 VBIAS.n3 VBIAS.t24 9.25218
R11344 VBIAS.n4 VBIAS.t29 9.25218
R11345 VBIAS.n1 VBIAS.t26 9.14586
R11346 VBIAS.n2 VBIAS.t30 9.14586
R11347 VBIAS.n3 VBIAS.t28 9.14586
R11348 VBIAS.n4 VBIAS.t31 9.14586
R11349 VBIAS.n5 VBIAS.n0 7.64451
R11350 VBIAS VBIAS.t32 7.49578
R11351 VBIAS VBIAS.t33 7.49552
R11352 VBIAS VBIAS.t34 7.37012
R11353 VBIAS.n31 VBIAS.n19 7.33537
R11354 VBIAS.n11 VBIAS.t5 6.72866
R11355 VBIAS.n6 VBIAS.t11 6.72866
R11356 VBIAS.n20 VBIAS.t16 6.72866
R11357 VBIAS.n25 VBIAS.t20 6.72866
R11358 VBIAS.n15 VBIAS.t2 6.05884
R11359 VBIAS.n10 VBIAS.t10 6.05884
R11360 VBIAS.n24 VBIAS.t14 6.05884
R11361 VBIAS.n29 VBIAS.t22 6.05884
R11362 VBIAS.n11 VBIAS.t4 6.02741
R11363 VBIAS.n12 VBIAS.t1 6.02741
R11364 VBIAS.n13 VBIAS.t3 6.02741
R11365 VBIAS.n14 VBIAS.t0 6.02741
R11366 VBIAS.n9 VBIAS.t7 6.02741
R11367 VBIAS.n8 VBIAS.t6 6.02741
R11368 VBIAS.n7 VBIAS.t9 6.02741
R11369 VBIAS.n6 VBIAS.t8 6.02741
R11370 VBIAS.n20 VBIAS.t17 6.02741
R11371 VBIAS.n21 VBIAS.t13 6.02741
R11372 VBIAS.n22 VBIAS.t15 6.02741
R11373 VBIAS.n23 VBIAS.t12 6.02741
R11374 VBIAS.n28 VBIAS.t23 6.02741
R11375 VBIAS.n27 VBIAS.t19 6.02741
R11376 VBIAS.n26 VBIAS.t18 6.02741
R11377 VBIAS.n25 VBIAS.t21 6.02741
R11378 VBIAS.n18 VBIAS.n17 4.5665
R11379 VBIAS.n32 VBIAS.n31 4.5665
R11380 VBIAS.n16 VBIAS.n15 4.5005
R11381 VBIAS.n30 VBIAS.n29 4.5005
R11382 VBIAS.n32 VBIAS 4.1717
R11383 VBIAS.n17 VBIAS 4.0463
R11384 VBIAS.n0 VBIAS 4.0177
R11385 VBIAS VBIAS.n5 3.3163
R11386 VBIAS.n14 VBIAS.n13 0.70175
R11387 VBIAS.n13 VBIAS.n12 0.70175
R11388 VBIAS.n12 VBIAS.n11 0.70175
R11389 VBIAS.n7 VBIAS.n6 0.70175
R11390 VBIAS.n8 VBIAS.n7 0.70175
R11391 VBIAS.n9 VBIAS.n8 0.70175
R11392 VBIAS.n23 VBIAS.n22 0.70175
R11393 VBIAS.n22 VBIAS.n21 0.70175
R11394 VBIAS.n21 VBIAS.n20 0.70175
R11395 VBIAS.n26 VBIAS.n25 0.70175
R11396 VBIAS.n27 VBIAS.n26 0.70175
R11397 VBIAS.n28 VBIAS.n27 0.70175
R11398 VBIAS.n15 VBIAS.n14 0.603208
R11399 VBIAS.n10 VBIAS.n9 0.603208
R11400 VBIAS.n24 VBIAS.n23 0.603208
R11401 VBIAS.n29 VBIAS.n28 0.603208
R11402 VBIAS.n0 VBIAS 0.5461
R11403 VBIAS VBIAS.n4 0.532245
R11404 VBIAS.n17 VBIAS 0.5175
R11405 VBIAS VBIAS.n32 0.3943
R11406 VBIAS.n3 VBIAS.n2 0.382457
R11407 VBIAS.n2 VBIAS.n1 0.380585
R11408 VBIAS.n4 VBIAS.n3 0.380585
R11409 SEL_CAL.n0 SEL_CAL 64.4021
R11410 SEL_CAL.n0 SEL_CAL 22.536
R11411 SEL_CAL SEL_CAL.t0 3.61218
R11412 SEL_CAL SEL_CAL.n0 0.6785
R11413 ref_selector_0.ref_selector_r_96_0.vcal.n6 ref_selector_0.ref_selector_r_96_0.vcal.t1 17.4764
R11414 ref_selector_0.ref_selector_r_96_0.vcal.n7 ref_selector_0.ref_selector_r_96_0.vcal.t4 15.0005
R11415 ref_selector_0.ref_selector_r_96_0.vcal.n8 ref_selector_0.ref_selector_r_96_0.vcal.t7 15.0005
R11416 ref_selector_0.ref_selector_r_96_0.vcal.n9 ref_selector_0.ref_selector_r_96_0.vcal.t6 15.0005
R11417 ref_selector_0.ref_selector_r_96_0.vcal.n10 ref_selector_0.ref_selector_r_96_0.vcal.t5 15.0005
R11418 ref_selector_0.ref_selector_r_96_0.vcal.n6 ref_selector_0.ref_selector_r_96_0.vcal.t2 15.0005
R11419 ref_selector_0.ref_selector_r_96_0.vcal.n5 ref_selector_0.ref_selector_r_96_0.vcal.t11 15.0005
R11420 ref_selector_0.ref_selector_r_96_0.vcal.n3 ref_selector_0.ref_selector_r_96_0.vcal.t12 15.0005
R11421 ref_selector_0.ref_selector_r_96_0.vcal.n2 ref_selector_0.ref_selector_r_96_0.vcal.t3 15.0005
R11422 ref_selector_0.ref_selector_r_96_0.vcal.n4 ref_selector_0.ref_selector_r_96_0.vcal.t0 15.0005
R11423 ref_selector_0.ref_selector_r_96_0.vcal.n12 ref_selector_0.ref_selector_r_96_0.vcal.n5 12.0056
R11424 ref_selector_0.ref_selector_r_96_0.vcal.n12 ref_selector_0.ref_selector_r_96_0.vcal.n11 11.9487
R11425 ref_selector_0.ref_selector_r_96_0.vcal.n14 ref_selector_0.ref_selector_r_96_0.vcal.n1 9.3393
R11426 ref_selector_0.ref_selector_r_96_0.vcal.n0 ref_selector_0.ref_selector_r_96_0.vcal.t9 6.22031
R11427 ref_selector_0.ref_selector_r_96_0.vcal.n8 ref_selector_0.ref_selector_r_96_0.vcal.n7 5.38979
R11428 ref_selector_0.ref_selector_r_96_0.vcal.n0 ref_selector_0.ref_selector_r_96_0.vcal.t8 4.66294
R11429 ref_selector_0.ref_selector_r_96_0.vcal.n15 ref_selector_0.ref_selector_r_96_0.vcal.t10 2.72181
R11430 ref_selector_0.ref_selector_r_96_0.vcal.n2 ref_selector_0.ref_selector_r_96_0.vcal.n1 2.53371
R11431 ref_selector_0.ref_selector_r_96_0.vcal.n9 ref_selector_0.ref_selector_r_96_0.vcal.n8 2.47637
R11432 ref_selector_0.ref_selector_r_96_0.vcal.n10 ref_selector_0.ref_selector_r_96_0.vcal.n9 2.47637
R11433 ref_selector_0.ref_selector_r_96_0.vcal.n11 ref_selector_0.ref_selector_r_96_0.vcal.n10 2.4752
R11434 ref_selector_0.ref_selector_r_96_0.vcal.n5 ref_selector_0.ref_selector_r_96_0.vcal.n4 2.45304
R11435 ref_selector_0.ref_selector_r_96_0.vcal.n4 ref_selector_0.ref_selector_r_96_0.vcal.n3 0.4955
R11436 ref_selector_0.ref_selector_r_96_0.vcal.n3 ref_selector_0.ref_selector_r_96_0.vcal.n2 0.4955
R11437 ref_selector_0.ref_selector_r_96_0.vcal ref_selector_0.ref_selector_r_96_0.vcal.n15 0.320583
R11438 ref_selector_0.ref_selector_r_96_0.vcal ref_selector_0.ref_selector_r_96_0.vcal.n0 0.0930596
R11439 ref_selector_0.ref_selector_r_96_0.vcal.n13 ref_selector_0.ref_selector_r_96_0.vcal 0.0569823
R11440 ref_selector_0.ref_selector_r_96_0.vcal.n15 ref_selector_0.ref_selector_r_96_0.vcal.n14 0.0144067
R11441 ref_selector_0.ref_selector_r_96_0.vcal.n13 ref_selector_0.ref_selector_r_96_0.vcal.n12 0.0121869
R11442 ref_selector_0.ref_selector_r_96_0.vcal.n14 ref_selector_0.ref_selector_r_96_0.vcal.n13 0.011215
R11443 ref_selector_0.ref_selector_r_96_0.vcal.n7 ref_selector_0.ref_selector_r_96_0.vcal.n1 0.00416667
R11444 ref_selector_0.ref_selector_r_96_0.vcal.n11 ref_selector_0.ref_selector_r_96_0.vcal.n6 0.00167021
R11445 ref_selector_0.I1MA.n6 ref_selector_0.I1MA.t4 7.33053
R11446 ref_selector_0.I1MA.n6 ref_selector_0.I1MA.t12 7.33006
R11447 ref_selector_0.I1MA.n16 ref_selector_0.I1MA.n14 6.52622
R11448 ref_selector_0.I1MA ref_selector_0.I1MA.n5 6.48993
R11449 ref_selector_0.I1MA.n16 ref_selector_0.I1MA.n15 6.16938
R11450 ref_selector_0.I1MA.n15 ref_selector_0.I1MA.t5 4.25247
R11451 ref_selector_0.I1MA.n15 ref_selector_0.I1MA.t3 4.25172
R11452 ref_selector_0.I1MA.n11 ref_selector_0.I1MA.t9 4.23869
R11453 ref_selector_0.I1MA.n14 ref_selector_0.I1MA.t2 4.19961
R11454 ref_selector_0.I1MA.n5 ref_selector_0.I1MA.t1 4.19961
R11455 ref_selector_0.I1MA.n9 ref_selector_0.I1MA.t8 4.18678
R11456 ref_selector_0.I1MA.n13 ref_selector_0.I1MA.t11 4.08428
R11457 ref_selector_0.I1MA.n12 ref_selector_0.I1MA.t7 4.08428
R11458 ref_selector_0.I1MA.n7 ref_selector_0.I1MA.t10 4.08428
R11459 ref_selector_0.I1MA.n8 ref_selector_0.I1MA.t6 4.08428
R11460 ref_selector_0.I1MA.n11 ref_selector_0.I1MA.n10 3.51115
R11461 ref_selector_0.I1MA.n4 ref_selector_0.I1MA.t0 3.50547
R11462 ref_selector_0.I1MA.n10 ref_selector_0.I1MA.n9 3.50272
R11463 ref_selector_0.I1MA.n0 ref_selector_0.I1MA.t13 3.47572
R11464 ref_selector_0.I1MA.n32 ref_selector_0.I1MA.n31 1.5005
R11465 ref_selector_0.I1MA.n30 ref_selector_0.I1MA.n1 1.5005
R11466 ref_selector_0.I1MA.n29 ref_selector_0.I1MA.n28 1.5005
R11467 ref_selector_0.I1MA.n27 ref_selector_0.I1MA.n2 1.5005
R11468 ref_selector_0.I1MA.n26 ref_selector_0.I1MA.n25 1.5005
R11469 ref_selector_0.I1MA.n24 ref_selector_0.I1MA.n3 1.5005
R11470 ref_selector_0.I1MA.n23 ref_selector_0.I1MA.n22 1.5005
R11471 ref_selector_0.I1MA.n21 ref_selector_0.I1MA.n20 1.5005
R11472 ref_selector_0.I1MA.n19 ref_selector_0.I1MA.n18 1.5005
R11473 ref_selector_0.I1MA.n13 ref_selector_0.I1MA.n12 1.42554
R11474 ref_selector_0.I1MA.n8 ref_selector_0.I1MA.n7 1.42554
R11475 ref_selector_0.I1MA.n9 ref_selector_0.I1MA.n8 1.28376
R11476 ref_selector_0.I1MA.n14 ref_selector_0.I1MA.n13 1.26691
R11477 ref_selector_0.I1MA.n7 ref_selector_0.I1MA.n5 1.26691
R11478 ref_selector_0.I1MA.n12 ref_selector_0.I1MA.n11 1.21606
R11479 ref_selector_0.I1MA.n33 ref_selector_0.I1MA.n32 0.769015
R11480 ref_selector_0.I1MA.n18 ref_selector_0.I1MA.n17 0.513664
R11481 ref_selector_0.I1MA.n17 ref_selector_0.I1MA 0.234473
R11482 ref_selector_0.I1MA.n19 ref_selector_0.I1MA 0.180047
R11483 ref_selector_0.I1MA.n10 ref_selector_0.I1MA.n6 0.130965
R11484 ref_selector_0.I1MA ref_selector_0.I1MA.n16 0.029249
R11485 ref_selector_0.I1MA.n17 ref_selector_0.I1MA 0.0279189
R11486 ref_selector_0.I1MA.n33 ref_selector_0.I1MA.n0 0.0179516
R11487 ref_selector_0.I1MA.n21 ref_selector_0.I1MA.n18 0.0178115
R11488 ref_selector_0.I1MA.n22 ref_selector_0.I1MA.n21 0.0178115
R11489 ref_selector_0.I1MA.n22 ref_selector_0.I1MA.n3 0.0178115
R11490 ref_selector_0.I1MA.n26 ref_selector_0.I1MA.n3 0.0178115
R11491 ref_selector_0.I1MA.n27 ref_selector_0.I1MA.n26 0.0178115
R11492 ref_selector_0.I1MA.n28 ref_selector_0.I1MA.n27 0.0178115
R11493 ref_selector_0.I1MA.n28 ref_selector_0.I1MA.n1 0.0178115
R11494 ref_selector_0.I1MA.n32 ref_selector_0.I1MA.n1 0.0178115
R11495 ref_selector_0.I1MA.n20 ref_selector_0.I1MA.n19 0.0149658
R11496 ref_selector_0.I1MA.n24 ref_selector_0.I1MA.n23 0.0149658
R11497 ref_selector_0.I1MA.n25 ref_selector_0.I1MA.n24 0.0149658
R11498 ref_selector_0.I1MA.n25 ref_selector_0.I1MA.n2 0.0149658
R11499 ref_selector_0.I1MA.n29 ref_selector_0.I1MA.n2 0.0149658
R11500 ref_selector_0.I1MA.n30 ref_selector_0.I1MA.n29 0.0149658
R11501 ref_selector_0.I1MA.n31 ref_selector_0.I1MA.n30 0.0149658
R11502 ref_selector_0.I1MA.n20 ref_selector_0.I1MA.n4 0.0148151
R11503 ref_selector_0.I1MA ref_selector_0.I1MA.n33 0.0130616
R11504 ref_selector_0.I1MA.n31 ref_selector_0.I1MA.n0 0.00517123
R11505 ref_selector_0.I1MA.n23 ref_selector_0.I1MA.n4 0.000650685
R11506 two_stage_instrumentation_amplifier_0.ota_slow_gmid_0.en.n1 two_stage_instrumentation_amplifier_0.ota_slow_gmid_0.en.t3 28.3725
R11507 two_stage_instrumentation_amplifier_0.ota_slow_gmid_0.en.n1 two_stage_instrumentation_amplifier_0.ota_slow_gmid_0.en.t2 25.0065
R11508 two_stage_instrumentation_amplifier_0.ota_slow_gmid_0.ota_slow_gmid_ctrl_buff_0.ota_slow_gmid_ctrl_inv_0.y two_stage_instrumentation_amplifier_0.ota_slow_gmid_0.en.n1 5.42219
R11509 two_stage_instrumentation_amplifier_0.ota_slow_gmid_0.en.n0 two_stage_instrumentation_amplifier_0.ota_slow_gmid_0.en.t1 3.55057
R11510 two_stage_instrumentation_amplifier_0.ota_slow_gmid_0.en.n0 two_stage_instrumentation_amplifier_0.ota_slow_gmid_0.en.t0 3.47311
R11511 two_stage_instrumentation_amplifier_0.ota_slow_gmid_0.ota_slow_gmid_ctrl_buff_0.ota_slow_gmid_ctrl_inv_0.y two_stage_instrumentation_amplifier_0.ota_slow_gmid_0.en.n0 0.2865
R11512 non_inverting_amplifier_hv_0.ota_hv_slow_gmid_0.en_n.n0 non_inverting_amplifier_hv_0.ota_hv_slow_gmid_0.en_n.t7 12.5871
R11513 non_inverting_amplifier_hv_0.ota_hv_slow_gmid_0.en_n.n1 non_inverting_amplifier_hv_0.ota_hv_slow_gmid_0.en_n.n0 12.1393
R11514 non_inverting_amplifier_hv_0.ota_hv_slow_gmid_0.en_n.n6 non_inverting_amplifier_hv_0.ota_hv_slow_gmid_0.en_n.n5 10.7176
R11515 non_inverting_amplifier_hv_0.ota_hv_slow_gmid_0.en_n.n5 non_inverting_amplifier_hv_0.ota_hv_slow_gmid_0.en_n.n4 8.2471
R11516 non_inverting_amplifier_hv_0.ota_hv_slow_gmid_0.en_n.n4 non_inverting_amplifier_hv_0.ota_hv_slow_gmid_0.en_n.n3 6.53697
R11517 non_inverting_amplifier_hv_0.ota_hv_slow_gmid_0.en_n.n4 non_inverting_amplifier_hv_0.ota_hv_slow_gmid_0.en_n.n2 6.50374
R11518 non_inverting_amplifier_hv_0.ota_hv_slow_gmid_0.en_n.n1 non_inverting_amplifier_hv_0.ota_hv_slow_gmid_0.en_n.t1 5.58645
R11519 non_inverting_amplifier_hv_0.ota_hv_slow_gmid_0.en_n.n6 non_inverting_amplifier_hv_0.ota_hv_slow_gmid_0.en_n.t0 4.01101
R11520 non_inverting_amplifier_hv_0.ota_hv_slow_gmid_0.ota_hv_slow_gmid_ctrl_inv_0.A non_inverting_amplifier_hv_0.ota_hv_slow_gmid_0.en_n.t6 3.7941
R11521 non_inverting_amplifier_hv_0.ota_hv_slow_gmid_0.ota_hv_slow_gmid_ctrl_inv_1.Y non_inverting_amplifier_hv_0.ota_hv_slow_gmid_0.en_n.n1 0.618669
R11522 non_inverting_amplifier_hv_0.ota_hv_slow_gmid_0.en_n.n0 non_inverting_amplifier_hv_0.ota_hv_slow_gmid_0.en_n.t2 0.46401
R11523 non_inverting_amplifier_hv_0.ota_hv_slow_gmid_0.ota_hv_slow_gmid_ctrl_inv_1.Y non_inverting_amplifier_hv_0.ota_hv_slow_gmid_0.en_n.n6 0.172375
R11524 non_inverting_amplifier_hv_0.ota_hv_slow_gmid_0.en_n.n5 non_inverting_amplifier_hv_0.ota_hv_slow_gmid_0.ota_hv_slow_gmid_ctrl_inv_0.A 0.155935
R11525 non_inverting_amplifier_hv_0.ota_hv_slow_gmid_0.en_n.n6 non_inverting_amplifier_hv_0.ota_hv_slow_gmid_0.ota_hv_slow_gmid_ctrl_inv_1.Y 0.062375
R11526 non_inverting_amplifier_hv_0.ota_hv_slow_gmid_0.en_n.n6 non_inverting_amplifier_hv_0.ota_hv_slow_gmid_0.ota_hv_slow_gmid_ctrl_inv_1.Y 0.0555
R11527 non_inverting_amplifier_hv_0.ota_hv_slow_gmid_0.en_n.n2 non_inverting_amplifier_hv_0.ota_hv_slow_gmid_0.en_n.t8 0.00272068
R11528 non_inverting_amplifier_hv_0.ota_hv_slow_gmid_0.en_n.n3 non_inverting_amplifier_hv_0.ota_hv_slow_gmid_0.en_n.t5 0.00169561
R11529 non_inverting_amplifier_hv_0.ota_hv_slow_gmid_0.en_n.n3 non_inverting_amplifier_hv_0.ota_hv_slow_gmid_0.en_n.t3 0.00130437
R11530 non_inverting_amplifier_hv_0.ota_hv_slow_gmid_0.en_n.n2 non_inverting_amplifier_hv_0.ota_hv_slow_gmid_0.en_n.t4 0.00127919
R11531 non_inverting_amplifier_hv_0.ota_hv_slow_gmid_0.vamp.n0 non_inverting_amplifier_hv_0.ota_hv_slow_gmid_0.vamp.t3 18.4718
R11532 non_inverting_amplifier_hv_0.ota_hv_slow_gmid_0.vamp.n13 non_inverting_amplifier_hv_0.ota_hv_slow_gmid_0.vamp.t14 18.4718
R11533 non_inverting_amplifier_hv_0.ota_hv_slow_gmid_0.vamp.n0 non_inverting_amplifier_hv_0.ota_hv_slow_gmid_0.vamp.t11 17.3305
R11534 non_inverting_amplifier_hv_0.ota_hv_slow_gmid_0.vamp.n13 non_inverting_amplifier_hv_0.ota_hv_slow_gmid_0.vamp.t5 17.3305
R11535 non_inverting_amplifier_hv_0.ota_hv_slow_gmid_0.vamp.n1 non_inverting_amplifier_hv_0.ota_hv_slow_gmid_0.vamp.t15 17.0005
R11536 non_inverting_amplifier_hv_0.ota_hv_slow_gmid_0.vamp.n14 non_inverting_amplifier_hv_0.ota_hv_slow_gmid_0.vamp.t9 17.0005
R11537 non_inverting_amplifier_hv_0.ota_hv_slow_gmid_0.vamp.n8 non_inverting_amplifier_hv_0.ota_hv_slow_gmid_0.vamp.t17 14.5447
R11538 non_inverting_amplifier_hv_0.ota_hv_slow_gmid_0.vamp.n20 non_inverting_amplifier_hv_0.ota_hv_slow_gmid_0.vamp.n19 14.174
R11539 non_inverting_amplifier_hv_0.ota_hv_slow_gmid_0.vamp.n7 non_inverting_amplifier_hv_0.ota_hv_slow_gmid_0.vamp.t20 10.9907
R11540 non_inverting_amplifier_hv_0.ota_hv_slow_gmid_0.vamp.n2 non_inverting_amplifier_hv_0.ota_hv_slow_gmid_0.vamp.n1 9.33947
R11541 non_inverting_amplifier_hv_0.ota_hv_slow_gmid_0.vamp.n15 non_inverting_amplifier_hv_0.ota_hv_slow_gmid_0.vamp.n14 9.33947
R11542 non_inverting_amplifier_hv_0.ota_hv_slow_gmid_0.vamp.n11 non_inverting_amplifier_hv_0.ota_hv_slow_gmid_0.vamp.t21 7.80883
R11543 non_inverting_amplifier_hv_0.ota_hv_slow_gmid_0.vamp.n8 non_inverting_amplifier_hv_0.ota_hv_slow_gmid_0.vamp.n7 7.7505
R11544 non_inverting_amplifier_hv_0.ota_hv_slow_gmid_0.vamp.n11 non_inverting_amplifier_hv_0.ota_hv_slow_gmid_0.vamp.t22 7.48317
R11545 non_inverting_amplifier_hv_0.ota_hv_slow_gmid_0.vamp.n12 non_inverting_amplifier_hv_0.ota_hv_slow_gmid_0.ota_hv_slow_gmid_tail_0.vamp 7.37576
R11546 non_inverting_amplifier_hv_0.ota_hv_slow_gmid_0.vamp.n10 non_inverting_amplifier_hv_0.ota_hv_slow_gmid_0.vamp.t16 6.79355
R11547 non_inverting_amplifier_hv_0.ota_hv_slow_gmid_0.ota_hv_slow_gmid_buffer_0.vamp non_inverting_amplifier_hv_0.ota_hv_slow_gmid_0.vamp.n6 6.64265
R11548 non_inverting_amplifier_hv_0.ota_hv_slow_gmid_0.vamp.n22 non_inverting_amplifier_hv_0.ota_hv_slow_gmid_0.vamp.n21 5.97247
R11549 non_inverting_amplifier_hv_0.ota_hv_slow_gmid_0.ota_hv_slow_gmid_tail_0.vamp non_inverting_amplifier_hv_0.ota_hv_slow_gmid_0.vamp.n11 5.2727
R11550 non_inverting_amplifier_hv_0.ota_hv_slow_gmid_0.vamp.n17 non_inverting_amplifier_hv_0.ota_hv_slow_gmid_0.vamp.t7 3.45109
R11551 non_inverting_amplifier_hv_0.ota_hv_slow_gmid_0.vamp.n6 non_inverting_amplifier_hv_0.ota_hv_slow_gmid_0.vamp.t13 3.44986
R11552 non_inverting_amplifier_hv_0.ota_hv_slow_gmid_0.vamp.n5 non_inverting_amplifier_hv_0.ota_hv_slow_gmid_0.vamp.t10 3.44986
R11553 non_inverting_amplifier_hv_0.ota_hv_slow_gmid_0.vamp.n4 non_inverting_amplifier_hv_0.ota_hv_slow_gmid_0.vamp.t0 3.44986
R11554 non_inverting_amplifier_hv_0.ota_hv_slow_gmid_0.vamp.n3 non_inverting_amplifier_hv_0.ota_hv_slow_gmid_0.vamp.t4 3.44986
R11555 non_inverting_amplifier_hv_0.ota_hv_slow_gmid_0.vamp.n16 non_inverting_amplifier_hv_0.ota_hv_slow_gmid_0.vamp.t8 3.44986
R11556 non_inverting_amplifier_hv_0.ota_hv_slow_gmid_0.vamp.n18 non_inverting_amplifier_hv_0.ota_hv_slow_gmid_0.vamp.t2 3.44986
R11557 non_inverting_amplifier_hv_0.ota_hv_slow_gmid_0.vamp.n19 non_inverting_amplifier_hv_0.ota_hv_slow_gmid_0.vamp.t6 3.44986
R11558 non_inverting_amplifier_hv_0.ota_hv_slow_gmid_0.vamp.n2 non_inverting_amplifier_hv_0.ota_hv_slow_gmid_0.vamp.t1 2.89467
R11559 non_inverting_amplifier_hv_0.ota_hv_slow_gmid_0.vamp.n15 non_inverting_amplifier_hv_0.ota_hv_slow_gmid_0.vamp.t12 2.89467
R11560 non_inverting_amplifier_hv_0.ota_hv_slow_gmid_0.ota_hv_slow_gmid_mirror_0.vamp non_inverting_amplifier_hv_0.ota_hv_slow_gmid_0.vamp.n9 2.75342
R11561 non_inverting_amplifier_hv_0.ota_hv_slow_gmid_0.vamp.n12 non_inverting_amplifier_hv_0.ota_hv_slow_gmid_0.vamp.t23 2.38324
R11562 non_inverting_amplifier_hv_0.ota_hv_slow_gmid_0.vamp.n21 non_inverting_amplifier_hv_0.ota_hv_slow_gmid_0.vamp.n12 2.25691
R11563 non_inverting_amplifier_hv_0.ota_hv_slow_gmid_0.vamp.n21 non_inverting_amplifier_hv_0.ota_hv_slow_gmid_0.vamp.n20 1.98271
R11564 non_inverting_amplifier_hv_0.ota_hv_slow_gmid_0.vamp.n7 non_inverting_amplifier_hv_0.ota_hv_slow_gmid_0.vamp.t19 1.89935
R11565 non_inverting_amplifier_hv_0.ota_hv_slow_gmid_0.vamp.n3 non_inverting_amplifier_hv_0.ota_hv_slow_gmid_0.vamp.n2 1.62176
R11566 non_inverting_amplifier_hv_0.ota_hv_slow_gmid_0.vamp.n16 non_inverting_amplifier_hv_0.ota_hv_slow_gmid_0.vamp.n15 1.62176
R11567 non_inverting_amplifier_hv_0.ota_hv_slow_gmid_0.vamp.n1 non_inverting_amplifier_hv_0.ota_hv_slow_gmid_0.vamp.n0 1.43165
R11568 non_inverting_amplifier_hv_0.ota_hv_slow_gmid_0.vamp.n14 non_inverting_amplifier_hv_0.ota_hv_slow_gmid_0.vamp.n13 1.43165
R11569 non_inverting_amplifier_hv_0.ota_hv_slow_gmid_0.vamp.n10 non_inverting_amplifier_hv_0.ota_hv_slow_gmid_0.ota_hv_slow_gmid_mirror_0.vamp 1.40894
R11570 non_inverting_amplifier_hv_0.ota_hv_slow_gmid_0.vamp.n9 non_inverting_amplifier_hv_0.ota_hv_slow_gmid_0.vamp.t18 1.38426
R11571 non_inverting_amplifier_hv_0.ota_hv_slow_gmid_0.vamp.n4 non_inverting_amplifier_hv_0.ota_hv_slow_gmid_0.vamp.n3 1.14175
R11572 non_inverting_amplifier_hv_0.ota_hv_slow_gmid_0.vamp.n5 non_inverting_amplifier_hv_0.ota_hv_slow_gmid_0.vamp.n4 1.14175
R11573 non_inverting_amplifier_hv_0.ota_hv_slow_gmid_0.vamp.n6 non_inverting_amplifier_hv_0.ota_hv_slow_gmid_0.vamp.n5 1.14175
R11574 non_inverting_amplifier_hv_0.ota_hv_slow_gmid_0.vamp.n19 non_inverting_amplifier_hv_0.ota_hv_slow_gmid_0.vamp.n18 1.14175
R11575 non_inverting_amplifier_hv_0.ota_hv_slow_gmid_0.vamp.n18 non_inverting_amplifier_hv_0.ota_hv_slow_gmid_0.vamp.n17 1.14175
R11576 non_inverting_amplifier_hv_0.ota_hv_slow_gmid_0.vamp.n17 non_inverting_amplifier_hv_0.ota_hv_slow_gmid_0.vamp.n16 1.14175
R11577 non_inverting_amplifier_hv_0.ota_hv_slow_gmid_0.vamp.n9 non_inverting_amplifier_hv_0.ota_hv_slow_gmid_0.vamp.n8 0.422903
R11578 non_inverting_amplifier_hv_0.ota_hv_slow_gmid_0.vamp.n20 non_inverting_amplifier_hv_0.ota_hv_slow_gmid_0.vamp.t24 0.405285
R11579 non_inverting_amplifier_hv_0.ota_hv_slow_gmid_0.ota_hv_slow_gmid_buffer_0.vamp non_inverting_amplifier_hv_0.ota_hv_slow_gmid_0.vamp.n22 0.0374032
R11580 non_inverting_amplifier_hv_0.ota_hv_slow_gmid_0.vamp.n22 non_inverting_amplifier_hv_0.ota_hv_slow_gmid_0.vamp.n10 0.0175323
R11581 SEL_SENSOR.n0 SEL_SENSOR 68.7058
R11582 SEL_SENSOR.n0 SEL_SENSOR 30.7756
R11583 SEL_SENSOR SEL_SENSOR.t0 6.55016
R11584 SEL_SENSOR SEL_SENSOR.n0 0.8925
R11585 two_stage_instrumentation_amplifier_0.VP two_stage_instrumentation_amplifier_0.VP.n1 70.2962
R11586 two_stage_instrumentation_amplifier_0.VP.n1 two_stage_instrumentation_amplifier_0.VP 43.4427
R11587 two_stage_instrumentation_amplifier_0.VP.n1 two_stage_instrumentation_amplifier_0.VP 8.48399
R11588 two_stage_instrumentation_amplifier_0.VP.n0 two_stage_instrumentation_amplifier_0.VP.t2 6.6698
R11589 two_stage_instrumentation_amplifier_0.VP.n0 two_stage_instrumentation_amplifier_0.VP.t3 4.87123
R11590 two_stage_instrumentation_amplifier_0.VP two_stage_instrumentation_amplifier_0.VP.n0 3.8043
R11591 two_stage_instrumentation_amplifier_0.VP two_stage_instrumentation_amplifier_0.VP.n2 2.94245
R11592 two_stage_instrumentation_amplifier_0.VP.n2 two_stage_instrumentation_amplifier_0.VP.t1 2.27451
R11593 two_stage_instrumentation_amplifier_0.VP.n2 two_stage_instrumentation_amplifier_0.VP.t0 1.05268
R11594 SENSOR.n0 SENSOR.t0 2.87642
R11595 SENSOR.n0 SENSOR.t1 2.37194
R11596 SENSOR.n1 SENSOR 0.0952119
R11597 SENSOR SENSOR.n0 0.0926036
R11598 SENSOR SENSOR.n1 0.024743
R11599 SENSOR.n1 SENSOR 0.00209585
R11600 ota_lv_gmid_comparator_0.ota_slow_gmid_mirror_0.vout1.n10 ota_lv_gmid_comparator_0.ota_slow_gmid_mirror_0.vout1.t1 31.5136
R11601 ota_lv_gmid_comparator_0.ota_slow_gmid_mirror_0.vout1.n0 ota_lv_gmid_comparator_0.ota_slow_gmid_mirror_0.vout1.t14 25.518
R11602 ota_lv_gmid_comparator_0.ota_slow_gmid_mirror_0.vout1.n1 ota_lv_gmid_comparator_0.ota_slow_gmid_mirror_0.vout1.t16 24.0005
R11603 ota_lv_gmid_comparator_0.ota_slow_gmid_mirror_0.vout1.n11 ota_lv_gmid_comparator_0.ota_slow_gmid_mirror_0.vout1.t2 17.0903
R11604 ota_lv_gmid_comparator_0.ota_slow_gmid_mirror_0.vout1.n10 ota_lv_gmid_comparator_0.ota_slow_gmid_mirror_0.vout1.t0 17.0903
R11605 ota_lv_gmid_comparator_0.ota_slow_gmid_mirror_0.vout1.n12 ota_lv_gmid_comparator_0.ota_slow_gmid_mirror_0.vout1.t3 17.01
R11606 ota_lv_gmid_comparator_0.ota_slow_gmid_mirror_0.vout1.n8 ota_lv_gmid_comparator_0.ota_slow_gmid_mirror_0.vout1 16.6531
R11607 ota_lv_gmid_comparator_0.ota_slow_gmid_mirror_0.vout1.n9 ota_lv_gmid_comparator_0.ota_slow_gmid_mirror_0.vout1.n8 14.4679
R11608 ota_lv_gmid_comparator_0.ota_slow_gmid_mirror_0.vout1.n12 ota_lv_gmid_comparator_0.ota_slow_gmid_mirror_0.vout1.n11 14.4641
R11609 ota_lv_gmid_comparator_0.ota_slow_gmid_mirror_0.vout1 ota_lv_gmid_comparator_0.ota_slow_gmid_mirror_0.vout1.n12 9.40044
R11610 ota_lv_gmid_comparator_0.ota_slow_gmid_mirror_0.vout1.n6 ota_lv_gmid_comparator_0.ota_slow_gmid_mirror_0.vout1.t10 9.25218
R11611 ota_lv_gmid_comparator_0.ota_slow_gmid_mirror_0.vout1.n5 ota_lv_gmid_comparator_0.ota_slow_gmid_mirror_0.vout1.t12 9.25218
R11612 ota_lv_gmid_comparator_0.ota_slow_gmid_mirror_0.vout1.n4 ota_lv_gmid_comparator_0.ota_slow_gmid_mirror_0.vout1.t11 9.25218
R11613 ota_lv_gmid_comparator_0.ota_slow_gmid_mirror_0.vout1.n3 ota_lv_gmid_comparator_0.ota_slow_gmid_mirror_0.vout1.t8 9.25218
R11614 ota_lv_gmid_comparator_0.ota_slow_gmid_mirror_0.vout1.n6 ota_lv_gmid_comparator_0.ota_slow_gmid_mirror_0.vout1.t13 9.14586
R11615 ota_lv_gmid_comparator_0.ota_slow_gmid_mirror_0.vout1.n5 ota_lv_gmid_comparator_0.ota_slow_gmid_mirror_0.vout1.t7 9.14586
R11616 ota_lv_gmid_comparator_0.ota_slow_gmid_mirror_0.vout1.n4 ota_lv_gmid_comparator_0.ota_slow_gmid_mirror_0.vout1.t6 9.14586
R11617 ota_lv_gmid_comparator_0.ota_slow_gmid_mirror_0.vout1.n3 ota_lv_gmid_comparator_0.ota_slow_gmid_mirror_0.vout1.t9 9.14586
R11618 ota_lv_gmid_comparator_0.ota_slow_gmid_mirror_0.vout1.n2 ota_lv_gmid_comparator_0.ota_slow_gmid_mirror_0.vout1.t4 7.70967
R11619 ota_lv_gmid_comparator_0.ota_slow_gmid_mirror_0.vout1.n0 ota_lv_gmid_comparator_0.ota_slow_gmid_mirror_0.vout1.t15 6.61988
R11620 ota_lv_gmid_comparator_0.ota_slow_gmid_mirror_0.vout1 ota_lv_gmid_comparator_0.ota_slow_gmid_mirror_0.vout1.n2 5.9369
R11621 ota_lv_gmid_comparator_0.ota_slow_gmid_mirror_0.vout1.n2 ota_lv_gmid_comparator_0.ota_slow_gmid_mirror_0.vout1.t5 5.64781
R11622 ota_lv_gmid_comparator_0.ota_slow_gmid_mirror_0.vout1.n8 ota_lv_gmid_comparator_0.ota_slow_gmid_mirror_0.vout1.n7 4.7645
R11623 ota_lv_gmid_comparator_0.ota_slow_gmid_mirror_0.vout1.n9 ota_lv_gmid_comparator_0.ota_slow_gmid_mirror_0.vout1.n1 2.33849
R11624 ota_lv_gmid_comparator_0.ota_slow_gmid_mirror_0.vout1 ota_lv_gmid_comparator_0.ota_slow_gmid_mirror_0.vout1.n9 2.27825
R11625 ota_lv_gmid_comparator_0.ota_slow_gmid_mirror_0.vout1.n11 ota_lv_gmid_comparator_0.ota_slow_gmid_mirror_0.vout1.n10 1.69241
R11626 ota_lv_gmid_comparator_0.ota_slow_gmid_mirror_0.vout1.n1 ota_lv_gmid_comparator_0.ota_slow_gmid_mirror_0.vout1 1.13084
R11627 ota_lv_gmid_comparator_0.ota_slow_gmid_mirror_0.vout1 ota_lv_gmid_comparator_0.ota_slow_gmid_mirror_0.vout1.n6 0.431138
R11628 ota_lv_gmid_comparator_0.ota_slow_gmid_mirror_0.vout1 ota_lv_gmid_comparator_0.ota_slow_gmid_mirror_0.vout1.n0 0.389879
R11629 ota_lv_gmid_comparator_0.ota_slow_gmid_mirror_0.vout1.n5 ota_lv_gmid_comparator_0.ota_slow_gmid_mirror_0.vout1.n4 0.382457
R11630 ota_lv_gmid_comparator_0.ota_slow_gmid_mirror_0.vout1.n6 ota_lv_gmid_comparator_0.ota_slow_gmid_mirror_0.vout1.n5 0.380585
R11631 ota_lv_gmid_comparator_0.ota_slow_gmid_mirror_0.vout1.n4 ota_lv_gmid_comparator_0.ota_slow_gmid_mirror_0.vout1.n3 0.380585
R11632 ota_lv_gmid_comparator_0.ota_slow_gmid_mirror_0.vout1.n7 ota_lv_gmid_comparator_0.ota_slow_gmid_mirror_0.vout1 0.0267128
R11633 ota_lv_gmid_comparator_0.ota_slow_gmid_mirror_0.vout1.n7 ota_lv_gmid_comparator_0.ota_slow_gmid_mirror_0.vout1 0.0261667
R11634 a_n17403_4529.t0 a_n17403_4529.t1 32.8154
R11635 a_n17104_4821.t0 a_n17104_4821.t1 30.5928
R11636 current_source_1mA_0.current_source_1mA_2_stage_0.current_source_pass_element_0.iref current_source_1mA_0.current_source_1mA_2_stage_0.current_source_pass_element_0.iref.n15 20.8023
R11637 current_source_1mA_0.current_source_1mA_2_stage_0.current_source_pass_element_0.iref.n10 current_source_1mA_0.current_source_1mA_2_stage_0.current_source_pass_element_0.iref.n4 16.5675
R11638 current_source_1mA_0.current_source_1mA_2_stage_0.current_source_pass_element_0.iref.n14 current_source_1mA_0.current_source_1mA_2_stage_0.current_source_pass_element_0.iref.n4 16.5661
R11639 current_source_1mA_0.current_source_1mA_2_stage_0.current_source_pass_element_0.iref.n12 current_source_1mA_0.current_source_1mA_2_stage_0.current_source_pass_element_0.iref.n10 13.103
R11640 current_source_1mA_0.current_source_1mA_2_stage_0.current_source_pass_element_0.iref.n14 current_source_1mA_0.current_source_1mA_2_stage_0.current_source_pass_element_0.iref.n13 13.1026
R11641 current_source_1mA_0.current_source_1mA_2_stage_0.current_source_pass_element_0.iref.n10 current_source_1mA_0.current_source_1mA_2_stage_0.current_source_pass_element_0.iref.n3 11.9959
R11642 current_source_1mA_0.current_source_1mA_2_stage_0.current_source_pass_element_0.iref.n15 current_source_1mA_0.current_source_1mA_2_stage_0.current_source_pass_element_0.iref.n14 10.1715
R11643 current_source_1mA_0.current_source_1mA_2_stage_0.current_source_pass_element_0.iref.n6 current_source_1mA_0.current_source_1mA_2_stage_0.current_source_pass_element_0.iref.t10 9.37443
R11644 current_source_1mA_0.current_source_1mA_2_stage_0.current_source_pass_element_0.iref.n5 current_source_1mA_0.current_source_1mA_2_stage_0.current_source_pass_element_0.iref.t7 9.37443
R11645 current_source_1mA_0.current_source_1mA_2_stage_0.current_source_pass_element_0.iref.n6 current_source_1mA_0.current_source_1mA_2_stage_0.current_source_pass_element_0.iref.t9 8.80502
R11646 current_source_1mA_0.current_source_1mA_2_stage_0.current_source_pass_element_0.iref.n5 current_source_1mA_0.current_source_1mA_2_stage_0.current_source_pass_element_0.iref.t8 8.80502
R11647 current_source_1mA_0.current_source_1mA_2_stage_0.current_source_pass_element_0.iref.n8 current_source_1mA_0.current_source_1mA_2_stage_0.current_source_pass_element_0.iref 6.85652
R11648 current_source_1mA_0.current_source_1mA_2_stage_0.current_source_pass_element_0.iref.n13 current_source_1mA_0.current_source_1mA_2_stage_0.current_source_pass_element_0.iref.t4 4.89726
R11649 current_source_1mA_0.current_source_1mA_2_stage_0.current_source_pass_element_0.iref.t4 current_source_1mA_0.current_source_1mA_2_stage_0.current_source_pass_element_0.iref.n12 4.89714
R11650 current_source_1mA_0.current_source_1mA_2_stage_0.current_source_pass_element_0.iref.n11 current_source_1mA_0.current_source_1mA_2_stage_0.current_source_pass_element_0.iref.t6 4.73448
R11651 current_source_1mA_0.current_source_1mA_2_stage_0.current_source_pass_element_0.iref.n0 current_source_1mA_0.current_source_1mA_2_stage_0.current_source_pass_element_0.iref.t3 4.37071
R11652 current_source_1mA_0.current_source_1mA_2_stage_0.current_source_pass_element_0.iref.n13 current_source_1mA_0.current_source_1mA_2_stage_0.current_source_pass_element_0.iref.n9 4.14488
R11653 current_source_1mA_0.current_source_1mA_2_stage_0.current_source_pass_element_0.iref.n12 current_source_1mA_0.current_source_1mA_2_stage_0.current_source_pass_element_0.iref.n11 4.14434
R11654 current_source_1mA_0.current_source_1mA_2_stage_0.current_source_pass_element_0.iref.n8 current_source_1mA_0.current_source_1mA_2_stage_0.current_source_pass_element_0.iref.t5 4.13787
R11655 current_source_1mA_0.current_source_1mA_2_stage_0.current_source_pass_element_0.iref current_source_1mA_0.current_source_1mA_2_stage_0.current_source_pass_element_0.iref.n2 4.07525
R11656 current_source_1mA_0.current_source_1mA_2_stage_0.current_source_pass_element_0.iref.t4 current_source_1mA_0.current_source_1mA_2_stage_0.current_source_pass_element_0.iref.n3 3.58864
R11657 current_source_1mA_0.current_source_1mA_2_stage_0.current_source_pass_element_0.iref.n0 current_source_1mA_0.current_source_1mA_2_stage_0.current_source_pass_element_0.iref.t1 3.41985
R11658 current_source_1mA_0.current_source_1mA_2_stage_0.current_source_pass_element_0.iref.n1 current_source_1mA_0.current_source_1mA_2_stage_0.current_source_pass_element_0.iref.t0 3.41985
R11659 current_source_1mA_0.current_source_1mA_2_stage_0.current_source_pass_element_0.iref.n2 current_source_1mA_0.current_source_1mA_2_stage_0.current_source_pass_element_0.iref.t2 2.86887
R11660 current_source_1mA_0.current_source_1mA_2_stage_0.current_source_pass_element_0.iref.n15 current_source_1mA_0.current_source_1mA_2_stage_0.current_source_pass_element_0.iref.n3 1.82457
R11661 current_source_1mA_0.current_source_1mA_2_stage_0.current_source_pass_element_0.iref current_source_1mA_0.current_source_1mA_2_stage_0.current_source_pass_element_0.iref.n7 1.7805
R11662 current_source_1mA_0.current_source_1mA_2_stage_0.current_source_pass_element_0.iref.n2 current_source_1mA_0.current_source_1mA_2_stage_0.current_source_pass_element_0.iref.n1 1.43496
R11663 current_source_1mA_0.current_source_1mA_2_stage_0.current_source_pass_element_0.iref.t4 current_source_1mA_0.current_source_1mA_2_stage_0.current_source_pass_element_0.iref.n4 1.30474
R11664 current_source_1mA_0.current_source_1mA_2_stage_0.current_source_pass_element_0.iref.n1 current_source_1mA_0.current_source_1mA_2_stage_0.current_source_pass_element_0.iref.n0 0.953833
R11665 current_source_1mA_0.current_source_1mA_2_stage_0.current_source_pass_element_0.iref.n9 current_source_1mA_0.current_source_1mA_2_stage_0.current_source_pass_element_0.iref.n8 0.578397
R11666 current_source_1mA_0.current_source_1mA_2_stage_0.current_source_pass_element_0.iref.n11 current_source_1mA_0.current_source_1mA_2_stage_0.current_source_pass_element_0.iref.n9 0.382605
R11667 current_source_1mA_0.current_source_1mA_2_stage_0.current_source_pass_element_0.iref.n7 current_source_1mA_0.current_source_1mA_2_stage_0.current_source_pass_element_0.iref.n5 0.285206
R11668 current_source_1mA_0.current_source_1mA_2_stage_0.current_source_pass_element_0.iref.n7 current_source_1mA_0.current_source_1mA_2_stage_0.current_source_pass_element_0.iref.n6 0.285206
R11669 two_stage_instrumentation_amplifier_0.top_conditionning_gain_s1_0.vamp1 two_stage_instrumentation_amplifier_0.vamp1.t0 18.7384
R11670 two_stage_instrumentation_amplifier_0.top_conditionning_gain_s2_0.vamp1 two_stage_instrumentation_amplifier_0.vamp1.t62 18.6605
R11671 two_stage_instrumentation_amplifier_0.vamp1.n6 two_stage_instrumentation_amplifier_0.vamp1.t50 17.2374
R11672 two_stage_instrumentation_amplifier_0.vamp1.n2 two_stage_instrumentation_amplifier_0.vamp1.t10 17.0005
R11673 two_stage_instrumentation_amplifier_0.vamp1.n2 two_stage_instrumentation_amplifier_0.vamp1.t53 17.0005
R11674 two_stage_instrumentation_amplifier_0.vamp1.n1 two_stage_instrumentation_amplifier_0.vamp1.t45 17.0005
R11675 two_stage_instrumentation_amplifier_0.vamp1.n1 two_stage_instrumentation_amplifier_0.vamp1.t29 17.0005
R11676 two_stage_instrumentation_amplifier_0.vamp1.n0 two_stage_instrumentation_amplifier_0.vamp1.t20 17.0005
R11677 two_stage_instrumentation_amplifier_0.vamp1.n0 two_stage_instrumentation_amplifier_0.vamp1.t4 17.0005
R11678 two_stage_instrumentation_amplifier_0.vamp1.n3 two_stage_instrumentation_amplifier_0.vamp1.t34 17.0005
R11679 two_stage_instrumentation_amplifier_0.vamp1.n6 two_stage_instrumentation_amplifier_0.vamp1.t12 17.0005
R11680 two_stage_instrumentation_amplifier_0.vamp1.n7 two_stage_instrumentation_amplifier_0.vamp1.t36 17.0005
R11681 two_stage_instrumentation_amplifier_0.vamp1.n17 two_stage_instrumentation_amplifier_0.vamp1.t5 17.0005
R11682 two_stage_instrumentation_amplifier_0.vamp1.n17 two_stage_instrumentation_amplifier_0.vamp1.t31 17.0005
R11683 two_stage_instrumentation_amplifier_0.vamp1.n16 two_stage_instrumentation_amplifier_0.vamp1.t46 17.0005
R11684 two_stage_instrumentation_amplifier_0.vamp1.n16 two_stage_instrumentation_amplifier_0.vamp1.t6 17.0005
R11685 two_stage_instrumentation_amplifier_0.vamp1.n15 two_stage_instrumentation_amplifier_0.vamp1.t21 17.0005
R11686 two_stage_instrumentation_amplifier_0.vamp1.n15 two_stage_instrumentation_amplifier_0.vamp1.t47 17.0005
R11687 two_stage_instrumentation_amplifier_0.vamp1.n14 two_stage_instrumentation_amplifier_0.vamp1.t56 17.0005
R11688 two_stage_instrumentation_amplifier_0.vamp1.n14 two_stage_instrumentation_amplifier_0.vamp1.t22 17.0005
R11689 two_stage_instrumentation_amplifier_0.vamp1.n13 two_stage_instrumentation_amplifier_0.vamp1.t37 17.0005
R11690 two_stage_instrumentation_amplifier_0.vamp1.n13 two_stage_instrumentation_amplifier_0.vamp1.t57 17.0005
R11691 two_stage_instrumentation_amplifier_0.vamp1.n12 two_stage_instrumentation_amplifier_0.vamp1.t8 17.0005
R11692 two_stage_instrumentation_amplifier_0.vamp1.n12 two_stage_instrumentation_amplifier_0.vamp1.t33 17.0005
R11693 two_stage_instrumentation_amplifier_0.vamp1.n11 two_stage_instrumentation_amplifier_0.vamp1.t48 17.0005
R11694 two_stage_instrumentation_amplifier_0.vamp1.n11 two_stage_instrumentation_amplifier_0.vamp1.t9 17.0005
R11695 two_stage_instrumentation_amplifier_0.vamp1.n10 two_stage_instrumentation_amplifier_0.vamp1.t24 17.0005
R11696 two_stage_instrumentation_amplifier_0.vamp1.n10 two_stage_instrumentation_amplifier_0.vamp1.t49 17.0005
R11697 two_stage_instrumentation_amplifier_0.vamp1.n9 two_stage_instrumentation_amplifier_0.vamp1.t59 17.0005
R11698 two_stage_instrumentation_amplifier_0.vamp1.n9 two_stage_instrumentation_amplifier_0.vamp1.t26 17.0005
R11699 two_stage_instrumentation_amplifier_0.vamp1.n8 two_stage_instrumentation_amplifier_0.vamp1.t39 17.0005
R11700 two_stage_instrumentation_amplifier_0.vamp1.n8 two_stage_instrumentation_amplifier_0.vamp1.t61 17.0005
R11701 two_stage_instrumentation_amplifier_0.vamp1.n18 two_stage_instrumentation_amplifier_0.vamp1.t14 17.0005
R11702 two_stage_instrumentation_amplifier_0.vamp1.n21 two_stage_instrumentation_amplifier_0.vamp1.t13 17.0005
R11703 two_stage_instrumentation_amplifier_0.vamp1.n21 two_stage_instrumentation_amplifier_0.vamp1.t23 17.0005
R11704 two_stage_instrumentation_amplifier_0.vamp1.n20 two_stage_instrumentation_amplifier_0.vamp1.t51 17.0005
R11705 two_stage_instrumentation_amplifier_0.vamp1.n20 two_stage_instrumentation_amplifier_0.vamp1.t58 17.0005
R11706 two_stage_instrumentation_amplifier_0.vamp1.n19 two_stage_instrumentation_amplifier_0.vamp1.t30 17.0005
R11707 two_stage_instrumentation_amplifier_0.vamp1.n19 two_stage_instrumentation_amplifier_0.vamp1.t38 17.0005
R11708 two_stage_instrumentation_amplifier_0.vamp1.n23 two_stage_instrumentation_amplifier_0.vamp1.t28 17.0005
R11709 two_stage_instrumentation_amplifier_0.vamp1.n22 two_stage_instrumentation_amplifier_0.vamp1.t19 17.0005
R11710 two_stage_instrumentation_amplifier_0.vamp1.n24 two_stage_instrumentation_amplifier_0.vamp1.t3 17.0005
R11711 two_stage_instrumentation_amplifier_0.vamp1.n25 two_stage_instrumentation_amplifier_0.vamp1.t43 17.0005
R11712 two_stage_instrumentation_amplifier_0.vamp1.n25 two_stage_instrumentation_amplifier_0.vamp1.t35 17.0005
R11713 two_stage_instrumentation_amplifier_0.vamp1.n26 two_stage_instrumentation_amplifier_0.vamp1.t17 17.0005
R11714 two_stage_instrumentation_amplifier_0.vamp1.n26 two_stage_instrumentation_amplifier_0.vamp1.t11 17.0005
R11715 two_stage_instrumentation_amplifier_0.vamp1.n27 two_stage_instrumentation_amplifier_0.vamp1.t42 17.0005
R11716 two_stage_instrumentation_amplifier_0.vamp1.n27 two_stage_instrumentation_amplifier_0.vamp1.t25 17.0005
R11717 two_stage_instrumentation_amplifier_0.vamp1.n28 two_stage_instrumentation_amplifier_0.vamp1.t16 17.0005
R11718 two_stage_instrumentation_amplifier_0.vamp1.n28 two_stage_instrumentation_amplifier_0.vamp1.t60 17.0005
R11719 two_stage_instrumentation_amplifier_0.vamp1.n29 two_stage_instrumentation_amplifier_0.vamp1.t54 17.0005
R11720 two_stage_instrumentation_amplifier_0.vamp1.n29 two_stage_instrumentation_amplifier_0.vamp1.t40 17.0005
R11721 two_stage_instrumentation_amplifier_0.vamp1.n30 two_stage_instrumentation_amplifier_0.vamp1.t32 17.0005
R11722 two_stage_instrumentation_amplifier_0.vamp1.n30 two_stage_instrumentation_amplifier_0.vamp1.t15 17.0005
R11723 two_stage_instrumentation_amplifier_0.vamp1.n31 two_stage_instrumentation_amplifier_0.vamp1.t7 17.0005
R11724 two_stage_instrumentation_amplifier_0.vamp1.n31 two_stage_instrumentation_amplifier_0.vamp1.t52 17.0005
R11725 two_stage_instrumentation_amplifier_0.vamp1.n32 two_stage_instrumentation_amplifier_0.vamp1.t44 17.0005
R11726 two_stage_instrumentation_amplifier_0.vamp1.n32 two_stage_instrumentation_amplifier_0.vamp1.t27 17.0005
R11727 two_stage_instrumentation_amplifier_0.vamp1.n5 two_stage_instrumentation_amplifier_0.vamp1.t18 17.0005
R11728 two_stage_instrumentation_amplifier_0.vamp1.n5 two_stage_instrumentation_amplifier_0.vamp1.t2 17.0005
R11729 two_stage_instrumentation_amplifier_0.vamp1.n4 two_stage_instrumentation_amplifier_0.vamp1.t55 17.0005
R11730 two_stage_instrumentation_amplifier_0.vamp1.n4 two_stage_instrumentation_amplifier_0.vamp1.t41 17.0005
R11731 two_stage_instrumentation_amplifier_0.vamp1.n0 two_stage_instrumentation_amplifier_0.vamp1.t1 15.7731
R11732 two_stage_instrumentation_amplifier_0.vamp1.n34 two_stage_instrumentation_amplifier_0.top_conditionning_gain_s2_0.vamp1 6.62496
R11733 two_stage_instrumentation_amplifier_0.top_conditionning_gain_s1_0.vamp1 two_stage_instrumentation_amplifier_0.vamp1.n34 4.3359
R11734 two_stage_instrumentation_amplifier_0.vamp1.n34 two_stage_instrumentation_amplifier_0.ota_slow_gmid_1.VOUT 3.09066
R11735 two_stage_instrumentation_amplifier_0.ota_slow_gmid_1.ota_slow_gmid_buffer_0.vout two_stage_instrumentation_amplifier_0.vamp1.n33 2.73089
R11736 two_stage_instrumentation_amplifier_0.vamp1.n22 two_stage_instrumentation_amplifier_0.vamp1.n21 1.64354
R11737 two_stage_instrumentation_amplifier_0.vamp1.n3 two_stage_instrumentation_amplifier_0.vamp1.n2 0.618486
R11738 two_stage_instrumentation_amplifier_0.vamp1.n4 two_stage_instrumentation_amplifier_0.vamp1.n3 0.618486
R11739 two_stage_instrumentation_amplifier_0.vamp1.n8 two_stage_instrumentation_amplifier_0.vamp1.n7 0.618486
R11740 two_stage_instrumentation_amplifier_0.vamp1.n18 two_stage_instrumentation_amplifier_0.vamp1.n17 0.618486
R11741 two_stage_instrumentation_amplifier_0.vamp1.n19 two_stage_instrumentation_amplifier_0.vamp1.n18 0.618486
R11742 two_stage_instrumentation_amplifier_0.vamp1.n25 two_stage_instrumentation_amplifier_0.vamp1.n24 0.618486
R11743 two_stage_instrumentation_amplifier_0.vamp1.n7 two_stage_instrumentation_amplifier_0.vamp1.n6 0.598625
R11744 two_stage_instrumentation_amplifier_0.vamp1.n24 two_stage_instrumentation_amplifier_0.vamp1.n23 0.598625
R11745 two_stage_instrumentation_amplifier_0.vamp1.n1 two_stage_instrumentation_amplifier_0.vamp1.n0 0.153278
R11746 two_stage_instrumentation_amplifier_0.vamp1.n2 two_stage_instrumentation_amplifier_0.vamp1.n1 0.153278
R11747 two_stage_instrumentation_amplifier_0.vamp1.n9 two_stage_instrumentation_amplifier_0.vamp1.n8 0.153278
R11748 two_stage_instrumentation_amplifier_0.vamp1.n10 two_stage_instrumentation_amplifier_0.vamp1.n9 0.153278
R11749 two_stage_instrumentation_amplifier_0.vamp1.n11 two_stage_instrumentation_amplifier_0.vamp1.n10 0.153278
R11750 two_stage_instrumentation_amplifier_0.vamp1.n12 two_stage_instrumentation_amplifier_0.vamp1.n11 0.153278
R11751 two_stage_instrumentation_amplifier_0.vamp1.n13 two_stage_instrumentation_amplifier_0.vamp1.n12 0.153278
R11752 two_stage_instrumentation_amplifier_0.vamp1.n14 two_stage_instrumentation_amplifier_0.vamp1.n13 0.153278
R11753 two_stage_instrumentation_amplifier_0.vamp1.n15 two_stage_instrumentation_amplifier_0.vamp1.n14 0.153278
R11754 two_stage_instrumentation_amplifier_0.vamp1.n16 two_stage_instrumentation_amplifier_0.vamp1.n15 0.153278
R11755 two_stage_instrumentation_amplifier_0.vamp1.n17 two_stage_instrumentation_amplifier_0.vamp1.n16 0.153278
R11756 two_stage_instrumentation_amplifier_0.vamp1.n20 two_stage_instrumentation_amplifier_0.vamp1.n19 0.153278
R11757 two_stage_instrumentation_amplifier_0.vamp1.n21 two_stage_instrumentation_amplifier_0.vamp1.n20 0.153278
R11758 two_stage_instrumentation_amplifier_0.vamp1.n5 two_stage_instrumentation_amplifier_0.vamp1.n4 0.153278
R11759 two_stage_instrumentation_amplifier_0.vamp1.n32 two_stage_instrumentation_amplifier_0.vamp1.n31 0.153278
R11760 two_stage_instrumentation_amplifier_0.vamp1.n31 two_stage_instrumentation_amplifier_0.vamp1.n30 0.153278
R11761 two_stage_instrumentation_amplifier_0.vamp1.n30 two_stage_instrumentation_amplifier_0.vamp1.n29 0.153278
R11762 two_stage_instrumentation_amplifier_0.vamp1.n29 two_stage_instrumentation_amplifier_0.vamp1.n28 0.153278
R11763 two_stage_instrumentation_amplifier_0.vamp1.n28 two_stage_instrumentation_amplifier_0.vamp1.n27 0.153278
R11764 two_stage_instrumentation_amplifier_0.vamp1.n27 two_stage_instrumentation_amplifier_0.vamp1.n26 0.153278
R11765 two_stage_instrumentation_amplifier_0.vamp1.n26 two_stage_instrumentation_amplifier_0.vamp1.n25 0.153278
R11766 two_stage_instrumentation_amplifier_0.vamp1.n23 two_stage_instrumentation_amplifier_0.vamp1.n22 0.101484
R11767 two_stage_instrumentation_amplifier_0.vamp1.n33 two_stage_instrumentation_amplifier_0.vamp1.n5 0.0807083
R11768 two_stage_instrumentation_amplifier_0.vamp1.n33 two_stage_instrumentation_amplifier_0.vamp1.n32 0.0730694
R11769 two_stage_instrumentation_amplifier_0.ota_slow_gmid_1.VOUT two_stage_instrumentation_amplifier_0.ota_slow_gmid_1.ota_slow_gmid_buffer_0.vout 0.0661393
R11770 a_n9604_1483.t0 a_n9604_1483.t1 30.5717
R11771 a_n9874_1205.t0 a_n9874_1205.t1 30.5717
R11772 a_7225_719.t0 a_7225_719.t1 30.5717
R11773 a_7631_719.t0 a_7631_719.t1 33.6319
R11774 VOUT VOUT.t1 25.2513
R11775 VOUT.n2 VOUT.t3 11.6236
R11776 VOUT.n0 VOUT.t6 11.6149
R11777 VOUT.n0 VOUT.t0 10.7636
R11778 VOUT.n2 VOUT.t5 10.4388
R11779 VOUT.n1 VOUT.t7 10.4302
R11780 VOUT.n0 VOUT.t2 10.4302
R11781 VOUT.n3 VOUT.t4 10.2232
R11782 VOUT VOUT.n6 8.84489
R11783 VOUT VOUT.n5 7.54475
R11784 VOUT.n3 VOUT.n2 1.40088
R11785 VOUT VOUT.n4 1.22202
R11786 VOUT.n1 VOUT.n0 1.18528
R11787 VOUT.n4 VOUT.n3 0.9201
R11788 VOUT.n4 VOUT.n1 0.4625
R11789 VOUT.n5 VOUT 0.0347222
R11790 VOUT.n6 VOUT 0.0271667
R11791 VOUT.n5 VOUT 0.0235476
R11792 VOUT.n6 VOUT 0.0137
R11793 ota_lv_gmid_comparator_0.ota_slow_gmid_ctrl_buff_0.x.n5 ota_lv_gmid_comparator_0.ota_slow_gmid_ctrl_buff_0.x.t7 25.1081
R11794 ota_lv_gmid_comparator_0.ota_slow_gmid_ctrl_buff_0.x.n7 ota_lv_gmid_comparator_0.ota_slow_gmid_ctrl_buff_0.x.t6 24.4839
R11795 ota_lv_gmid_comparator_0.ota_slow_gmid_ctrl_buff_0.x.n6 ota_lv_gmid_comparator_0.ota_slow_gmid_ctrl_buff_0.x.t8 15.2168
R11796 ota_lv_gmid_comparator_0.ota_slow_gmid_ctrl_buff_0.x.n5 ota_lv_gmid_comparator_0.ota_slow_gmid_ctrl_buff_0.x.n4 9.87282
R11797 ota_lv_gmid_comparator_0.ota_slow_gmid_ctrl_buff_0.x.n7 ota_lv_gmid_comparator_0.ota_slow_gmid_ctrl_buff_0.x.n6 9.47717
R11798 ota_lv_gmid_comparator_0.ota_slow_gmid_ctrl_buff_0.x.n2 ota_lv_gmid_comparator_0.ota_slow_gmid_ctrl_buff_0.x.t2 6.77452
R11799 ota_lv_gmid_comparator_0.ota_slow_gmid_ctrl_buff_0.x.n2 ota_lv_gmid_comparator_0.ota_slow_gmid_ctrl_buff_0.x.t0 6.07327
R11800 ota_lv_gmid_comparator_0.ota_slow_gmid_ctrl_buff_0.x.n3 ota_lv_gmid_comparator_0.ota_slow_gmid_ctrl_buff_0.x.t1 6.07227
R11801 ota_lv_gmid_comparator_0.ota_slow_gmid_ctrl_buff_0.x.n0 ota_lv_gmid_comparator_0.ota_slow_gmid_ctrl_buff_0.x.t5 4.10783
R11802 ota_lv_gmid_comparator_0.ota_slow_gmid_ctrl_buff_0.x.n0 ota_lv_gmid_comparator_0.ota_slow_gmid_ctrl_buff_0.x.t3 3.40658
R11803 ota_lv_gmid_comparator_0.ota_slow_gmid_ctrl_buff_0.x.n1 ota_lv_gmid_comparator_0.ota_slow_gmid_ctrl_buff_0.x.t4 3.40592
R11804 ota_lv_gmid_comparator_0.ota_slow_gmid_ctrl_buff_0.x ota_lv_gmid_comparator_0.ota_slow_gmid_ctrl_buff_0.x.n7 0.954845
R11805 ota_lv_gmid_comparator_0.ota_slow_gmid_ctrl_buff_0.x.n1 ota_lv_gmid_comparator_0.ota_slow_gmid_ctrl_buff_0.x.n0 0.70175
R11806 ota_lv_gmid_comparator_0.ota_slow_gmid_ctrl_buff_0.x.n3 ota_lv_gmid_comparator_0.ota_slow_gmid_ctrl_buff_0.x.n2 0.70175
R11807 ota_lv_gmid_comparator_0.ota_slow_gmid_ctrl_buff_0.x.n4 ota_lv_gmid_comparator_0.ota_slow_gmid_ctrl_buff_0.x.n3 0.138
R11808 ota_lv_gmid_comparator_0.ota_slow_gmid_ctrl_buff_0.x.n4 ota_lv_gmid_comparator_0.ota_slow_gmid_ctrl_buff_0.x.n1 0.120812
R11809 ota_lv_gmid_comparator_0.ota_slow_gmid_ctrl_buff_0.x ota_lv_gmid_comparator_0.ota_slow_gmid_ctrl_buff_0.x.n5 0.0611897
R11810 ota_lv_gmid_comparator_0.ota_slow_gmid_ctrl_buff_0.x.n6 ota_lv_gmid_comparator_0.ota_slow_gmid_ctrl_buff_0.x 0.0445
R11811 a_2285_1463.n5 a_2285_1463.n4 18.7002
R11812 a_2285_1463.n2 a_2285_1463.t8 17.2274
R11813 a_2285_1463.n1 a_2285_1463.t0 17.2274
R11814 a_2285_1463.n0 a_2285_1463.t6 17.2274
R11815 a_2285_1463.n6 a_2285_1463.t3 17.2274
R11816 a_2285_1463.t5 a_2285_1463.n7 17.2274
R11817 a_2285_1463.n7 a_2285_1463.t7 17.2239
R11818 a_2285_1463.n2 a_2285_1463.t1 17.2239
R11819 a_2285_1463.n1 a_2285_1463.t9 17.2239
R11820 a_2285_1463.n0 a_2285_1463.t4 17.2239
R11821 a_2285_1463.n6 a_2285_1463.t2 17.2239
R11822 a_2285_1463.n3 a_2285_1463.t10 4.10735
R11823 a_2285_1463.n4 a_2285_1463.t12 3.64026
R11824 a_2285_1463.n3 a_2285_1463.t11 3.4061
R11825 a_2285_1463.n2 a_2285_1463.n1 1.293
R11826 a_2285_1463.n7 a_2285_1463.n0 1.293
R11827 a_2285_1463.n7 a_2285_1463.n6 1.293
R11828 a_2285_1463.n6 a_2285_1463.n5 0.942702
R11829 a_2285_1463.n4 a_2285_1463.n3 0.413313
R11830 a_2285_1463.n5 a_2285_1463.n2 0.303327
R11831 a_17412_7390.t0 a_17412_7390.t1 30.5717
R11832 a_17412_6864.t0 a_17412_6864.t1 30.2659
R11833 two_stage_instrumentation_amplifier_0.ota_slow_gmid_1.ota_slow_gmid_buffer_0.ibiasn.n9 two_stage_instrumentation_amplifier_0.ota_slow_gmid_1.ota_slow_gmid_buffer_0.ibiasn.t3 27.9721
R11834 two_stage_instrumentation_amplifier_0.ota_slow_gmid_1.ota_slow_gmid_buffer_0.ibiasn.n32 two_stage_instrumentation_amplifier_0.ota_slow_gmid_1.ota_slow_gmid_buffer_0.ibiasn.t4 27.3694
R11835 two_stage_instrumentation_amplifier_0.ota_slow_gmid_1.ota_slow_gmid_buffer_0.ibiasn.n32 two_stage_instrumentation_amplifier_0.ota_slow_gmid_1.ota_slow_gmid_buffer_0.ibiasn.t1 27.0914
R11836 two_stage_instrumentation_amplifier_0.ota_slow_gmid_1.ota_slow_gmid_buffer_0.ibiasn.n9 two_stage_instrumentation_amplifier_0.ota_slow_gmid_1.ota_slow_gmid_buffer_0.ibiasn.t2 26.4736
R11837 two_stage_instrumentation_amplifier_0.ota_slow_gmid_1.ota_slow_gmid_buffer_0.ibiasn.t0 two_stage_instrumentation_amplifier_0.ota_slow_gmid_1.ota_slow_gmid_buffer_0.ibiasn.n34 15.0005
R11838 two_stage_instrumentation_amplifier_0.ota_slow_gmid_1.ota_slow_gmid_buffer_0.ibiasn.n39 two_stage_instrumentation_amplifier_0.ota_slow_gmid_1.ota_slow_gmid_buffer_0.ibiasn.t6 10.2759
R11839 two_stage_instrumentation_amplifier_0.ota_slow_gmid_1.ota_slow_gmid_buffer_0.ibiasn.n10 two_stage_instrumentation_amplifier_0.ota_slow_gmid_1.ota_slow_gmid_buffer_0.ibiasn.n5 9.18829
R11840 two_stage_instrumentation_amplifier_0.ota_slow_gmid_1.ota_slow_gmid_buffer_0.ibiasn.n31 two_stage_instrumentation_amplifier_0.ota_slow_gmid_1.ota_slow_gmid_buffer_0.ibiasn.n24 9.0005
R11841 two_stage_instrumentation_amplifier_0.ota_slow_gmid_1.ota_slow_gmid_buffer_0.ibiasn.n30 two_stage_instrumentation_amplifier_0.ota_slow_gmid_1.ota_slow_gmid_buffer_0.ibiasn.n29 9.0005
R11842 two_stage_instrumentation_amplifier_0.ota_slow_gmid_1.ota_slow_gmid_buffer_0.ibiasn.n28 two_stage_instrumentation_amplifier_0.ota_slow_gmid_1.ota_slow_gmid_buffer_0.ibiasn.n27 9.0005
R11843 two_stage_instrumentation_amplifier_0.ota_slow_gmid_1.ota_slow_gmid_buffer_0.ibiasn.n26 two_stage_instrumentation_amplifier_0.ota_slow_gmid_1.ota_slow_gmid_buffer_0.ibiasn.n25 9.0005
R11844 two_stage_instrumentation_amplifier_0.ota_slow_gmid_1.ota_slow_gmid_buffer_0.ibiasn.n3 two_stage_instrumentation_amplifier_0.ota_slow_gmid_1.ota_slow_gmid_buffer_0.ibiasn.n1 9.0005
R11845 two_stage_instrumentation_amplifier_0.ota_slow_gmid_1.ota_slow_gmid_buffer_0.ibiasn.n37 two_stage_instrumentation_amplifier_0.ota_slow_gmid_1.ota_slow_gmid_buffer_0.ibiasn.n36 9.0005
R11846 two_stage_instrumentation_amplifier_0.ota_slow_gmid_1.ota_slow_gmid_buffer_0.ibiasn.n2 two_stage_instrumentation_amplifier_0.ota_slow_gmid_1.ota_slow_gmid_buffer_0.ibiasn.n0 9.0005
R11847 two_stage_instrumentation_amplifier_0.ota_slow_gmid_1.ota_slow_gmid_buffer_0.ibiasn.n21 two_stage_instrumentation_amplifier_0.ota_slow_gmid_1.ota_slow_gmid_buffer_0.ibiasn.n20 9.0005
R11848 two_stage_instrumentation_amplifier_0.ota_slow_gmid_1.ota_slow_gmid_buffer_0.ibiasn.n19 two_stage_instrumentation_amplifier_0.ota_slow_gmid_1.ota_slow_gmid_buffer_0.ibiasn.n8 9.0005
R11849 two_stage_instrumentation_amplifier_0.ota_slow_gmid_1.ota_slow_gmid_buffer_0.ibiasn.n18 two_stage_instrumentation_amplifier_0.ota_slow_gmid_1.ota_slow_gmid_buffer_0.ibiasn.n17 9.0005
R11850 two_stage_instrumentation_amplifier_0.ota_slow_gmid_1.ota_slow_gmid_buffer_0.ibiasn.n16 two_stage_instrumentation_amplifier_0.ota_slow_gmid_1.ota_slow_gmid_buffer_0.ibiasn.n15 9.0005
R11851 two_stage_instrumentation_amplifier_0.ota_slow_gmid_1.ota_slow_gmid_buffer_0.ibiasn.n14 two_stage_instrumentation_amplifier_0.ota_slow_gmid_1.ota_slow_gmid_buffer_0.ibiasn.n13 9.0005
R11852 two_stage_instrumentation_amplifier_0.ota_slow_gmid_1.ota_slow_gmid_buffer_0.ibiasn.n12 two_stage_instrumentation_amplifier_0.ota_slow_gmid_1.ota_slow_gmid_buffer_0.ibiasn.n11 9.0005
R11853 two_stage_instrumentation_amplifier_0.ota_slow_gmid_1.ota_slow_gmid_buffer_0.ibiasn.n34 two_stage_instrumentation_amplifier_0.ota_slow_gmid_1.ota_slow_gmid_buffer_0.ibiasn.n33 9.0005
R11854 two_stage_instrumentation_amplifier_0.ota_slow_gmid_1.ota_slow_gmid_buffer_0.ibiasn.t0 two_stage_instrumentation_amplifier_0.ota_slow_gmid_1.ota_slow_gmid_buffer_0.ibiasn.n5 7.40736
R11855 two_stage_instrumentation_amplifier_0.ota_slow_gmid_1.ota_slow_gmid_buffer_0.ibiasn.t0 two_stage_instrumentation_amplifier_0.ota_slow_gmid_1.ota_slow_gmid_buffer_0.ibiasn.n6 7.40736
R11856 two_stage_instrumentation_amplifier_0.ota_slow_gmid_1.ota_slow_gmid_buffer_0.ibiasn.t0 two_stage_instrumentation_amplifier_0.ota_slow_gmid_1.ota_slow_gmid_buffer_0.ibiasn.n7 7.40736
R11857 two_stage_instrumentation_amplifier_0.ota_slow_gmid_1.ota_slow_gmid_buffer_0.ibiasn.t0 two_stage_instrumentation_amplifier_0.ota_slow_gmid_1.ota_slow_gmid_buffer_0.ibiasn.n22 7.40736
R11858 two_stage_instrumentation_amplifier_0.ota_slow_gmid_1.ota_slow_gmid_buffer_0.ibiasn.n35 two_stage_instrumentation_amplifier_0.ota_slow_gmid_1.ota_slow_gmid_buffer_0.ibiasn.t0 7.40736
R11859 two_stage_instrumentation_amplifier_0.ota_slow_gmid_1.ota_slow_gmid_buffer_0.ibiasn.t0 two_stage_instrumentation_amplifier_0.ota_slow_gmid_1.ota_slow_gmid_buffer_0.ibiasn.n23 7.40736
R11860 two_stage_instrumentation_amplifier_0.ota_slow_gmid_1.ota_slow_gmid_buffer_0.ibiasn.t0 two_stage_instrumentation_amplifier_0.ota_slow_gmid_1.ota_slow_gmid_buffer_0.ibiasn.n4 7.40736
R11861 two_stage_instrumentation_amplifier_0.ota_slow_gmid_1.ota_slow_gmid_buffer_0.ibiasn two_stage_instrumentation_amplifier_0.ota_slow_gmid_1.ota_slow_gmid_buffer_0.ibiasn.n39 5.8926
R11862 two_stage_instrumentation_amplifier_0.ota_slow_gmid_1.ota_slow_gmid_buffer_0.ibiasn.n39 two_stage_instrumentation_amplifier_0.ota_slow_gmid_1.ota_slow_gmid_buffer_0.ibiasn.t5 5.69455
R11863 two_stage_instrumentation_amplifier_0.ota_slow_gmid_1.ota_slow_gmid_buffer_0.ibiasn two_stage_instrumentation_amplifier_0.ota_slow_gmid_1.ota_slow_gmid_buffer_0.ibiasn.n38 1.18134
R11864 two_stage_instrumentation_amplifier_0.ota_slow_gmid_1.ota_slow_gmid_buffer_0.ibiasn.n33 two_stage_instrumentation_amplifier_0.ota_slow_gmid_1.ota_slow_gmid_buffer_0.ibiasn.n32 0.622952
R11865 two_stage_instrumentation_amplifier_0.ota_slow_gmid_1.ota_slow_gmid_buffer_0.ibiasn.n10 two_stage_instrumentation_amplifier_0.ota_slow_gmid_1.ota_slow_gmid_buffer_0.ibiasn.n9 0.614003
R11866 two_stage_instrumentation_amplifier_0.ota_slow_gmid_1.ota_slow_gmid_buffer_0.ibiasn.n13 two_stage_instrumentation_amplifier_0.ota_slow_gmid_1.ota_slow_gmid_buffer_0.ibiasn.n12 0.37981
R11867 two_stage_instrumentation_amplifier_0.ota_slow_gmid_1.ota_slow_gmid_buffer_0.ibiasn.n17 two_stage_instrumentation_amplifier_0.ota_slow_gmid_1.ota_slow_gmid_buffer_0.ibiasn.n16 0.37981
R11868 two_stage_instrumentation_amplifier_0.ota_slow_gmid_1.ota_slow_gmid_buffer_0.ibiasn.n21 two_stage_instrumentation_amplifier_0.ota_slow_gmid_1.ota_slow_gmid_buffer_0.ibiasn.n8 0.37981
R11869 two_stage_instrumentation_amplifier_0.ota_slow_gmid_1.ota_slow_gmid_buffer_0.ibiasn.n36 two_stage_instrumentation_amplifier_0.ota_slow_gmid_1.ota_slow_gmid_buffer_0.ibiasn.n2 0.37981
R11870 two_stage_instrumentation_amplifier_0.ota_slow_gmid_1.ota_slow_gmid_buffer_0.ibiasn.n25 two_stage_instrumentation_amplifier_0.ota_slow_gmid_1.ota_slow_gmid_buffer_0.ibiasn.n3 0.37981
R11871 two_stage_instrumentation_amplifier_0.ota_slow_gmid_1.ota_slow_gmid_buffer_0.ibiasn.n29 two_stage_instrumentation_amplifier_0.ota_slow_gmid_1.ota_slow_gmid_buffer_0.ibiasn.n28 0.37981
R11872 two_stage_instrumentation_amplifier_0.ota_slow_gmid_1.ota_slow_gmid_buffer_0.ibiasn.n34 two_stage_instrumentation_amplifier_0.ota_slow_gmid_1.ota_slow_gmid_buffer_0.ibiasn.n24 0.37981
R11873 two_stage_instrumentation_amplifier_0.ota_slow_gmid_1.ota_slow_gmid_buffer_0.ibiasn.n11 two_stage_instrumentation_amplifier_0.ota_slow_gmid_1.ota_slow_gmid_buffer_0.ibiasn.n10 0.298805
R11874 two_stage_instrumentation_amplifier_0.ota_slow_gmid_1.ota_slow_gmid_buffer_0.ibiasn.n14 two_stage_instrumentation_amplifier_0.ota_slow_gmid_1.ota_slow_gmid_buffer_0.ibiasn.n11 0.298805
R11875 two_stage_instrumentation_amplifier_0.ota_slow_gmid_1.ota_slow_gmid_buffer_0.ibiasn.n15 two_stage_instrumentation_amplifier_0.ota_slow_gmid_1.ota_slow_gmid_buffer_0.ibiasn.n14 0.298805
R11876 two_stage_instrumentation_amplifier_0.ota_slow_gmid_1.ota_slow_gmid_buffer_0.ibiasn.n18 two_stage_instrumentation_amplifier_0.ota_slow_gmid_1.ota_slow_gmid_buffer_0.ibiasn.n15 0.298805
R11877 two_stage_instrumentation_amplifier_0.ota_slow_gmid_1.ota_slow_gmid_buffer_0.ibiasn.n19 two_stage_instrumentation_amplifier_0.ota_slow_gmid_1.ota_slow_gmid_buffer_0.ibiasn.n18 0.298805
R11878 two_stage_instrumentation_amplifier_0.ota_slow_gmid_1.ota_slow_gmid_buffer_0.ibiasn.n20 two_stage_instrumentation_amplifier_0.ota_slow_gmid_1.ota_slow_gmid_buffer_0.ibiasn.n19 0.298805
R11879 two_stage_instrumentation_amplifier_0.ota_slow_gmid_1.ota_slow_gmid_buffer_0.ibiasn.n20 two_stage_instrumentation_amplifier_0.ota_slow_gmid_1.ota_slow_gmid_buffer_0.ibiasn.n0 0.298805
R11880 two_stage_instrumentation_amplifier_0.ota_slow_gmid_1.ota_slow_gmid_buffer_0.ibiasn.n37 two_stage_instrumentation_amplifier_0.ota_slow_gmid_1.ota_slow_gmid_buffer_0.ibiasn.n1 0.298805
R11881 two_stage_instrumentation_amplifier_0.ota_slow_gmid_1.ota_slow_gmid_buffer_0.ibiasn.n26 two_stage_instrumentation_amplifier_0.ota_slow_gmid_1.ota_slow_gmid_buffer_0.ibiasn.n1 0.298805
R11882 two_stage_instrumentation_amplifier_0.ota_slow_gmid_1.ota_slow_gmid_buffer_0.ibiasn.n27 two_stage_instrumentation_amplifier_0.ota_slow_gmid_1.ota_slow_gmid_buffer_0.ibiasn.n26 0.298805
R11883 two_stage_instrumentation_amplifier_0.ota_slow_gmid_1.ota_slow_gmid_buffer_0.ibiasn.n30 two_stage_instrumentation_amplifier_0.ota_slow_gmid_1.ota_slow_gmid_buffer_0.ibiasn.n27 0.298805
R11884 two_stage_instrumentation_amplifier_0.ota_slow_gmid_1.ota_slow_gmid_buffer_0.ibiasn.n31 two_stage_instrumentation_amplifier_0.ota_slow_gmid_1.ota_slow_gmid_buffer_0.ibiasn.n30 0.298805
R11885 two_stage_instrumentation_amplifier_0.ota_slow_gmid_1.ota_slow_gmid_buffer_0.ibiasn.n33 two_stage_instrumentation_amplifier_0.ota_slow_gmid_1.ota_slow_gmid_buffer_0.ibiasn.n31 0.298805
R11886 two_stage_instrumentation_amplifier_0.ota_slow_gmid_1.ota_slow_gmid_buffer_0.ibiasn.n38 two_stage_instrumentation_amplifier_0.ota_slow_gmid_1.ota_slow_gmid_buffer_0.ibiasn.n37 0.294331
R11887 two_stage_instrumentation_amplifier_0.ota_slow_gmid_1.ota_slow_gmid_buffer_0.ibiasn.n13 two_stage_instrumentation_amplifier_0.ota_slow_gmid_1.ota_slow_gmid_buffer_0.ibiasn.n6 0.188287
R11888 two_stage_instrumentation_amplifier_0.ota_slow_gmid_1.ota_slow_gmid_buffer_0.ibiasn.n17 two_stage_instrumentation_amplifier_0.ota_slow_gmid_1.ota_slow_gmid_buffer_0.ibiasn.n7 0.188287
R11889 two_stage_instrumentation_amplifier_0.ota_slow_gmid_1.ota_slow_gmid_buffer_0.ibiasn.n22 two_stage_instrumentation_amplifier_0.ota_slow_gmid_1.ota_slow_gmid_buffer_0.ibiasn.n21 0.188287
R11890 two_stage_instrumentation_amplifier_0.ota_slow_gmid_1.ota_slow_gmid_buffer_0.ibiasn.n36 two_stage_instrumentation_amplifier_0.ota_slow_gmid_1.ota_slow_gmid_buffer_0.ibiasn.n35 0.188287
R11891 two_stage_instrumentation_amplifier_0.ota_slow_gmid_1.ota_slow_gmid_buffer_0.ibiasn.n25 two_stage_instrumentation_amplifier_0.ota_slow_gmid_1.ota_slow_gmid_buffer_0.ibiasn.n23 0.188287
R11892 two_stage_instrumentation_amplifier_0.ota_slow_gmid_1.ota_slow_gmid_buffer_0.ibiasn.n24 two_stage_instrumentation_amplifier_0.ota_slow_gmid_1.ota_slow_gmid_buffer_0.ibiasn.n4 0.188287
R11893 two_stage_instrumentation_amplifier_0.ota_slow_gmid_1.ota_slow_gmid_buffer_0.ibiasn.n12 two_stage_instrumentation_amplifier_0.ota_slow_gmid_1.ota_slow_gmid_buffer_0.ibiasn.n5 0.188287
R11894 two_stage_instrumentation_amplifier_0.ota_slow_gmid_1.ota_slow_gmid_buffer_0.ibiasn.n16 two_stage_instrumentation_amplifier_0.ota_slow_gmid_1.ota_slow_gmid_buffer_0.ibiasn.n6 0.188287
R11895 two_stage_instrumentation_amplifier_0.ota_slow_gmid_1.ota_slow_gmid_buffer_0.ibiasn.n8 two_stage_instrumentation_amplifier_0.ota_slow_gmid_1.ota_slow_gmid_buffer_0.ibiasn.n7 0.188287
R11896 two_stage_instrumentation_amplifier_0.ota_slow_gmid_1.ota_slow_gmid_buffer_0.ibiasn.n22 two_stage_instrumentation_amplifier_0.ota_slow_gmid_1.ota_slow_gmid_buffer_0.ibiasn.n2 0.188287
R11897 two_stage_instrumentation_amplifier_0.ota_slow_gmid_1.ota_slow_gmid_buffer_0.ibiasn.n35 two_stage_instrumentation_amplifier_0.ota_slow_gmid_1.ota_slow_gmid_buffer_0.ibiasn.n3 0.188287
R11898 two_stage_instrumentation_amplifier_0.ota_slow_gmid_1.ota_slow_gmid_buffer_0.ibiasn.n28 two_stage_instrumentation_amplifier_0.ota_slow_gmid_1.ota_slow_gmid_buffer_0.ibiasn.n23 0.188287
R11899 two_stage_instrumentation_amplifier_0.ota_slow_gmid_1.ota_slow_gmid_buffer_0.ibiasn.n29 two_stage_instrumentation_amplifier_0.ota_slow_gmid_1.ota_slow_gmid_buffer_0.ibiasn.n4 0.188287
R11900 two_stage_instrumentation_amplifier_0.ota_slow_gmid_1.ota_slow_gmid_buffer_0.ibiasn.n38 two_stage_instrumentation_amplifier_0.ota_slow_gmid_1.ota_slow_gmid_buffer_0.ibiasn.n0 0.00497458
R11901 a_2485_3315.n3 a_2485_3315.t0 19.1936
R11902 a_2485_3315.n2 a_2485_3315.n1 18.7515
R11903 a_2485_3315.n2 a_2485_3315.t2 18.2143
R11904 a_2485_3315.t1 a_2485_3315.n3 17.2961
R11905 a_2485_3315.n0 a_2485_3315.t3 6.77495
R11906 a_2485_3315.n1 a_2485_3315.t5 6.07724
R11907 a_2485_3315.n0 a_2485_3315.t4 6.0737
R11908 a_2485_3315.n3 a_2485_3315.n2 0.9255
R11909 a_2485_3315.n1 a_2485_3315.n0 0.653317
R11910 two_stage_instrumentation_amplifier_0.ota_slow_gmid_0.ota_slow_gmid_buffer_0.ibiasn.n10 two_stage_instrumentation_amplifier_0.ota_slow_gmid_0.ota_slow_gmid_buffer_0.ibiasn.t2 27.9721
R11911 two_stage_instrumentation_amplifier_0.ota_slow_gmid_0.ota_slow_gmid_buffer_0.ibiasn.n33 two_stage_instrumentation_amplifier_0.ota_slow_gmid_0.ota_slow_gmid_buffer_0.ibiasn.t1 27.3694
R11912 two_stage_instrumentation_amplifier_0.ota_slow_gmid_0.ota_slow_gmid_buffer_0.ibiasn.n33 two_stage_instrumentation_amplifier_0.ota_slow_gmid_0.ota_slow_gmid_buffer_0.ibiasn.t3 27.0914
R11913 two_stage_instrumentation_amplifier_0.ota_slow_gmid_0.ota_slow_gmid_buffer_0.ibiasn.n10 two_stage_instrumentation_amplifier_0.ota_slow_gmid_0.ota_slow_gmid_buffer_0.ibiasn.t4 26.4736
R11914 two_stage_instrumentation_amplifier_0.ota_slow_gmid_0.ota_slow_gmid_buffer_0.ibiasn.t0 two_stage_instrumentation_amplifier_0.ota_slow_gmid_0.ota_slow_gmid_buffer_0.ibiasn.n35 15.0005
R11915 two_stage_instrumentation_amplifier_0.ota_slow_gmid_0.ota_slow_gmid_buffer_0.ibiasn.n0 two_stage_instrumentation_amplifier_0.ota_slow_gmid_0.ota_slow_gmid_buffer_0.ibiasn.t5 10.2759
R11916 two_stage_instrumentation_amplifier_0.ota_slow_gmid_0.ota_slow_gmid_buffer_0.ibiasn.n11 two_stage_instrumentation_amplifier_0.ota_slow_gmid_0.ota_slow_gmid_buffer_0.ibiasn.n6 9.18829
R11917 two_stage_instrumentation_amplifier_0.ota_slow_gmid_0.ota_slow_gmid_buffer_0.ibiasn.n32 two_stage_instrumentation_amplifier_0.ota_slow_gmid_0.ota_slow_gmid_buffer_0.ibiasn.n25 9.0005
R11918 two_stage_instrumentation_amplifier_0.ota_slow_gmid_0.ota_slow_gmid_buffer_0.ibiasn.n31 two_stage_instrumentation_amplifier_0.ota_slow_gmid_0.ota_slow_gmid_buffer_0.ibiasn.n30 9.0005
R11919 two_stage_instrumentation_amplifier_0.ota_slow_gmid_0.ota_slow_gmid_buffer_0.ibiasn.n29 two_stage_instrumentation_amplifier_0.ota_slow_gmid_0.ota_slow_gmid_buffer_0.ibiasn.n28 9.0005
R11920 two_stage_instrumentation_amplifier_0.ota_slow_gmid_0.ota_slow_gmid_buffer_0.ibiasn.n27 two_stage_instrumentation_amplifier_0.ota_slow_gmid_0.ota_slow_gmid_buffer_0.ibiasn.n26 9.0005
R11921 two_stage_instrumentation_amplifier_0.ota_slow_gmid_0.ota_slow_gmid_buffer_0.ibiasn.n4 two_stage_instrumentation_amplifier_0.ota_slow_gmid_0.ota_slow_gmid_buffer_0.ibiasn.n2 9.0005
R11922 two_stage_instrumentation_amplifier_0.ota_slow_gmid_0.ota_slow_gmid_buffer_0.ibiasn.n38 two_stage_instrumentation_amplifier_0.ota_slow_gmid_0.ota_slow_gmid_buffer_0.ibiasn.n37 9.0005
R11923 two_stage_instrumentation_amplifier_0.ota_slow_gmid_0.ota_slow_gmid_buffer_0.ibiasn.n3 two_stage_instrumentation_amplifier_0.ota_slow_gmid_0.ota_slow_gmid_buffer_0.ibiasn.n1 9.0005
R11924 two_stage_instrumentation_amplifier_0.ota_slow_gmid_0.ota_slow_gmid_buffer_0.ibiasn.n22 two_stage_instrumentation_amplifier_0.ota_slow_gmid_0.ota_slow_gmid_buffer_0.ibiasn.n21 9.0005
R11925 two_stage_instrumentation_amplifier_0.ota_slow_gmid_0.ota_slow_gmid_buffer_0.ibiasn.n20 two_stage_instrumentation_amplifier_0.ota_slow_gmid_0.ota_slow_gmid_buffer_0.ibiasn.n9 9.0005
R11926 two_stage_instrumentation_amplifier_0.ota_slow_gmid_0.ota_slow_gmid_buffer_0.ibiasn.n19 two_stage_instrumentation_amplifier_0.ota_slow_gmid_0.ota_slow_gmid_buffer_0.ibiasn.n18 9.0005
R11927 two_stage_instrumentation_amplifier_0.ota_slow_gmid_0.ota_slow_gmid_buffer_0.ibiasn.n17 two_stage_instrumentation_amplifier_0.ota_slow_gmid_0.ota_slow_gmid_buffer_0.ibiasn.n16 9.0005
R11928 two_stage_instrumentation_amplifier_0.ota_slow_gmid_0.ota_slow_gmid_buffer_0.ibiasn.n15 two_stage_instrumentation_amplifier_0.ota_slow_gmid_0.ota_slow_gmid_buffer_0.ibiasn.n14 9.0005
R11929 two_stage_instrumentation_amplifier_0.ota_slow_gmid_0.ota_slow_gmid_buffer_0.ibiasn.n13 two_stage_instrumentation_amplifier_0.ota_slow_gmid_0.ota_slow_gmid_buffer_0.ibiasn.n12 9.0005
R11930 two_stage_instrumentation_amplifier_0.ota_slow_gmid_0.ota_slow_gmid_buffer_0.ibiasn.n35 two_stage_instrumentation_amplifier_0.ota_slow_gmid_0.ota_slow_gmid_buffer_0.ibiasn.n34 9.0005
R11931 two_stage_instrumentation_amplifier_0.ota_slow_gmid_0.ota_slow_gmid_buffer_0.ibiasn.t0 two_stage_instrumentation_amplifier_0.ota_slow_gmid_0.ota_slow_gmid_buffer_0.ibiasn.n6 7.40736
R11932 two_stage_instrumentation_amplifier_0.ota_slow_gmid_0.ota_slow_gmid_buffer_0.ibiasn.t0 two_stage_instrumentation_amplifier_0.ota_slow_gmid_0.ota_slow_gmid_buffer_0.ibiasn.n7 7.40736
R11933 two_stage_instrumentation_amplifier_0.ota_slow_gmid_0.ota_slow_gmid_buffer_0.ibiasn.t0 two_stage_instrumentation_amplifier_0.ota_slow_gmid_0.ota_slow_gmid_buffer_0.ibiasn.n8 7.40736
R11934 two_stage_instrumentation_amplifier_0.ota_slow_gmid_0.ota_slow_gmid_buffer_0.ibiasn.t0 two_stage_instrumentation_amplifier_0.ota_slow_gmid_0.ota_slow_gmid_buffer_0.ibiasn.n23 7.40736
R11935 two_stage_instrumentation_amplifier_0.ota_slow_gmid_0.ota_slow_gmid_buffer_0.ibiasn.n36 two_stage_instrumentation_amplifier_0.ota_slow_gmid_0.ota_slow_gmid_buffer_0.ibiasn.t0 7.40736
R11936 two_stage_instrumentation_amplifier_0.ota_slow_gmid_0.ota_slow_gmid_buffer_0.ibiasn.t0 two_stage_instrumentation_amplifier_0.ota_slow_gmid_0.ota_slow_gmid_buffer_0.ibiasn.n24 7.40736
R11937 two_stage_instrumentation_amplifier_0.ota_slow_gmid_0.ota_slow_gmid_buffer_0.ibiasn.t0 two_stage_instrumentation_amplifier_0.ota_slow_gmid_0.ota_slow_gmid_buffer_0.ibiasn.n5 7.40736
R11938 two_stage_instrumentation_amplifier_0.ota_slow_gmid_0.ota_slow_gmid_buffer_0.ibiasn two_stage_instrumentation_amplifier_0.ota_slow_gmid_0.ota_slow_gmid_buffer_0.ibiasn.n0 6.0246
R11939 two_stage_instrumentation_amplifier_0.ota_slow_gmid_0.ota_slow_gmid_buffer_0.ibiasn.n0 two_stage_instrumentation_amplifier_0.ota_slow_gmid_0.ota_slow_gmid_buffer_0.ibiasn.t6 5.69455
R11940 two_stage_instrumentation_amplifier_0.ota_slow_gmid_0.ota_slow_gmid_buffer_0.ibiasn two_stage_instrumentation_amplifier_0.ota_slow_gmid_0.ota_slow_gmid_buffer_0.ibiasn.n39 1.07697
R11941 two_stage_instrumentation_amplifier_0.ota_slow_gmid_0.ota_slow_gmid_buffer_0.ibiasn.n34 two_stage_instrumentation_amplifier_0.ota_slow_gmid_0.ota_slow_gmid_buffer_0.ibiasn.n33 0.622952
R11942 two_stage_instrumentation_amplifier_0.ota_slow_gmid_0.ota_slow_gmid_buffer_0.ibiasn.n11 two_stage_instrumentation_amplifier_0.ota_slow_gmid_0.ota_slow_gmid_buffer_0.ibiasn.n10 0.614003
R11943 two_stage_instrumentation_amplifier_0.ota_slow_gmid_0.ota_slow_gmid_buffer_0.ibiasn.n14 two_stage_instrumentation_amplifier_0.ota_slow_gmid_0.ota_slow_gmid_buffer_0.ibiasn.n13 0.37981
R11944 two_stage_instrumentation_amplifier_0.ota_slow_gmid_0.ota_slow_gmid_buffer_0.ibiasn.n18 two_stage_instrumentation_amplifier_0.ota_slow_gmid_0.ota_slow_gmid_buffer_0.ibiasn.n17 0.37981
R11945 two_stage_instrumentation_amplifier_0.ota_slow_gmid_0.ota_slow_gmid_buffer_0.ibiasn.n22 two_stage_instrumentation_amplifier_0.ota_slow_gmid_0.ota_slow_gmid_buffer_0.ibiasn.n9 0.37981
R11946 two_stage_instrumentation_amplifier_0.ota_slow_gmid_0.ota_slow_gmid_buffer_0.ibiasn.n37 two_stage_instrumentation_amplifier_0.ota_slow_gmid_0.ota_slow_gmid_buffer_0.ibiasn.n3 0.37981
R11947 two_stage_instrumentation_amplifier_0.ota_slow_gmid_0.ota_slow_gmid_buffer_0.ibiasn.n26 two_stage_instrumentation_amplifier_0.ota_slow_gmid_0.ota_slow_gmid_buffer_0.ibiasn.n4 0.37981
R11948 two_stage_instrumentation_amplifier_0.ota_slow_gmid_0.ota_slow_gmid_buffer_0.ibiasn.n30 two_stage_instrumentation_amplifier_0.ota_slow_gmid_0.ota_slow_gmid_buffer_0.ibiasn.n29 0.37981
R11949 two_stage_instrumentation_amplifier_0.ota_slow_gmid_0.ota_slow_gmid_buffer_0.ibiasn.n35 two_stage_instrumentation_amplifier_0.ota_slow_gmid_0.ota_slow_gmid_buffer_0.ibiasn.n25 0.37981
R11950 two_stage_instrumentation_amplifier_0.ota_slow_gmid_0.ota_slow_gmid_buffer_0.ibiasn.n12 two_stage_instrumentation_amplifier_0.ota_slow_gmid_0.ota_slow_gmid_buffer_0.ibiasn.n11 0.298805
R11951 two_stage_instrumentation_amplifier_0.ota_slow_gmid_0.ota_slow_gmid_buffer_0.ibiasn.n15 two_stage_instrumentation_amplifier_0.ota_slow_gmid_0.ota_slow_gmid_buffer_0.ibiasn.n12 0.298805
R11952 two_stage_instrumentation_amplifier_0.ota_slow_gmid_0.ota_slow_gmid_buffer_0.ibiasn.n16 two_stage_instrumentation_amplifier_0.ota_slow_gmid_0.ota_slow_gmid_buffer_0.ibiasn.n15 0.298805
R11953 two_stage_instrumentation_amplifier_0.ota_slow_gmid_0.ota_slow_gmid_buffer_0.ibiasn.n19 two_stage_instrumentation_amplifier_0.ota_slow_gmid_0.ota_slow_gmid_buffer_0.ibiasn.n16 0.298805
R11954 two_stage_instrumentation_amplifier_0.ota_slow_gmid_0.ota_slow_gmid_buffer_0.ibiasn.n20 two_stage_instrumentation_amplifier_0.ota_slow_gmid_0.ota_slow_gmid_buffer_0.ibiasn.n19 0.298805
R11955 two_stage_instrumentation_amplifier_0.ota_slow_gmid_0.ota_slow_gmid_buffer_0.ibiasn.n21 two_stage_instrumentation_amplifier_0.ota_slow_gmid_0.ota_slow_gmid_buffer_0.ibiasn.n20 0.298805
R11956 two_stage_instrumentation_amplifier_0.ota_slow_gmid_0.ota_slow_gmid_buffer_0.ibiasn.n21 two_stage_instrumentation_amplifier_0.ota_slow_gmid_0.ota_slow_gmid_buffer_0.ibiasn.n1 0.298805
R11957 two_stage_instrumentation_amplifier_0.ota_slow_gmid_0.ota_slow_gmid_buffer_0.ibiasn.n38 two_stage_instrumentation_amplifier_0.ota_slow_gmid_0.ota_slow_gmid_buffer_0.ibiasn.n2 0.298805
R11958 two_stage_instrumentation_amplifier_0.ota_slow_gmid_0.ota_slow_gmid_buffer_0.ibiasn.n27 two_stage_instrumentation_amplifier_0.ota_slow_gmid_0.ota_slow_gmid_buffer_0.ibiasn.n2 0.298805
R11959 two_stage_instrumentation_amplifier_0.ota_slow_gmid_0.ota_slow_gmid_buffer_0.ibiasn.n28 two_stage_instrumentation_amplifier_0.ota_slow_gmid_0.ota_slow_gmid_buffer_0.ibiasn.n27 0.298805
R11960 two_stage_instrumentation_amplifier_0.ota_slow_gmid_0.ota_slow_gmid_buffer_0.ibiasn.n31 two_stage_instrumentation_amplifier_0.ota_slow_gmid_0.ota_slow_gmid_buffer_0.ibiasn.n28 0.298805
R11961 two_stage_instrumentation_amplifier_0.ota_slow_gmid_0.ota_slow_gmid_buffer_0.ibiasn.n32 two_stage_instrumentation_amplifier_0.ota_slow_gmid_0.ota_slow_gmid_buffer_0.ibiasn.n31 0.298805
R11962 two_stage_instrumentation_amplifier_0.ota_slow_gmid_0.ota_slow_gmid_buffer_0.ibiasn.n34 two_stage_instrumentation_amplifier_0.ota_slow_gmid_0.ota_slow_gmid_buffer_0.ibiasn.n32 0.298805
R11963 two_stage_instrumentation_amplifier_0.ota_slow_gmid_0.ota_slow_gmid_buffer_0.ibiasn.n39 two_stage_instrumentation_amplifier_0.ota_slow_gmid_0.ota_slow_gmid_buffer_0.ibiasn.n38 0.294331
R11964 two_stage_instrumentation_amplifier_0.ota_slow_gmid_0.ota_slow_gmid_buffer_0.ibiasn.n14 two_stage_instrumentation_amplifier_0.ota_slow_gmid_0.ota_slow_gmid_buffer_0.ibiasn.n7 0.188287
R11965 two_stage_instrumentation_amplifier_0.ota_slow_gmid_0.ota_slow_gmid_buffer_0.ibiasn.n18 two_stage_instrumentation_amplifier_0.ota_slow_gmid_0.ota_slow_gmid_buffer_0.ibiasn.n8 0.188287
R11966 two_stage_instrumentation_amplifier_0.ota_slow_gmid_0.ota_slow_gmid_buffer_0.ibiasn.n23 two_stage_instrumentation_amplifier_0.ota_slow_gmid_0.ota_slow_gmid_buffer_0.ibiasn.n22 0.188287
R11967 two_stage_instrumentation_amplifier_0.ota_slow_gmid_0.ota_slow_gmid_buffer_0.ibiasn.n37 two_stage_instrumentation_amplifier_0.ota_slow_gmid_0.ota_slow_gmid_buffer_0.ibiasn.n36 0.188287
R11968 two_stage_instrumentation_amplifier_0.ota_slow_gmid_0.ota_slow_gmid_buffer_0.ibiasn.n26 two_stage_instrumentation_amplifier_0.ota_slow_gmid_0.ota_slow_gmid_buffer_0.ibiasn.n24 0.188287
R11969 two_stage_instrumentation_amplifier_0.ota_slow_gmid_0.ota_slow_gmid_buffer_0.ibiasn.n25 two_stage_instrumentation_amplifier_0.ota_slow_gmid_0.ota_slow_gmid_buffer_0.ibiasn.n5 0.188287
R11970 two_stage_instrumentation_amplifier_0.ota_slow_gmid_0.ota_slow_gmid_buffer_0.ibiasn.n13 two_stage_instrumentation_amplifier_0.ota_slow_gmid_0.ota_slow_gmid_buffer_0.ibiasn.n6 0.188287
R11971 two_stage_instrumentation_amplifier_0.ota_slow_gmid_0.ota_slow_gmid_buffer_0.ibiasn.n17 two_stage_instrumentation_amplifier_0.ota_slow_gmid_0.ota_slow_gmid_buffer_0.ibiasn.n7 0.188287
R11972 two_stage_instrumentation_amplifier_0.ota_slow_gmid_0.ota_slow_gmid_buffer_0.ibiasn.n9 two_stage_instrumentation_amplifier_0.ota_slow_gmid_0.ota_slow_gmid_buffer_0.ibiasn.n8 0.188287
R11973 two_stage_instrumentation_amplifier_0.ota_slow_gmid_0.ota_slow_gmid_buffer_0.ibiasn.n23 two_stage_instrumentation_amplifier_0.ota_slow_gmid_0.ota_slow_gmid_buffer_0.ibiasn.n3 0.188287
R11974 two_stage_instrumentation_amplifier_0.ota_slow_gmid_0.ota_slow_gmid_buffer_0.ibiasn.n36 two_stage_instrumentation_amplifier_0.ota_slow_gmid_0.ota_slow_gmid_buffer_0.ibiasn.n4 0.188287
R11975 two_stage_instrumentation_amplifier_0.ota_slow_gmid_0.ota_slow_gmid_buffer_0.ibiasn.n29 two_stage_instrumentation_amplifier_0.ota_slow_gmid_0.ota_slow_gmid_buffer_0.ibiasn.n24 0.188287
R11976 two_stage_instrumentation_amplifier_0.ota_slow_gmid_0.ota_slow_gmid_buffer_0.ibiasn.n30 two_stage_instrumentation_amplifier_0.ota_slow_gmid_0.ota_slow_gmid_buffer_0.ibiasn.n5 0.188287
R11977 two_stage_instrumentation_amplifier_0.ota_slow_gmid_0.ota_slow_gmid_buffer_0.ibiasn.n39 two_stage_instrumentation_amplifier_0.ota_slow_gmid_0.ota_slow_gmid_buffer_0.ibiasn.n1 0.00497458
R11978 ota_lv_gmid_comparator_0.ota_slow_gmid_ctrl_buff_1.y ota_lv_gmid_comparator_0.ota_slow_gmid_ctrl_buff_1.y.t3 7.76611
R11979 ota_lv_gmid_comparator_0.ota_slow_gmid_ctrl_buff_1.y.n0 ota_lv_gmid_comparator_0.ota_slow_gmid_ctrl_buff_1.y.t2 7.76611
R11980 ota_lv_gmid_comparator_0.ota_slow_gmid_ctrl_buff_1.y ota_lv_gmid_comparator_0.ota_slow_gmid_ctrl_buff_1.y.n1 7.6161
R11981 ota_lv_gmid_comparator_0.ota_slow_gmid_ctrl_buff_1.y.n1 ota_lv_gmid_comparator_0.ota_slow_gmid_ctrl_buff_1.y.n0 6.87119
R11982 ota_lv_gmid_comparator_0.ota_slow_gmid_ctrl_buff_1.y.n2 ota_lv_gmid_comparator_0.ota_slow_gmid_ctrl_buff_1.y.t1 3.54938
R11983 ota_lv_gmid_comparator_0.ota_slow_gmid_ctrl_buff_1.y.n2 ota_lv_gmid_comparator_0.ota_slow_gmid_ctrl_buff_1.y.t0 3.47311
R11984 ota_lv_gmid_comparator_0.ota_slow_gmid_ctrl_buff_1.y.n1 ota_lv_gmid_comparator_0.ota_slow_gmid_ctrl_buff_1.y 0.5901
R11985 ota_lv_gmid_comparator_0.ota_slow_gmid_ctrl_buff_1.y ota_lv_gmid_comparator_0.ota_slow_gmid_ctrl_buff_1.y.n2 0.204
R11986 ota_lv_gmid_comparator_0.ota_slow_gmid_ctrl_buff_1.y.n0 ota_lv_gmid_comparator_0.ota_slow_gmid_ctrl_buff_1.y 0.0387609
R11987 non_inverting_amplifier_hv_0.ota_hv_slow_gmid_0.en.n2 non_inverting_amplifier_hv_0.ota_hv_slow_gmid_0.en.n0 37.0495
R11988 non_inverting_amplifier_hv_0.ota_hv_slow_gmid_0.en.n0 non_inverting_amplifier_hv_0.ota_hv_slow_gmid_0.en.t4 16.2353
R11989 non_inverting_amplifier_hv_0.ota_hv_slow_gmid_0.en.n1 non_inverting_amplifier_hv_0.ota_hv_slow_gmid_0.en.t5 16.1959
R11990 non_inverting_amplifier_hv_0.ota_hv_slow_gmid_0.ota_hv_slow_gmid_ctrl_inv_0.Y non_inverting_amplifier_hv_0.ota_hv_slow_gmid_0.en.t1 6.21917
R11991 non_inverting_amplifier_hv_0.ota_hv_slow_gmid_0.en.n3 non_inverting_amplifier_hv_0.ota_hv_slow_gmid_0.en.n2 5.97605
R11992 non_inverting_amplifier_hv_0.ota_hv_slow_gmid_0.en.n2 non_inverting_amplifier_hv_0.ota_hv_slow_gmid_0.en.n1 5.41727
R11993 non_inverting_amplifier_hv_0.ota_hv_slow_gmid_0.en.n3 non_inverting_amplifier_hv_0.ota_hv_slow_gmid_0.en.t0 2.65347
R11994 non_inverting_amplifier_hv_0.ota_hv_slow_gmid_0.ota_hv_slow_gmid_ctrl_inv_0.Y non_inverting_amplifier_hv_0.ota_hv_slow_gmid_0.en.n3 1.52479
R11995 non_inverting_amplifier_hv_0.ota_hv_slow_gmid_0.en.n1 non_inverting_amplifier_hv_0.ota_hv_slow_gmid_0.en.t3 0.449201
R11996 non_inverting_amplifier_hv_0.ota_hv_slow_gmid_0.en.n0 non_inverting_amplifier_hv_0.ota_hv_slow_gmid_0.en.t2 0.411234
R11997 VBIASH.n14 VBIASH 79.6877
R11998 VBIASH.n6 VBIASH.n5 22.4355
R11999 VBIASH.n4 VBIASH.t4 17.2377
R12000 VBIASH.n3 VBIASH.t10 17.2377
R12001 VBIASH.n2 VBIASH.t12 17.2377
R12002 VBIASH.n5 VBIASH.t9 17.2377
R12003 VBIASH.n9 VBIASH.t11 17.2377
R12004 VBIASH.n10 VBIASH.t6 17.2377
R12005 VBIASH.n11 VBIASH.t14 17.2377
R12006 VBIASH.n12 VBIASH.t17 17.2377
R12007 VBIASH.n1 VBIASH.t16 17.0213
R12008 VBIASH.n8 VBIASH.t13 17.0213
R12009 VBIASH.n18 VBIASH 15.9492
R12010 VBIASH VBIASH.t18 15.1324
R12011 VBIASH VBIASH.n13 12.0698
R12012 VBIASH.n13 VBIASH.n12 11.0038
R12013 VBIASH.n1 VBIASH.n0 10.6029
R12014 VBIASH.n8 VBIASH.n7 10.6029
R12015 VBIASH.n0 VBIASH.t7 10.2052
R12016 VBIASH.n7 VBIASH.t15 10.2052
R12017 VBIASH VBIASH.n14 9.70057
R12018 VBIASH.n0 VBIASH.t8 8.45947
R12019 VBIASH.n7 VBIASH.t5 8.45947
R12020 VBIASH.n13 VBIASH.n6 6.86345
R12021 VBIASH.n15 VBIASH.t0 4.37319
R12022 VBIASH VBIASH.n17 3.96305
R12023 VBIASH.n16 VBIASH.t2 3.41985
R12024 VBIASH.n15 VBIASH.t3 3.41985
R12025 VBIASH.n17 VBIASH.t1 2.86869
R12026 VBIASH.n6 VBIASH.t19 1.86707
R12027 VBIASH.n17 VBIASH.n16 1.43497
R12028 VBIASH.n2 VBIASH.n1 1.2327
R12029 VBIASH.n9 VBIASH.n8 1.2327
R12030 VBIASH.n3 VBIASH.n2 1.073
R12031 VBIASH.n4 VBIASH.n3 1.073
R12032 VBIASH.n11 VBIASH.n10 1.073
R12033 VBIASH.n10 VBIASH.n9 1.073
R12034 VBIASH VBIASH.n18 0.9861
R12035 VBIASH.n16 VBIASH.n15 0.953833
R12036 VBIASH.n5 VBIASH.n4 0.900378
R12037 VBIASH.n12 VBIASH.n11 0.873968
R12038 VBIASH.n18 VBIASH 0.1677
R12039 VBIASH.n14 VBIASH 0.155187
R12040 VBIASH.n13 VBIASH 0.107357
R12041 VBIASH.n13 VBIASH 0.0367353
R12042 two_stage_instrumentation_amplifier_0.ota_slow_gmid_1.VN.n0 two_stage_instrumentation_amplifier_0.ota_slow_gmid_1.VN.t1 15.3157
R12043 two_stage_instrumentation_amplifier_0.ota_slow_gmid_1.VN.n0 two_stage_instrumentation_amplifier_0.ota_slow_gmid_1.VN.t0 15.2565
R12044 two_stage_instrumentation_amplifier_0.ota_slow_gmid_1.VN.n1 two_stage_instrumentation_amplifier_0.ota_slow_gmid_1.VN.t2 9.00288
R12045 two_stage_instrumentation_amplifier_0.ota_slow_gmid_1.VN.n1 two_stage_instrumentation_amplifier_0.ota_slow_gmid_1.VN.t3 4.87123
R12046 two_stage_instrumentation_amplifier_0.ota_slow_gmid_1.VN two_stage_instrumentation_amplifier_0.ota_slow_gmid_1.VN.n1 3.50243
R12047 two_stage_instrumentation_amplifier_0.ota_slow_gmid_1.VN two_stage_instrumentation_amplifier_0.ota_slow_gmid_1.VN.n0 3.2239
R12048 two_stage_instrumentation_amplifier_0.ota_slow_gmid_1.ota_slow_gmid_mirror_0.vref.n0 two_stage_instrumentation_amplifier_0.ota_slow_gmid_1.ota_slow_gmid_mirror_0.vref.t4 19.5609
R12049 two_stage_instrumentation_amplifier_0.ota_slow_gmid_1.ota_slow_gmid_mirror_0.vref.n3 two_stage_instrumentation_amplifier_0.ota_slow_gmid_1.ota_slow_gmid_mirror_0.vref.n2 17.2964
R12050 two_stage_instrumentation_amplifier_0.ota_slow_gmid_1.ota_slow_gmid_mirror_0.vref.n1 two_stage_instrumentation_amplifier_0.ota_slow_gmid_1.ota_slow_gmid_mirror_0.vref.t3 17.0658
R12051 two_stage_instrumentation_amplifier_0.ota_slow_gmid_1.ota_slow_gmid_mirror_0.vref.n3 two_stage_instrumentation_amplifier_0.ota_slow_gmid_1.ota_slow_gmid_mirror_0.vref.t0 13.9935
R12052 two_stage_instrumentation_amplifier_0.ota_slow_gmid_1.ota_slow_gmid_mirror_0.vref two_stage_instrumentation_amplifier_0.ota_slow_gmid_1.ota_slow_gmid_mirror_0.vref.n1 5.4971
R12053 two_stage_instrumentation_amplifier_0.ota_slow_gmid_1.ota_slow_gmid_mirror_0.vref.n4 two_stage_instrumentation_amplifier_0.ota_slow_gmid_1.ota_slow_gmid_mirror_0.vref.t1 5.39538
R12054 two_stage_instrumentation_amplifier_0.ota_slow_gmid_1.ota_slow_gmid_mirror_0.vref.n4 two_stage_instrumentation_amplifier_0.ota_slow_gmid_1.ota_slow_gmid_mirror_0.vref.n3 4.9175
R12055 two_stage_instrumentation_amplifier_0.ota_slow_gmid_1.ota_slow_gmid_mirror_0.vref.n1 two_stage_instrumentation_amplifier_0.ota_slow_gmid_1.ota_slow_gmid_mirror_0.vref.n0 2.51451
R12056 two_stage_instrumentation_amplifier_0.ota_slow_gmid_1.ota_slow_gmid_mirror_0.vref.n2 two_stage_instrumentation_amplifier_0.ota_slow_gmid_1.ota_slow_gmid_mirror_0.vref 0.0995
R12057 two_stage_instrumentation_amplifier_0.ota_slow_gmid_1.ota_slow_gmid_mirror_0.vref.n4 two_stage_instrumentation_amplifier_0.ota_slow_gmid_1.ota_slow_gmid_mirror_0.vref 0.0885
R12058 two_stage_instrumentation_amplifier_0.ota_slow_gmid_1.ota_slow_gmid_mirror_0.vref.n0 two_stage_instrumentation_amplifier_0.ota_slow_gmid_1.ota_slow_gmid_mirror_0.vref.t2 0.0523162
R12059 two_stage_instrumentation_amplifier_0.ota_slow_gmid_1.ota_slow_gmid_mirror_0.vref.n2 two_stage_instrumentation_amplifier_0.ota_slow_gmid_1.ota_slow_gmid_mirror_0.vref 0.0445
R12060 two_stage_instrumentation_amplifier_0.ota_slow_gmid_1.ota_slow_gmid_mirror_0.vref two_stage_instrumentation_amplifier_0.ota_slow_gmid_1.ota_slow_gmid_mirror_0.vref.n4 0.0445
R12061 two_stage_instrumentation_amplifier_0.ota_slow_gmid_1.ota_slow_gmid_common_0/ota_slow_gmid_pairs_0.tail.n0 two_stage_instrumentation_amplifier_0.ota_slow_gmid_1.ota_slow_gmid_common_0/ota_slow_gmid_pairs_0.tail.t3 7.71313
R12062 two_stage_instrumentation_amplifier_0.ota_slow_gmid_1.ota_slow_gmid_common_0/ota_slow_gmid_pairs_0.tail.n0 two_stage_instrumentation_amplifier_0.ota_slow_gmid_1.ota_slow_gmid_common_0/ota_slow_gmid_pairs_0.tail.t2 5.6454
R12063 two_stage_instrumentation_amplifier_0.ota_slow_gmid_1.ota_slow_gmid_common_0/ota_slow_gmid_pairs_0.tail.n1 two_stage_instrumentation_amplifier_0.ota_slow_gmid_1.ota_slow_gmid_common_0/ota_slow_gmid_pairs_0.tail.n0 5.31864
R12064 two_stage_instrumentation_amplifier_0.ota_slow_gmid_1.ota_slow_gmid_common_0/ota_slow_gmid_pairs_0.tail.n4 two_stage_instrumentation_amplifier_0.ota_slow_gmid_1.ota_slow_gmid_common_0/ota_slow_gmid_pairs_0.tail.t1 4.21854
R12065 two_stage_instrumentation_amplifier_0.ota_slow_gmid_1.ota_slow_gmid_common_0/ota_slow_gmid_pairs_0.tail two_stage_instrumentation_amplifier_0.ota_slow_gmid_1.ota_slow_gmid_common_0/ota_slow_gmid_pairs_0.tail.n4 3.42203
R12066 two_stage_instrumentation_amplifier_0.ota_slow_gmid_1.ota_slow_gmid_common_0/ota_slow_gmid_pairs_0.tail.n4 two_stage_instrumentation_amplifier_0.ota_slow_gmid_1.ota_slow_gmid_common_0/ota_slow_gmid_pairs_0.tail.t0 2.31267
R12067 two_stage_instrumentation_amplifier_0.ota_slow_gmid_1.ota_slow_gmid_common_0/ota_slow_gmid_pairs_0.tail.n3 two_stage_instrumentation_amplifier_0.ota_slow_gmid_1.ota_slow_gmid_common_0/ota_slow_gmid_pairs_0.tail.n2 0.3833
R12068 two_stage_instrumentation_amplifier_0.ota_slow_gmid_1.ota_slow_gmid_common_0/ota_slow_gmid_pairs_0.tail.n2 two_stage_instrumentation_amplifier_0.ota_slow_gmid_1.ota_slow_gmid_common_0/ota_slow_gmid_pairs_0.tail 0.196667
R12069 two_stage_instrumentation_amplifier_0.ota_slow_gmid_1.ota_slow_gmid_common_0/ota_slow_gmid_pairs_0.tail.n2 two_stage_instrumentation_amplifier_0.ota_slow_gmid_1.ota_slow_gmid_common_0/ota_slow_gmid_pairs_0.tail 0.125167
R12070 two_stage_instrumentation_amplifier_0.ota_slow_gmid_1.ota_slow_gmid_common_0/ota_slow_gmid_pairs_0.tail.n1 two_stage_instrumentation_amplifier_0.ota_slow_gmid_1.ota_slow_gmid_common_0/ota_slow_gmid_pairs_0.tail 0.1061
R12071 two_stage_instrumentation_amplifier_0.ota_slow_gmid_1.ota_slow_gmid_common_0/ota_slow_gmid_pairs_0.tail.n3 two_stage_instrumentation_amplifier_0.ota_slow_gmid_1.ota_slow_gmid_common_0/ota_slow_gmid_pairs_0.tail 0.0885
R12072 two_stage_instrumentation_amplifier_0.ota_slow_gmid_1.ota_slow_gmid_common_0/ota_slow_gmid_pairs_0.tail two_stage_instrumentation_amplifier_0.ota_slow_gmid_1.ota_slow_gmid_common_0/ota_slow_gmid_pairs_0.tail.n3 0.0511
R12073 two_stage_instrumentation_amplifier_0.ota_slow_gmid_1.ota_slow_gmid_common_0/ota_slow_gmid_pairs_0.tail two_stage_instrumentation_amplifier_0.ota_slow_gmid_1.ota_slow_gmid_common_0/ota_slow_gmid_pairs_0.tail.n1 0.0371667
R12074 a_14214_881.t0 a_14214_881.t1 32.0224
R12075 a_14350_881.t0 a_14350_881.t1 33.0255
R12076 S3.n0 S3 58.9079
R12077 S3 S3.t0 24.4581
R12078 S3.n0 S3 12.2888
R12079 S3 S3.n0 0.8607
R12080 ref_selector_0.ref_selector_r_refs_0.R3 ref_selector_0.ref_selector_r_refs_0.R3.t0 23.4687
R12081 ref_selector_0.ref_selector_r_refs_0.R3 ref_selector_0.ref_selector_r_refs_0.R3.t1 4.91076
R12082 vref.n1 two_stage_instrumentation_amplifier_0.VN 61.5134
R12083 ref_selector_0.ref_selector_r_96_0.vref vref.t5 27.2121
R12084 vref.n2 vref.t2 9.97421
R12085 vref.n2 vref.t3 8.87441
R12086 vref.n0 vref.t8 6.66783
R12087 vref.n0 vref.t7 4.87123
R12088 vref.n1 ref_selector_0.ref_selector_r_96_0.vref 4.79566
R12089 vref.n8 vref.t0 4.39241
R12090 vref.n7 vref.t0 4.18887
R12091 two_stage_instrumentation_amplifier_0.ota_slow_gmid_1.ota_slow_gmid_common_0/ota_slow_gmid_pairs_0.vp vref.n0 3.9033
R12092 vref.n4 current_source_1mA_0.I100UA 3.71021
R12093 vref.n5 vref.t1 2.97445
R12094 vref.n9 vref.n8 2.2505
R12095 vref.n6 vref.t4 1.99971
R12096 vref.n5 vref.t6 1.99971
R12097 vref.n3 vref.n2 1.43668
R12098 vref.n6 vref.n5 0.978287
R12099 vref.n7 vref.n6 0.784185
R12100 two_stage_instrumentation_amplifier_0.VN two_stage_instrumentation_amplifier_0.ota_slow_gmid_1.ota_slow_gmid_common_0/ota_slow_gmid_pairs_0.vp 0.7837
R12101 current_source_1mA_0.I100UA vref.n3 0.447559
R12102 vref.n3 current_source_1mA_0.current_source_1mA_2_stage_0.current_source_ref_0.i100ua 0.3041
R12103 vref.n8 vref.n7 0.199829
R12104 vref.n9 vref.n4 0.0301744
R12105 ref_selector_0.ref_selector_r_switch_0.vref vref.n9 0.0135465
R12106 vref.n4 vref.n1 0.00126744
R12107 ota_lv_gmid_comparator_0.ota_slow_gmid_ctrl_buff_0.ota_slow_gmid_ctrl_inv_0.x ota_lv_gmid_comparator_0.ota_slow_gmid_ctrl_buff_0.ota_slow_gmid_ctrl_inv_0.x.t2 15.2608
R12108 ota_lv_gmid_comparator_0.ota_slow_gmid_ctrl_buff_0.ota_slow_gmid_ctrl_inv_0.x.n0 ota_lv_gmid_comparator_0.ota_slow_gmid_ctrl_buff_0.ota_slow_gmid_ctrl_inv_0.x.t1 3.55057
R12109 ota_lv_gmid_comparator_0.ota_slow_gmid_ctrl_buff_0.ota_slow_gmid_ctrl_inv_0.x.n0 ota_lv_gmid_comparator_0.ota_slow_gmid_ctrl_buff_0.ota_slow_gmid_ctrl_inv_0.x.t0 3.47311
R12110 ota_lv_gmid_comparator_0.ota_slow_gmid_ctrl_buff_0.ota_slow_gmid_ctrl_inv_0.x ota_lv_gmid_comparator_0.ota_slow_gmid_ctrl_buff_0.ota_slow_gmid_ctrl_inv_0.x.n0 0.204
R12111 COMPARATOR_RES.n2 COMPARATOR_RES 63.7049
R12112 COMPARATOR_RES.n0 COMPARATOR_RES.t1 3.55057
R12113 COMPARATOR_RES.n0 COMPARATOR_RES.t0 3.47123
R12114 COMPARATOR_RES COMPARATOR_RES.n0 0.117833
R12115 COMPARATOR_RES.n1 COMPARATOR_RES 0.0518333
R12116 COMPARATOR_RES COMPARATOR_RES.n2 0.0511579
R12117 COMPARATOR_RES.n2 COMPARATOR_RES 0.0394764
R12118 COMPARATOR_RES.n1 COMPARATOR_RES 0.024752
R12119 COMPARATOR_RES COMPARATOR_RES.n1 0.0169567
R12120 a_17952_7916.t0 a_17952_7916.t1 30.5717
R12121 a_18222_7638.t0 a_18222_7638.t1 31.357
R12122 a_17412_8690.t0 a_17412_8690.t1 30.5717
R12123 two_stage_instrumentation_amplifier_0.ota_slow_gmid_1.vota.n6 two_stage_instrumentation_amplifier_0.ota_slow_gmid_1.vota.t0 34.4823
R12124 two_stage_instrumentation_amplifier_0.ota_slow_gmid_1.vota.n5 two_stage_instrumentation_amplifier_0.ota_slow_gmid_1.vota.t1 17.0005
R12125 two_stage_instrumentation_amplifier_0.ota_slow_gmid_1.vota.n4 two_stage_instrumentation_amplifier_0.ota_slow_gmid_1.vota.n1 13.6567
R12126 two_stage_instrumentation_amplifier_0.ota_slow_gmid_1.vota.n2 two_stage_instrumentation_amplifier_0.ota_slow_gmid_1.vota.t2 11.1062
R12127 two_stage_instrumentation_amplifier_0.ota_slow_gmid_1.vota.n0 two_stage_instrumentation_amplifier_0.ota_slow_gmid_1.vota.t6 10.4875
R12128 two_stage_instrumentation_amplifier_0.ota_slow_gmid_1.ota_slow_gmid_mirror_0.vota two_stage_instrumentation_amplifier_0.ota_slow_gmid_1.vota.n4 9.09905
R12129 two_stage_instrumentation_amplifier_0.ota_slow_gmid_1.vota.n1 two_stage_instrumentation_amplifier_0.ota_slow_gmid_1.vota.n0 8.24209
R12130 two_stage_instrumentation_amplifier_0.ota_slow_gmid_1.vota.n4 two_stage_instrumentation_amplifier_0.ota_slow_gmid_1.ota_slow_gmid_common_0/ota_slow_gmid_pairs_0.vota 7.28321
R12131 two_stage_instrumentation_amplifier_0.ota_slow_gmid_1.vota.n0 two_stage_instrumentation_amplifier_0.ota_slow_gmid_1.vota.t8 6.4935
R12132 two_stage_instrumentation_amplifier_0.ota_slow_gmid_1.vota.n1 two_stage_instrumentation_amplifier_0.ota_slow_gmid_1.vota.t7 6.49059
R12133 two_stage_instrumentation_amplifier_0.ota_slow_gmid_1.ota_slow_gmid_mirror_0.vota two_stage_instrumentation_amplifier_0.ota_slow_gmid_1.vota.n7 5.4993
R12134 two_stage_instrumentation_amplifier_0.ota_slow_gmid_1.vota.n2 two_stage_instrumentation_amplifier_0.ota_slow_gmid_1.vota.t3 4.52571
R12135 two_stage_instrumentation_amplifier_0.ota_slow_gmid_1.vota.n5 two_stage_instrumentation_amplifier_0.ota_slow_gmid_1.vota.t5 4.28336
R12136 two_stage_instrumentation_amplifier_0.ota_slow_gmid_1.vota.n6 two_stage_instrumentation_amplifier_0.ota_slow_gmid_1.vota.t4 4.15409
R12137 two_stage_instrumentation_amplifier_0.ota_slow_gmid_1.vota.n3 two_stage_instrumentation_amplifier_0.ota_slow_gmid_1.vota.n2 2.9215
R12138 two_stage_instrumentation_amplifier_0.ota_slow_gmid_1.vota.n7 two_stage_instrumentation_amplifier_0.ota_slow_gmid_1.vota.n6 0.677202
R12139 two_stage_instrumentation_amplifier_0.ota_slow_gmid_1.vota.n3 two_stage_instrumentation_amplifier_0.ota_slow_gmid_1.ota_slow_gmid_common_0/ota_slow_gmid_pairs_0.vota 0.1017
R12140 two_stage_instrumentation_amplifier_0.ota_slow_gmid_1.ota_slow_gmid_common_0/ota_slow_gmid_pairs_0.vota two_stage_instrumentation_amplifier_0.ota_slow_gmid_1.vota.n3 0.0387609
R12141 two_stage_instrumentation_amplifier_0.ota_slow_gmid_1.vota.n7 two_stage_instrumentation_amplifier_0.ota_slow_gmid_1.vota.n5 0.0169567
R12142 a_n9874_2009.t0 a_n9874_2009.t1 30.2659
R12143 a_9187_1799.t0 a_9187_1799.t1 30.5717
R12144 a_9593_1529.t0 a_9593_1529.t1 30.5717
R12145 a_n14501_5507.t0 a_n14501_5507.t1 32.8145
R12146 a_n14781_4821.t0 a_n14781_4821.t1 30.5928
R12147 a_7225_1529.t0 a_7225_1529.t1 33.9283
R12148 a_7631_1529.t0 a_7631_1529.t1 30.5717
R12149 two_stage_instrumentation_amplifier_0.ota_slow_gmid_1.en.n0 two_stage_instrumentation_amplifier_0.ota_slow_gmid_1.en.t2 28.3725
R12150 two_stage_instrumentation_amplifier_0.ota_slow_gmid_1.en.n0 two_stage_instrumentation_amplifier_0.ota_slow_gmid_1.en.t3 25.0065
R12151 two_stage_instrumentation_amplifier_0.ota_slow_gmid_1.ota_slow_gmid_ctrl_buff_0.y two_stage_instrumentation_amplifier_0.ota_slow_gmid_1.en.n0 5.42219
R12152 two_stage_instrumentation_amplifier_0.ota_slow_gmid_1.en.n1 two_stage_instrumentation_amplifier_0.ota_slow_gmid_1.en.t1 3.54938
R12153 two_stage_instrumentation_amplifier_0.ota_slow_gmid_1.en.n1 two_stage_instrumentation_amplifier_0.ota_slow_gmid_1.en.t0 3.47311
R12154 two_stage_instrumentation_amplifier_0.ota_slow_gmid_1.ota_slow_gmid_ctrl_buff_0.ota_slow_gmid_ctrl_inv_0.y two_stage_instrumentation_amplifier_0.ota_slow_gmid_1.en.n1 0.204
R12155 two_stage_instrumentation_amplifier_0.ota_slow_gmid_1.ota_slow_gmid_ctrl_buff_0.y two_stage_instrumentation_amplifier_0.ota_slow_gmid_1.ota_slow_gmid_ctrl_buff_0.ota_slow_gmid_ctrl_inv_0.y 0.083
R12156 a_17412_6586.t0 a_17412_6586.t1 30.5717
R12157 two_stage_instrumentation_amplifier_0.ota_slow_gmid_0.vota.n3 two_stage_instrumentation_amplifier_0.ota_slow_gmid_0.vota.t3 34.4823
R12158 two_stage_instrumentation_amplifier_0.ota_slow_gmid_0.vota.n2 two_stage_instrumentation_amplifier_0.ota_slow_gmid_0.vota.t2 17.0005
R12159 two_stage_instrumentation_amplifier_0.ota_slow_gmid_0.vota.n6 two_stage_instrumentation_amplifier_0.ota_slow_gmid_0.vota.n1 13.6567
R12160 two_stage_instrumentation_amplifier_0.ota_slow_gmid_0.vota.n7 two_stage_instrumentation_amplifier_0.ota_slow_gmid_0.vota.t1 11.1062
R12161 two_stage_instrumentation_amplifier_0.ota_slow_gmid_0.vota.n0 two_stage_instrumentation_amplifier_0.ota_slow_gmid_0.vota.t5 10.4868
R12162 two_stage_instrumentation_amplifier_0.ota_slow_gmid_0.vota.n1 two_stage_instrumentation_amplifier_0.ota_slow_gmid_0.vota.n0 8.24209
R12163 two_stage_instrumentation_amplifier_0.ota_slow_gmid_0.vota.n8 two_stage_instrumentation_amplifier_0.ota_slow_gmid_0.vota.n6 7.32147
R12164 two_stage_instrumentation_amplifier_0.ota_slow_gmid_0.vota.n0 two_stage_instrumentation_amplifier_0.ota_slow_gmid_0.vota.t8 6.49353
R12165 two_stage_instrumentation_amplifier_0.ota_slow_gmid_0.vota.n1 two_stage_instrumentation_amplifier_0.ota_slow_gmid_0.vota.t7 6.49092
R12166 two_stage_instrumentation_amplifier_0.ota_slow_gmid_0.vota two_stage_instrumentation_amplifier_0.ota_slow_gmid_0.vota.n5 5.96557
R12167 two_stage_instrumentation_amplifier_0.ota_slow_gmid_0.vota two_stage_instrumentation_amplifier_0.ota_slow_gmid_0.vota.n4 5.4993
R12168 two_stage_instrumentation_amplifier_0.ota_slow_gmid_0.vota.n7 two_stage_instrumentation_amplifier_0.ota_slow_gmid_0.vota.t0 4.52391
R12169 two_stage_instrumentation_amplifier_0.ota_slow_gmid_0.vota.n2 two_stage_instrumentation_amplifier_0.ota_slow_gmid_0.vota.t6 4.2469
R12170 two_stage_instrumentation_amplifier_0.ota_slow_gmid_0.vota.n3 two_stage_instrumentation_amplifier_0.ota_slow_gmid_0.vota.t4 4.15314
R12171 two_stage_instrumentation_amplifier_0.ota_slow_gmid_0.vota.n6 two_stage_instrumentation_amplifier_0.ota_slow_gmid_0.vota 3.17798
R12172 two_stage_instrumentation_amplifier_0.ota_slow_gmid_0.vota.n8 two_stage_instrumentation_amplifier_0.ota_slow_gmid_0.vota.n7 2.9215
R12173 two_stage_instrumentation_amplifier_0.ota_slow_gmid_0.vota.n4 two_stage_instrumentation_amplifier_0.ota_slow_gmid_0.vota.n3 0.677202
R12174 two_stage_instrumentation_amplifier_0.ota_slow_gmid_0.vota two_stage_instrumentation_amplifier_0.ota_slow_gmid_0.vota.n8 0.1017
R12175 two_stage_instrumentation_amplifier_0.ota_slow_gmid_0.vota.n5 two_stage_instrumentation_amplifier_0.ota_slow_gmid_0.vota 0.0973
R12176 two_stage_instrumentation_amplifier_0.ota_slow_gmid_0.vota.n5 two_stage_instrumentation_amplifier_0.ota_slow_gmid_0.vota 0.0445
R12177 two_stage_instrumentation_amplifier_0.ota_slow_gmid_0.vota.n8 two_stage_instrumentation_amplifier_0.ota_slow_gmid_0.vota 0.0387609
R12178 two_stage_instrumentation_amplifier_0.ota_slow_gmid_0.vota.n4 two_stage_instrumentation_amplifier_0.ota_slow_gmid_0.vota.n2 0.0169567
R12179 two_stage_instrumentation_amplifier_0.ota_slow_gmid_0.vout1.n6 two_stage_instrumentation_amplifier_0.ota_slow_gmid_0.vout1.t4 31.5136
R12180 two_stage_instrumentation_amplifier_0.ota_slow_gmid_0.vout1.n16 two_stage_instrumentation_amplifier_0.ota_slow_gmid_0.vout1.t19 31.3583
R12181 two_stage_instrumentation_amplifier_0.ota_slow_gmid_0.vout1.n17 two_stage_instrumentation_amplifier_0.ota_slow_gmid_0.vout1.t0 28.3719
R12182 two_stage_instrumentation_amplifier_0.ota_slow_gmid_0.vout1.n6 two_stage_instrumentation_amplifier_0.ota_slow_gmid_0.vout1.t3 17.0903
R12183 two_stage_instrumentation_amplifier_0.ota_slow_gmid_0.vout1.n7 two_stage_instrumentation_amplifier_0.ota_slow_gmid_0.vout1.t1 17.0903
R12184 two_stage_instrumentation_amplifier_0.ota_slow_gmid_0.vout1.n8 two_stage_instrumentation_amplifier_0.ota_slow_gmid_0.vout1.t2 17.01
R12185 two_stage_instrumentation_amplifier_0.ota_slow_gmid_0.vout1.n8 two_stage_instrumentation_amplifier_0.ota_slow_gmid_0.vout1.n7 14.4641
R12186 two_stage_instrumentation_amplifier_0.ota_slow_gmid_0.vout1.n9 two_stage_instrumentation_amplifier_0.ota_slow_gmid_0.vout1 12.7853
R12187 two_stage_instrumentation_amplifier_0.ota_slow_gmid_0.vout1.n16 two_stage_instrumentation_amplifier_0.ota_slow_gmid_0.vout1.n15 12.6923
R12188 two_stage_instrumentation_amplifier_0.ota_slow_gmid_0.vout1 two_stage_instrumentation_amplifier_0.ota_slow_gmid_0.vout1.n8 9.40045
R12189 two_stage_instrumentation_amplifier_0.ota_slow_gmid_0.vout1.n0 two_stage_instrumentation_amplifier_0.ota_slow_gmid_0.vout1.t17 7.70967
R12190 two_stage_instrumentation_amplifier_0.ota_slow_gmid_0.vout1.n10 two_stage_instrumentation_amplifier_0.ota_slow_gmid_0.vout1.t6 6.76573
R12191 two_stage_instrumentation_amplifier_0.ota_slow_gmid_0.vout1.n1 two_stage_instrumentation_amplifier_0.ota_slow_gmid_0.vout1.t16 6.76573
R12192 two_stage_instrumentation_amplifier_0.ota_slow_gmid_0.vout1.n14 two_stage_instrumentation_amplifier_0.ota_slow_gmid_0.vout1.t10 6.09448
R12193 two_stage_instrumentation_amplifier_0.ota_slow_gmid_0.vout1.n5 two_stage_instrumentation_amplifier_0.ota_slow_gmid_0.vout1.t12 6.09448
R12194 two_stage_instrumentation_amplifier_0.ota_slow_gmid_0.vout1 two_stage_instrumentation_amplifier_0.ota_slow_gmid_0.vout1.n0 6.0667
R12195 two_stage_instrumentation_amplifier_0.ota_slow_gmid_0.vout1.n10 two_stage_instrumentation_amplifier_0.ota_slow_gmid_0.vout1.t8 6.06448
R12196 two_stage_instrumentation_amplifier_0.ota_slow_gmid_0.vout1.n11 two_stage_instrumentation_amplifier_0.ota_slow_gmid_0.vout1.t5 6.06448
R12197 two_stage_instrumentation_amplifier_0.ota_slow_gmid_0.vout1.n12 two_stage_instrumentation_amplifier_0.ota_slow_gmid_0.vout1.t7 6.06448
R12198 two_stage_instrumentation_amplifier_0.ota_slow_gmid_0.vout1.n13 two_stage_instrumentation_amplifier_0.ota_slow_gmid_0.vout1.t9 6.06448
R12199 two_stage_instrumentation_amplifier_0.ota_slow_gmid_0.vout1.n4 two_stage_instrumentation_amplifier_0.ota_slow_gmid_0.vout1.t14 6.06448
R12200 two_stage_instrumentation_amplifier_0.ota_slow_gmid_0.vout1.n3 two_stage_instrumentation_amplifier_0.ota_slow_gmid_0.vout1.t13 6.06448
R12201 two_stage_instrumentation_amplifier_0.ota_slow_gmid_0.vout1.n2 two_stage_instrumentation_amplifier_0.ota_slow_gmid_0.vout1.t15 6.06448
R12202 two_stage_instrumentation_amplifier_0.ota_slow_gmid_0.vout1.n1 two_stage_instrumentation_amplifier_0.ota_slow_gmid_0.vout1.t11 6.06448
R12203 two_stage_instrumentation_amplifier_0.ota_slow_gmid_0.vout1.n0 two_stage_instrumentation_amplifier_0.ota_slow_gmid_0.vout1.t18 5.64781
R12204 two_stage_instrumentation_amplifier_0.ota_slow_gmid_0.vout1.n9 two_stage_instrumentation_amplifier_0.ota_slow_gmid_0.vout1.n5 5.5059
R12205 two_stage_instrumentation_amplifier_0.ota_slow_gmid_0.vout1.n15 two_stage_instrumentation_amplifier_0.ota_slow_gmid_0.vout1.n9 4.6623
R12206 two_stage_instrumentation_amplifier_0.ota_slow_gmid_0.vout1.n15 two_stage_instrumentation_amplifier_0.ota_slow_gmid_0.vout1.n14 4.5005
R12207 two_stage_instrumentation_amplifier_0.ota_slow_gmid_0.vout1.n17 two_stage_instrumentation_amplifier_0.ota_slow_gmid_0.vout1.n16 1.76476
R12208 two_stage_instrumentation_amplifier_0.ota_slow_gmid_0.vout1.n7 two_stage_instrumentation_amplifier_0.ota_slow_gmid_0.vout1.n6 1.69241
R12209 two_stage_instrumentation_amplifier_0.ota_slow_gmid_0.vout1.n13 two_stage_instrumentation_amplifier_0.ota_slow_gmid_0.vout1.n12 0.70175
R12210 two_stage_instrumentation_amplifier_0.ota_slow_gmid_0.vout1.n12 two_stage_instrumentation_amplifier_0.ota_slow_gmid_0.vout1.n11 0.70175
R12211 two_stage_instrumentation_amplifier_0.ota_slow_gmid_0.vout1.n11 two_stage_instrumentation_amplifier_0.ota_slow_gmid_0.vout1.n10 0.70175
R12212 two_stage_instrumentation_amplifier_0.ota_slow_gmid_0.vout1.n2 two_stage_instrumentation_amplifier_0.ota_slow_gmid_0.vout1.n1 0.70175
R12213 two_stage_instrumentation_amplifier_0.ota_slow_gmid_0.vout1.n3 two_stage_instrumentation_amplifier_0.ota_slow_gmid_0.vout1.n2 0.70175
R12214 two_stage_instrumentation_amplifier_0.ota_slow_gmid_0.vout1.n4 two_stage_instrumentation_amplifier_0.ota_slow_gmid_0.vout1.n3 0.70175
R12215 two_stage_instrumentation_amplifier_0.ota_slow_gmid_0.vout1.n14 two_stage_instrumentation_amplifier_0.ota_slow_gmid_0.vout1.n13 0.594875
R12216 two_stage_instrumentation_amplifier_0.ota_slow_gmid_0.vout1.n5 two_stage_instrumentation_amplifier_0.ota_slow_gmid_0.vout1.n4 0.594875
R12217 two_stage_instrumentation_amplifier_0.ota_slow_gmid_0.vout1 two_stage_instrumentation_amplifier_0.ota_slow_gmid_0.vout1.n17 0.0042931
R12218 a_7225_1259.t0 a_7225_1259.t1 41.272
R12219 a_7631_989.t0 a_7631_989.t1 30.5717
R12220 a_n13602_4249.t0 a_n13602_4249.t1 30.5928
R12221 current_source_1mA_0.current_source_1mA_2_stage_0.current_source_pass_element_0.vota.n0 current_source_1mA_0.current_source_1mA_2_stage_0.current_source_pass_element_0.vota.t0 17.9704
R12222 current_source_1mA_0.current_source_1mA_2_stage_0.current_source_pass_element_0.vota.n2 current_source_1mA_0.current_source_1mA_2_stage_0.current_source_pass_element_0.vota.n1 15.7466
R12223 current_source_1mA_0.current_source_1mA_2_stage_0.current_source_pass_element_0.vota.n4 current_source_1mA_0.current_source_1mA_2_stage_0.current_source_pass_element_0.vota 7.8854
R12224 current_source_1mA_0.current_source_1mA_2_stage_0.current_source_pass_element_0.vota.n6 current_source_1mA_0.current_source_1mA_2_stage_0.current_source_pass_element_0.vota.t7 6.96021
R12225 current_source_1mA_0.current_source_1mA_2_stage_0.current_source_pass_element_0.vota current_source_1mA_0.current_source_1mA_2_stage_0.current_source_pass_element_0.vota.n0 6.62326
R12226 current_source_1mA_0.current_source_1mA_2_stage_0.current_source_pass_element_0.vota.n5 current_source_1mA_0.current_source_1mA_2_stage_0.current_source_pass_element_0.vota 6.12473
R12227 current_source_1mA_0.current_source_1mA_2_stage_0.current_source_pass_element_0.vota.n0 current_source_1mA_0.current_source_1mA_2_stage_0.current_source_pass_element_0.vota.t1 5.82914
R12228 current_source_1mA_0.current_source_1mA_2_stage_0.current_source_pass_element_0.vota.n1 current_source_1mA_0.current_source_1mA_2_stage_0.current_source_pass_element_0.vota.t4 4.87063
R12229 current_source_1mA_0.current_source_1mA_2_stage_0.current_source_pass_element_0.vota current_source_1mA_0.current_source_1mA_2_stage_0.current_source_pass_element_0.vota.t6 4.76195
R12230 current_source_1mA_0.current_source_1mA_2_stage_0.current_source_pass_element_0.vota.n6 current_source_1mA_0.current_source_1mA_2_stage_0.current_source_pass_element_0.vota.n5 4.40731
R12231 current_source_1mA_0.current_source_1mA_2_stage_0.current_source_pass_element_0.vota current_source_1mA_0.current_source_1mA_2_stage_0.current_source_pass_element_0.vota.n3 3.96903
R12232 current_source_1mA_0.current_source_1mA_2_stage_0.current_source_pass_element_0.vota.n3 current_source_1mA_0.current_source_1mA_2_stage_0.current_source_pass_element_0.vota.t3 3.27226
R12233 current_source_1mA_0.current_source_1mA_2_stage_0.current_source_pass_element_0.vota.n1 current_source_1mA_0.current_source_1mA_2_stage_0.current_source_pass_element_0.vota.t5 3.19099
R12234 current_source_1mA_0.current_source_1mA_2_stage_0.current_source_pass_element_0.vota.n2 current_source_1mA_0.current_source_1mA_2_stage_0.current_source_pass_element_0.vota.t2 3.19099
R12235 current_source_1mA_0.current_source_1mA_2_stage_0.current_source_pass_element_0.vota.n3 current_source_1mA_0.current_source_1mA_2_stage_0.current_source_pass_element_0.vota.n2 1.57623
R12236 current_source_1mA_0.current_source_1mA_2_stage_0.current_source_pass_element_0.vota.n5 current_source_1mA_0.current_source_1mA_2_stage_0.current_source_pass_element_0.vota.n4 1.36221
R12237 current_source_1mA_0.current_source_1mA_2_stage_0.current_source_pass_element_0.vota current_source_1mA_0.current_source_1mA_2_stage_0.current_source_pass_element_0.vota.n6 0.111315
R12238 current_source_1mA_0.current_source_1mA_2_stage_0.current_source_pass_element_0.vota.n4 current_source_1mA_0.current_source_1mA_2_stage_0.current_source_pass_element_0.vota 0.0306053
R12239 two_stage_instrumentation_amplifier_0.ota_slow_gmid_0.en_n.n0 two_stage_instrumentation_amplifier_0.ota_slow_gmid_0.en_n.t2 26.7483
R12240 two_stage_instrumentation_amplifier_0.ota_slow_gmid_0.en_n.n0 two_stage_instrumentation_amplifier_0.ota_slow_gmid_0.en_n.t4 26.7219
R12241 two_stage_instrumentation_amplifier_0.ota_slow_gmid_0.ota_slow_gmid_ctrl_buff_0.ota_slow_gmid_ctrl_inv_0.x two_stage_instrumentation_amplifier_0.ota_slow_gmid_0.en_n.t3 15.1728
R12242 two_stage_instrumentation_amplifier_0.ota_slow_gmid_0.en_n.n2 two_stage_instrumentation_amplifier_0.ota_slow_gmid_0.en_n.n0 5.57606
R12243 two_stage_instrumentation_amplifier_0.ota_slow_gmid_0.en_n.n1 two_stage_instrumentation_amplifier_0.ota_slow_gmid_0.en_n.t1 3.55057
R12244 two_stage_instrumentation_amplifier_0.ota_slow_gmid_0.en_n.n1 two_stage_instrumentation_amplifier_0.ota_slow_gmid_0.en_n.t0 3.47311
R12245 two_stage_instrumentation_amplifier_0.ota_slow_gmid_0.ota_slow_gmid_ctrl_buff_0.ota_slow_gmid_ctrl_inv_0.x two_stage_instrumentation_amplifier_0.ota_slow_gmid_0.en_n.n2 0.3855
R12246 two_stage_instrumentation_amplifier_0.ota_slow_gmid_0.en_n.n2 two_stage_instrumentation_amplifier_0.ota_slow_gmid_0.ota_slow_gmid_ctrl_buff_0.ota_slow_gmid_ctrl_inv_1.y 0.293833
R12247 two_stage_instrumentation_amplifier_0.ota_slow_gmid_0.ota_slow_gmid_ctrl_buff_0.ota_slow_gmid_ctrl_inv_1.y two_stage_instrumentation_amplifier_0.ota_slow_gmid_0.en_n.n1 0.2865
R12248 a_n9874_4085.t0 a_n9874_4085.t1 30.2659
R12249 a_n9874_3431.t0 a_n9874_3431.t1 30.2659
R12250 a_7879_1529.t0 a_7879_1529.t1 30.5717
R12251 ref_selector_0.VMIN.n17 ref_selector_0.VMIN.n16 40.1654
R12252 ref_selector_0.VMIN.n0 ref_selector_0.VMIN.t18 24.8322
R12253 ref_selector_0.VMIN.n3 ref_selector_0.VMIN.t3 24.8075
R12254 ref_selector_0.VMIN.n0 ref_selector_0.VMIN.t1 24.0402
R12255 ref_selector_0.VMIN.n20 ref_selector_0.VMIN.t4 21.1417
R12256 ref_selector_0.VMIN.n21 ref_selector_0.VMIN.t17 19.8237
R12257 ref_selector_0.VMIN.n18 ref_selector_0.VMIN.t13 19.7869
R12258 ref_selector_0.VMIN.n17 ref_selector_0.VMIN.t16 19.5534
R12259 ref_selector_0.VMIN.n5 ref_selector_0.VMIN.t12 15.4345
R12260 ref_selector_0.VMIN.n1 ref_selector_0.VMIN.t6 15.4345
R12261 ref_selector_0.VMIN.n2 ref_selector_0.VMIN.t7 15.4333
R12262 ref_selector_0.VMIN.n11 ref_selector_0.VMIN.t19 15.1488
R12263 ref_selector_0.VMIN.n12 ref_selector_0.VMIN.t2 15.1439
R12264 ref_selector_0.VMIN.n13 ref_selector_0.VMIN.t8 15.0423
R12265 ref_selector_0.VMIN.n4 ref_selector_0.VMIN.t15 15.0188
R12266 ref_selector_0.VMIN.n5 ref_selector_0.VMIN.t5 15.0005
R12267 ref_selector_0.VMIN.n6 ref_selector_0.VMIN.t11 15.0005
R12268 ref_selector_0.VMIN.n7 ref_selector_0.VMIN.t14 15.0005
R12269 ref_selector_0.VMIN.n1 ref_selector_0.VMIN.t9 15.0005
R12270 ref_selector_0.VMIN.n8 ref_selector_0.VMIN.t0 15.0005
R12271 ref_selector_0.VMIN ref_selector_0.VMIN.n13 10.168
R12272 ref_selector_0.VMIN.n4 ref_selector_0.VMIN.n3 9.80863
R12273 ref_selector_0.VMIN.n3 ref_selector_0.VMIN.n2 9.29181
R12274 ref_selector_0.VMIN.n10 ref_selector_0.VMIN.n0 7.37333
R12275 ref_selector_0.VMIN.n15 ref_selector_0.VMIN.t21 7.2053
R12276 ref_selector_0.VMIN.n16 ref_selector_0.VMIN.n15 5.68498
R12277 ref_selector_0.VMIN.n14 ref_selector_0.VMIN.t20 4.87123
R12278 ref_selector_0.VMIN.n19 ref_selector_0.VMIN.t10 4.56351
R12279 ref_selector_0.VMIN.n14 ref_selector_0.VMIN 3.50243
R12280 ref_selector_0.VMIN.n18 ref_selector_0.VMIN.n17 3.0612
R12281 ref_selector_0.VMIN.n9 ref_selector_0.VMIN.n4 3.01764
R12282 ref_selector_0.VMIN.n10 ref_selector_0.VMIN.n9 1.82139
R12283 ref_selector_0.VMIN.n15 ref_selector_0.VMIN.n14 1.79808
R12284 ref_selector_0.VMIN.n13 ref_selector_0.VMIN.n12 1.47886
R12285 ref_selector_0.VMIN.n12 ref_selector_0.VMIN.n11 1.36633
R12286 ref_selector_0.VMIN.n22 ref_selector_0.VMIN.n21 1.32702
R12287 ref_selector_0.VMIN ref_selector_0.VMIN.n22 1.31928
R12288 ref_selector_0.VMIN.n21 ref_selector_0.VMIN.n20 0.824161
R12289 ref_selector_0.VMIN.n6 ref_selector_0.VMIN.n5 0.434493
R12290 ref_selector_0.VMIN.n7 ref_selector_0.VMIN.n6 0.434493
R12291 ref_selector_0.VMIN.n8 ref_selector_0.VMIN.n7 0.434493
R12292 ref_selector_0.VMIN.n16 ref_selector_0.VMIN 0.296695
R12293 ref_selector_0.VMIN.n11 ref_selector_0.VMIN.n10 0.1655
R12294 ref_selector_0.VMIN.n9 ref_selector_0.VMIN.n8 0.0543298
R12295 ref_selector_0.VMIN.n19 ref_selector_0.VMIN.n18 0.0438016
R12296 ref_selector_0.VMIN.n20 ref_selector_0.VMIN.n19 0.0382143
R12297 ref_selector_0.VMIN.n22 ref_selector_0.VMIN 0.0335
R12298 ref_selector_0.VMIN.n2 ref_selector_0.VMIN.n1 0.00167021
R12299 a_9187_2339.t0 a_9187_2339.t1 30.5717
R12300 a_9593_2609.t0 a_9593_2609.t1 30.5717
R12301 a_7879_1259.t0 a_7879_1259.t1 41.1797
R12302 a_8285_989.t0 a_8285_989.t1 30.5717
R12303 a_9593_2069.t0 a_9593_2069.t1 30.5717
R12304 a_834_5436.t0 a_834_5436.t1 30.5928
R12305 ota_lv_gmid_comparator_0.ota_slow_gmid_common_0/ota_slow_gmid_pairs_0.tail.n0 ota_lv_gmid_comparator_0.ota_slow_gmid_common_0/ota_slow_gmid_pairs_0.tail.t2 7.71313
R12306 ota_lv_gmid_comparator_0.ota_slow_gmid_common_0/ota_slow_gmid_pairs_0.tail.n0 ota_lv_gmid_comparator_0.ota_slow_gmid_common_0/ota_slow_gmid_pairs_0.tail.t3 5.6454
R12307 ota_lv_gmid_comparator_0.ota_slow_gmid_common_0/ota_slow_gmid_pairs_0.tail.n1 ota_lv_gmid_comparator_0.ota_slow_gmid_common_0/ota_slow_gmid_pairs_0.tail.n0 5.31864
R12308 ota_lv_gmid_comparator_0.ota_slow_gmid_common_0/ota_slow_gmid_pairs_0.tail.n4 ota_lv_gmid_comparator_0.ota_slow_gmid_common_0/ota_slow_gmid_pairs_0.tail.t0 4.22086
R12309 ota_lv_gmid_comparator_0.ota_slow_gmid_common_0/ota_slow_gmid_pairs_0.tail ota_lv_gmid_comparator_0.ota_slow_gmid_common_0/ota_slow_gmid_pairs_0.tail.n4 3.42128
R12310 ota_lv_gmid_comparator_0.ota_slow_gmid_common_0/ota_slow_gmid_pairs_0.tail.n4 ota_lv_gmid_comparator_0.ota_slow_gmid_common_0/ota_slow_gmid_pairs_0.tail.t1 2.31228
R12311 ota_lv_gmid_comparator_0.ota_slow_gmid_common_0/ota_slow_gmid_pairs_0.tail.n3 ota_lv_gmid_comparator_0.ota_slow_gmid_common_0/ota_slow_gmid_pairs_0.tail.n2 0.3833
R12312 ota_lv_gmid_comparator_0.ota_slow_gmid_common_0/ota_slow_gmid_pairs_0.tail.n2 ota_lv_gmid_comparator_0.ota_slow_gmid_common_0/ota_slow_gmid_pairs_0.tail 0.196667
R12313 ota_lv_gmid_comparator_0.ota_slow_gmid_common_0/ota_slow_gmid_pairs_0.tail.n2 ota_lv_gmid_comparator_0.ota_slow_gmid_common_0/ota_slow_gmid_pairs_0.tail 0.125167
R12314 ota_lv_gmid_comparator_0.ota_slow_gmid_common_0/ota_slow_gmid_pairs_0.tail.n1 ota_lv_gmid_comparator_0.ota_slow_gmid_common_0/ota_slow_gmid_pairs_0.tail 0.1061
R12315 ota_lv_gmid_comparator_0.ota_slow_gmid_common_0/ota_slow_gmid_pairs_0.tail.n3 ota_lv_gmid_comparator_0.ota_slow_gmid_common_0/ota_slow_gmid_pairs_0.tail 0.0885
R12316 ota_lv_gmid_comparator_0.ota_slow_gmid_common_0/ota_slow_gmid_pairs_0.tail ota_lv_gmid_comparator_0.ota_slow_gmid_common_0/ota_slow_gmid_pairs_0.tail.n3 0.0511
R12317 ota_lv_gmid_comparator_0.ota_slow_gmid_common_0/ota_slow_gmid_pairs_0.tail ota_lv_gmid_comparator_0.ota_slow_gmid_common_0/ota_slow_gmid_pairs_0.tail.n1 0.0371667
R12318 a_17952_7390.t0 a_17952_7390.t1 30.5717
R12319 a_18222_7112.t0 a_18222_7112.t1 30.5717
R12320 a_n9334_4739.t0 a_n9334_4739.t1 30.5717
R12321 a_n9064_4085.t0 a_n9064_4085.t1 30.2659
R12322 a_n9874_3025.t0 a_n9874_3025.t1 30.5717
R12323 current_source_1mA_0.ota_med_hv_gmid_0.ota_med_hv_gmid_mirror_0.vota.n1 current_source_1mA_0.ota_med_hv_gmid_0.ota_med_hv_gmid_mirror_0.vota.t3 9.02534
R12324 current_source_1mA_0.ota_med_hv_gmid_0.ota_med_hv_gmid_mirror_0.vota.n3 current_source_1mA_0.ota_med_hv_gmid_0.ota_med_hv_gmid_mirror_0.vota.t6 7.92257
R12325 current_source_1mA_0.ota_med_hv_gmid_0.ota_med_hv_gmid_mirror_0.vota.n2 current_source_1mA_0.ota_med_hv_gmid_0.ota_med_hv_gmid_mirror_0.vota.t5 7.91597
R12326 current_source_1mA_0.ota_med_hv_gmid_0.ota_med_hv_gmid_mirror_0.vota.n2 current_source_1mA_0.ota_med_hv_gmid_0.ota_med_hv_gmid_mirror_0.vota.t0 6.87158
R12327 current_source_1mA_0.ota_med_hv_gmid_0.ota_med_hv_gmid_mirror_0.vota.n0 current_source_1mA_0.ota_med_hv_gmid_0.ota_med_hv_gmid_mirror_0.vota.t2 6.7265
R12328 current_source_1mA_0.ota_med_hv_gmid_0.ota_med_hv_gmid_mirror_0.vota.n4 current_source_1mA_0.ota_med_hv_gmid_0.ota_med_hv_gmid_mirror_0.vota.t1 6.53156
R12329 current_source_1mA_0.ota_med_hv_gmid_0.ota_med_hv_gmid_mirror_0.vota current_source_1mA_0.ota_med_hv_gmid_0.ota_med_hv_gmid_mirror_0.vota.n0 4.18748
R12330 current_source_1mA_0.ota_med_hv_gmid_0.ota_med_hv_gmid_mirror_0.vota.n0 current_source_1mA_0.ota_med_hv_gmid_0.ota_med_hv_gmid_mirror_0.vota.t4 2.29205
R12331 current_source_1mA_0.ota_med_hv_gmid_0.ota_med_hv_gmid_mirror_0.vota current_source_1mA_0.ota_med_hv_gmid_0.ota_med_hv_gmid_mirror_0.vota.n4 1.0367
R12332 current_source_1mA_0.ota_med_hv_gmid_0.ota_med_hv_gmid_mirror_0.vota current_source_1mA_0.ota_med_hv_gmid_0.ota_med_hv_gmid_mirror_0.vota.n1 0.4933
R12333 current_source_1mA_0.ota_med_hv_gmid_0.ota_med_hv_gmid_mirror_0.vota.n4 current_source_1mA_0.ota_med_hv_gmid_0.ota_med_hv_gmid_mirror_0.vota.n3 0.3393
R12334 current_source_1mA_0.ota_med_hv_gmid_0.ota_med_hv_gmid_mirror_0.vota.n3 current_source_1mA_0.ota_med_hv_gmid_0.ota_med_hv_gmid_mirror_0.vota.n2 0.2711
R12335 current_source_1mA_0.ota_med_hv_gmid_0.ota_med_hv_gmid_mirror_0.vota.n1 current_source_1mA_0.ota_med_hv_gmid_0.ota_med_hv_gmid_mirror_0.vota 0.2557
R12336 top_conditionning_level_shifter_0.EN_HV.n2 top_conditionning_level_shifter_0.EN_HV.n1 11.9344
R12337 top_conditionning_level_shifter_0.top_conditionning_inverter_0.Y top_conditionning_level_shifter_0.EN_HV.t1 6.00604
R12338 non_inverting_amplifier_hv_0.ota_hv_slow_gmid_0.EN_IN non_inverting_amplifier_hv_0.ota_hv_slow_gmid_0.ota_hv_slow_gmid_ctrl_inv_1.A 5.06394
R12339 current_source_1mA_0.ota_med_hv_gmid_0.ota_med_hv_gmid_enable_0.en_in top_conditionning_level_shifter_0.EN_HV.t2 4.46543
R12340 top_conditionning_level_shifter_0.EN_HV.n2 top_conditionning_level_shifter_0.EN_HV.t0 3.95257
R12341 non_inverting_amplifier_hv_0.ota_hv_slow_gmid_0.ota_hv_slow_gmid_ctrl_inv_1.A top_conditionning_level_shifter_0.EN_HV.t3 3.79952
R12342 top_conditionning_level_shifter_0.EN_HV.n1 non_inverting_amplifier_hv_0.ota_hv_slow_gmid_0.EN_IN 3.20948
R12343 top_conditionning_level_shifter_0.EN_HV.n1 top_conditionning_level_shifter_0.EN_HV.n0 1.8501
R12344 current_source_1mA_0.EN_IN current_source_1mA_0.ota_med_hv_gmid_0.ota_med_hv_gmid_enable_0.en_in 1.0917
R12345 top_conditionning_level_shifter_0.top_conditionning_inverter_0.Y top_conditionning_level_shifter_0.EN_HV.n2 0.736125
R12346 top_conditionning_level_shifter_0.EN_HV.n2 top_conditionning_level_shifter_0.top_conditionning_inverter_0.Y 0.5505
R12347 top_conditionning_level_shifter_0.EN_HV.n0 current_source_1mA_0.ota_med_hv_gmid_0.en_in 0.0511
R12348 top_conditionning_level_shifter_0.EN_HV.n0 current_source_1mA_0.EN_IN 0.0445
R12349 top_conditionning_level_shifter_0.EN_HV.n2 top_conditionning_level_shifter_0.top_conditionning_inverter_0.Y 0.0330926
R12350 top_conditionning_level_shifter_0.EN_HV.n0 current_source_1mA_0.ota_med_hv_gmid_0.en_in 0.0325
R12351 non_inverting_amplifier_hv_0.ota_hv_slow_gmid_0.ibiasn.n2 non_inverting_amplifier_hv_0.ota_hv_slow_gmid_0.ibiasn.t1 11.1523
R12352 non_inverting_amplifier_hv_0.ota_hv_slow_gmid_0.ibiasn.n2 non_inverting_amplifier_hv_0.ota_hv_slow_gmid_0.ibiasn.t0 10.6499
R12353 non_inverting_amplifier_hv_0.ota_hv_slow_gmid_0.ota_hv_slow_gmid_tail_0.ibiasn non_inverting_amplifier_hv_0.ota_hv_slow_gmid_0.ibiasn.n1 10.2163
R12354 non_inverting_amplifier_hv_0.ota_hv_slow_gmid_0.ibiasn.n1 non_inverting_amplifier_hv_0.ota_hv_slow_gmid_0.ibiasn.n0 6.3353
R12355 non_inverting_amplifier_hv_0.ota_hv_slow_gmid_0.ibiasn.n0 non_inverting_amplifier_hv_0.ota_hv_slow_gmid_0.ibiasn.t2 6.18247
R12356 non_inverting_amplifier_hv_0.ota_hv_slow_gmid_0.ibiasn.n0 non_inverting_amplifier_hv_0.ota_hv_slow_gmid_0.ibiasn.t3 2.24755
R12357 non_inverting_amplifier_hv_0.ota_hv_slow_gmid_0.ibiasn.n3 non_inverting_amplifier_hv_0.ota_hv_slow_gmid_0.ibiasn.n2 2.0266
R12358 non_inverting_amplifier_hv_0.ota_hv_slow_gmid_0.ibiasn.n1 non_inverting_amplifier_hv_0.ota_hv_slow_gmid_0.ota_hv_slow_gmid_buffer_0.ibiasn 0.2315
R12359 non_inverting_amplifier_hv_0.ota_hv_slow_gmid_0.ota_hv_slow_gmid_tail_0.ibiasn non_inverting_amplifier_hv_0.ota_hv_slow_gmid_0.ibiasn.n3 0.0361191
R12360 non_inverting_amplifier_hv_0.ota_hv_slow_gmid_0.ibiasn.n3 non_inverting_amplifier_hv_0.ota_hv_slow_gmid_0.ota_hv_slow_gmid_tail_0.ibiasn 0.0127623
R12361 S0.n0 S0 61.2913
R12362 S0 S0.t0 24.4581
R12363 S0.n0 S0 17.5103
R12364 S0 S0.n0 0.317944
R12365 ref_selector_0.ref_selector_r_refs_0.R0 ref_selector_0.ref_selector_r_refs_0.R0.t1 21.0714
R12366 ref_selector_0.ref_selector_r_refs_0.R0.t0 ref_selector_0.ref_selector_r_refs_0.R0.n0 8.90379
R12367 ref_selector_0.ref_selector_r_refs_0.R0.t0 ref_selector_0.ref_selector_r_refs_0.R0.n0 8.45088
R12368 ref_selector_0.ref_selector_r_refs_0.R0.n1 ref_selector_0.ref_selector_r_refs_0.R0.t0 4.53464
R12369 ref_selector_0.ref_selector_r_refs_0.R0.n2 ref_selector_0.ref_selector_r_refs_0.R0.n1 2.5105
R12370 ref_selector_0.ref_selector_r_refs_0.R0.n2 ref_selector_0.ref_selector_r_refs_0.R0 0.504228
R12371 ref_selector_0.ref_selector_r_refs_0.R0.n1 ref_selector_0.ref_selector_r_refs_0.R0.n0 0.206001
R12372 ref_selector_0.ref_selector_r_refs_0.R0 ref_selector_0.ref_selector_r_refs_0.R0.n2 0.0298333
R12373 a_18762_7916.t0 a_18762_7916.t1 30.5717
R12374 a_19032_7638.t0 a_19032_7638.t1 30.5717
R12375 two_stage_instrumentation_amplifier_0.ota_slow_gmid_0.ota_slow_gmid_mirror_0.vref.n0 two_stage_instrumentation_amplifier_0.ota_slow_gmid_0.ota_slow_gmid_mirror_0.vref.t3 18.8035
R12376 two_stage_instrumentation_amplifier_0.ota_slow_gmid_0.ota_slow_gmid_mirror_0.vref.n5 two_stage_instrumentation_amplifier_0.ota_slow_gmid_0.ota_slow_gmid_mirror_0.vref 17.2524
R12377 two_stage_instrumentation_amplifier_0.ota_slow_gmid_0.ota_slow_gmid_mirror_0.vref.n4 two_stage_instrumentation_amplifier_0.ota_slow_gmid_0.ota_slow_gmid_mirror_0.vref.t5 17.0658
R12378 two_stage_instrumentation_amplifier_0.ota_slow_gmid_0.ota_slow_gmid_mirror_0.vref.n5 two_stage_instrumentation_amplifier_0.ota_slow_gmid_0.ota_slow_gmid_mirror_0.vref.t1 13.9919
R12379 two_stage_instrumentation_amplifier_0.ota_slow_gmid_0.ota_slow_gmid_mirror_0.vref.n3 two_stage_instrumentation_amplifier_0.ota_slow_gmid_0.ota_slow_gmid_mirror_0.vref.n2 5.7556
R12380 two_stage_instrumentation_amplifier_0.ota_slow_gmid_0.ota_slow_gmid_mirror_0.vref two_stage_instrumentation_amplifier_0.ota_slow_gmid_0.ota_slow_gmid_mirror_0.vref.n4 5.4971
R12381 two_stage_instrumentation_amplifier_0.ota_slow_gmid_0.ota_slow_gmid_mirror_0.vref.n6 two_stage_instrumentation_amplifier_0.ota_slow_gmid_0.ota_slow_gmid_mirror_0.vref.t0 5.39669
R12382 two_stage_instrumentation_amplifier_0.ota_slow_gmid_0.ota_slow_gmid_mirror_0.vref two_stage_instrumentation_amplifier_0.ota_slow_gmid_0.ota_slow_gmid_mirror_0.vref.n5 4.8735
R12383 two_stage_instrumentation_amplifier_0.ota_slow_gmid_0.ota_slow_gmid_mirror_0.vref.n4 two_stage_instrumentation_amplifier_0.ota_slow_gmid_0.ota_slow_gmid_mirror_0.vref.n3 2.0109
R12384 two_stage_instrumentation_amplifier_0.ota_slow_gmid_0.ota_slow_gmid_mirror_0.vref.n2 two_stage_instrumentation_amplifier_0.ota_slow_gmid_0.ota_slow_gmid_mirror_0.vref.n1 1.76518
R12385 two_stage_instrumentation_amplifier_0.ota_slow_gmid_0.ota_slow_gmid_mirror_0.vref.t2 two_stage_instrumentation_amplifier_0.ota_slow_gmid_0.ota_slow_gmid_mirror_0.vref.n0 1.29907
R12386 two_stage_instrumentation_amplifier_0.ota_slow_gmid_0.ota_slow_gmid_mirror_0.vref.n2 two_stage_instrumentation_amplifier_0.ota_slow_gmid_0.ota_slow_gmid_mirror_0.vref.n0 0.708083
R12387 two_stage_instrumentation_amplifier_0.ota_slow_gmid_0.ota_slow_gmid_mirror_0.vref.n3 two_stage_instrumentation_amplifier_0.ota_slow_gmid_0.ota_slow_gmid_mirror_0.vref.t4 0.610499
R12388 two_stage_instrumentation_amplifier_0.ota_slow_gmid_0.ota_slow_gmid_mirror_0.vref two_stage_instrumentation_amplifier_0.ota_slow_gmid_0.ota_slow_gmid_mirror_0.vref.n6 0.0885
R12389 two_stage_instrumentation_amplifier_0.ota_slow_gmid_0.ota_slow_gmid_mirror_0.vref.n6 two_stage_instrumentation_amplifier_0.ota_slow_gmid_0.ota_slow_gmid_mirror_0.vref 0.0445
R12390 two_stage_instrumentation_amplifier_0.ota_slow_gmid_0.ota_slow_gmid_mirror_0.vref.n1 two_stage_instrumentation_amplifier_0.ota_slow_gmid_0.ota_slow_gmid_mirror_0.vref.t4 0.0077626
R12391 two_stage_instrumentation_amplifier_0.ota_slow_gmid_0.ota_slow_gmid_mirror_0.vref.n1 two_stage_instrumentation_amplifier_0.ota_slow_gmid_0.ota_slow_gmid_mirror_0.vref.t2 0.00323589
R12392 non_inverting_amplifier_hv_0.top_conditionning_gain_s3_0.vn3.n2 non_inverting_amplifier_hv_0.top_conditionning_gain_s3_0.vn3.t1 22.4526
R12393 non_inverting_amplifier_hv_0.top_conditionning_gain_s3_0.vn3.n2 non_inverting_amplifier_hv_0.top_conditionning_gain_s3_0.vn3.t0 19.7142
R12394 non_inverting_amplifier_hv_0.top_conditionning_gain_s3_0.vn3 non_inverting_amplifier_hv_0.top_conditionning_gain_s3_0.vn3.n1 14.494
R12395 non_inverting_amplifier_hv_0.top_conditionning_gain_s3_0.vn3.n0 non_inverting_amplifier_hv_0.top_conditionning_gain_s3_0.vn3.t3 8.342
R12396 non_inverting_amplifier_hv_0.top_conditionning_gain_s3_0.vn3.n1 non_inverting_amplifier_hv_0.top_conditionning_gain_s3_0.vn3.t2 6.61254
R12397 non_inverting_amplifier_hv_0.top_conditionning_gain_s3_0.vn3.n0 non_inverting_amplifier_hv_0.top_conditionning_gain_s3_0.vn3 6.2727
R12398 non_inverting_amplifier_hv_0.top_conditionning_gain_s3_0.vn3.n1 non_inverting_amplifier_hv_0.top_conditionning_gain_s3_0.vn3.n0 1.46423
R12399 non_inverting_amplifier_hv_0.top_conditionning_gain_s3_0.vn3 non_inverting_amplifier_hv_0.top_conditionning_gain_s3_0.vn3.n2 0.553885
R12400 rmod.n0 rmod.t0 26.1009
R12401 rmod.n0 rmod.t1 15.0005
R12402 rmod rmod.n0 0.0119925
R12403 a_18222_8968.t0 a_18222_8968.t1 30.5717
R12404 a_17952_8690.t0 a_17952_8690.t1 30.5717
R12405 a_18222_6864.t0 a_18222_6864.t1 30.5717
R12406 a_17952_6586.t0 a_17952_6586.t1 30.5717
R12407 a_17412_8442.t0 a_17412_8442.t1 30.5717
R12408 a_17412_8164.t0 a_17412_8164.t1 30.5182
R12409 a_n16824_5507.t0 a_n16824_5507.t1 43.3937
R12410 a_18492_7638.t0 a_18492_7638.t1 40.4428
R12411 EN.n4 EN.n2 63.5889
R12412 EN.n6 EN 33.6112
R12413 EN EN.n6 27.4518
R12414 EN.n6 EN.n5 16.5384
R12415 EN.n1 EN.t3 15.226
R12416 EN.n0 EN.t0 15.2113
R12417 EN EN.t1 15.1728
R12418 EN.n4 EN.n3 9.3757
R12419 EN.n2 EN.n1 9.3735
R12420 EN EN.n0 5.65867
R12421 EN EN.t2 3.79771
R12422 EN.n5 EN 0.769016
R12423 EN.n2 EN 0.3261
R12424 EN.n5 EN 0.225616
R12425 EN EN.n4 0.1567
R12426 EN.n3 EN 0.0536667
R12427 EN.n0 EN 0.05
R12428 EN.n3 EN 0.0396471
R12429 EN.n1 EN 0.0353333
R12430 ota_lv_gmid_comparator_0.ota_slow_gmid_ctrl_buff_1.ota_slow_gmid_ctrl_inv_0.x ota_lv_gmid_comparator_0.ota_slow_gmid_ctrl_buff_1.ota_slow_gmid_ctrl_inv_0.x.t2 15.2608
R12431 ota_lv_gmid_comparator_0.ota_slow_gmid_ctrl_buff_1.ota_slow_gmid_ctrl_inv_0.x.n0 ota_lv_gmid_comparator_0.ota_slow_gmid_ctrl_buff_1.ota_slow_gmid_ctrl_inv_0.x.t1 3.55057
R12432 ota_lv_gmid_comparator_0.ota_slow_gmid_ctrl_buff_1.ota_slow_gmid_ctrl_inv_0.x.n0 ota_lv_gmid_comparator_0.ota_slow_gmid_ctrl_buff_1.ota_slow_gmid_ctrl_inv_0.x.t0 3.47311
R12433 ota_lv_gmid_comparator_0.ota_slow_gmid_ctrl_buff_1.ota_slow_gmid_ctrl_inv_0.x ota_lv_gmid_comparator_0.ota_slow_gmid_ctrl_buff_1.ota_slow_gmid_ctrl_inv_0.x.n0 0.204
R12434 ota_lv_gmid_comparator_0.ota_slow_gmid_mirror_0.vota.n2 ota_lv_gmid_comparator_0.ota_slow_gmid_mirror_0.vota.t2 34.4823
R12435 ota_lv_gmid_comparator_0.ota_slow_gmid_mirror_0.vota.n1 ota_lv_gmid_comparator_0.ota_slow_gmid_mirror_0.vota.t3 17.0005
R12436 ota_lv_gmid_comparator_0.ota_slow_gmid_mirror_0.vota.n0 ota_lv_gmid_comparator_0.ota_slow_gmid_mirror_0.vota.t0 11.1062
R12437 ota_lv_gmid_comparator_0.ota_slow_gmid_mirror_0.vota ota_lv_gmid_comparator_0.ota_slow_gmid_mirror_0.vota.n3 5.4993
R12438 ota_lv_gmid_comparator_0.ota_slow_gmid_mirror_0.vota.n0 ota_lv_gmid_comparator_0.ota_slow_gmid_mirror_0.vota.t1 4.52664
R12439 ota_lv_gmid_comparator_0.ota_slow_gmid_mirror_0.vota.n1 ota_lv_gmid_comparator_0.ota_slow_gmid_mirror_0.vota.t5 4.28336
R12440 ota_lv_gmid_comparator_0.ota_slow_gmid_mirror_0.vota.n2 ota_lv_gmid_comparator_0.ota_slow_gmid_mirror_0.vota.t4 4.15409
R12441 ota_lv_gmid_comparator_0.ota_slow_gmid_mirror_0.vota ota_lv_gmid_comparator_0.ota_slow_gmid_mirror_0.vota.n0 2.95082
R12442 ota_lv_gmid_comparator_0.ota_slow_gmid_mirror_0.vota.n3 ota_lv_gmid_comparator_0.ota_slow_gmid_mirror_0.vota.n2 0.677202
R12443 ota_lv_gmid_comparator_0.ota_slow_gmid_mirror_0.vota.n3 ota_lv_gmid_comparator_0.ota_slow_gmid_mirror_0.vota.n1 0.0169567
R12444 a_8939_1529.t0 a_8939_1529.t1 30.5717
R12445 a_6571_2609.t0 a_6571_2609.t1 30.5717
R12446 a_6977_2879.t0 a_6977_2879.t1 33.3496
R12447 a_8939_989.t0 a_8939_989.t1 30.5717
R12448 VBG.n0 VBG.t1 24.6937
R12449 VBG.n0 VBG.t0 12.045
R12450 VBG VBG.n0 2.9397
R12451 ota_lv_gmid_comparator_0.ota_slow_gmid_mirror_0.vref.n2 ota_lv_gmid_comparator_0.ota_slow_gmid_mirror_0.vref 20.7344
R12452 ota_lv_gmid_comparator_0.ota_slow_gmid_mirror_0.vref.n0 ota_lv_gmid_comparator_0.ota_slow_gmid_mirror_0.vref.t3 19.5609
R12453 ota_lv_gmid_comparator_0.ota_slow_gmid_mirror_0.vref.n1 ota_lv_gmid_comparator_0.ota_slow_gmid_mirror_0.vref.t4 17.0658
R12454 ota_lv_gmid_comparator_0.ota_slow_gmid_mirror_0.vref.n2 ota_lv_gmid_comparator_0.ota_slow_gmid_mirror_0.vref.t1 13.9935
R12455 ota_lv_gmid_comparator_0.ota_slow_gmid_mirror_0.vref ota_lv_gmid_comparator_0.ota_slow_gmid_mirror_0.vref.n1 5.4971
R12456 ota_lv_gmid_comparator_0.ota_slow_gmid_mirror_0.vref.n3 ota_lv_gmid_comparator_0.ota_slow_gmid_mirror_0.vref.t0 5.39538
R12457 ota_lv_gmid_comparator_0.ota_slow_gmid_mirror_0.vref.n3 ota_lv_gmid_comparator_0.ota_slow_gmid_mirror_0.vref.n2 4.9175
R12458 ota_lv_gmid_comparator_0.ota_slow_gmid_mirror_0.vref.n1 ota_lv_gmid_comparator_0.ota_slow_gmid_mirror_0.vref.n0 2.51451
R12459 ota_lv_gmid_comparator_0.ota_slow_gmid_mirror_0.vref.n3 ota_lv_gmid_comparator_0.ota_slow_gmid_mirror_0.vref 0.0885
R12460 ota_lv_gmid_comparator_0.ota_slow_gmid_mirror_0.vref.n0 ota_lv_gmid_comparator_0.ota_slow_gmid_mirror_0.vref.t2 0.0523162
R12461 ota_lv_gmid_comparator_0.ota_slow_gmid_mirror_0.vref ota_lv_gmid_comparator_0.ota_slow_gmid_mirror_0.vref.n3 0.0445
R12462 a_18762_8968.t0 a_18762_8968.t1 30.5717
R12463 a_19032_8690.t0 a_19032_8690.t1 30.5717
R12464 a_18762_6864.t0 a_18762_6864.t1 30.5717
R12465 a_19032_6586.t0 a_19032_6586.t1 30.5717
R12466 a_18222_8442.t0 a_18222_8442.t1 30.5717
R12467 a_17682_8164.t0 a_17682_8164.t1 31.6533
R12468 a_n9604_4333.t0 a_n9604_4333.t1 30.5717
R12469 a_8533_719.t0 a_8533_719.t1 30.5717
R12470 a_n9874_2535.t0 a_n9874_2535.t1 30.5717
R12471 a_n9064_2009.t0 a_n9064_2009.t1 30.2659
R12472 a_n9064_1483.t0 a_n9064_1483.t1 30.2659
R12473 a_19302_7916.t0 a_19302_7916.t1 33.2204
R12474 a_7225_1799.t0 a_7225_1799.t1 30.5717
R12475 two_stage_instrumentation_amplifier_0.top_conditionning_gain_s2_0.vn2.n1 two_stage_instrumentation_amplifier_0.top_conditionning_gain_s2_0.vn2.t0 15.3157
R12476 two_stage_instrumentation_amplifier_0.top_conditionning_gain_s2_0.vn2.n1 two_stage_instrumentation_amplifier_0.top_conditionning_gain_s2_0.vn2.t1 15.2565
R12477 two_stage_instrumentation_amplifier_0.top_conditionning_gain_s2_0.vn2.n0 two_stage_instrumentation_amplifier_0.top_conditionning_gain_s2_0.vn2.t2 9.00326
R12478 two_stage_instrumentation_amplifier_0.top_conditionning_gain_s2_0.vn2.n0 two_stage_instrumentation_amplifier_0.top_conditionning_gain_s2_0.vn2.t3 4.87123
R12479 two_stage_instrumentation_amplifier_0.top_conditionning_gain_s2_0.vn2 two_stage_instrumentation_amplifier_0.top_conditionning_gain_s2_0.vn2.n0 3.61023
R12480 two_stage_instrumentation_amplifier_0.top_conditionning_gain_s2_0.vn2 two_stage_instrumentation_amplifier_0.top_conditionning_gain_s2_0.vn2.n1 3.0655
R12481 a_8285_1799.t0 a_8285_1799.t1 30.5717
R12482 a_7225_2609.t0 a_7225_2609.t1 30.5717
R12483 a_7631_2339.t0 a_7631_2339.t1 30.5717
R12484 a_n9334_3025.t0 a_n9334_3025.t1 30.5717
R12485 a_7879_2609.t0 a_7879_2609.t1 30.5717
R12486 a_8285_2339.t0 a_8285_2339.t1 30.5717
R12487 a_18762_8442.t0 a_18762_8442.t1 30.5717
R12488 a_19032_8164.t0 a_19032_8164.t1 30.5717
R12489 a_17682_7638.t0 a_17682_7638.t1 30.5717
R12490 a_19302_7390.t0 a_19302_7390.t1 30.5717
R12491 a_18762_7112.t0 a_18762_7112.t1 31.2037
R12492 a_14614_1527.t0 a_14614_1527.t1 31.8657
R12493 a_6977_719.t0 a_6977_719.t1 30.5717
R12494 a_n1930_5507.t0 a_n1930_5507.t1 32.8145
R12495 a_n2210_4821.t0 a_n2210_4821.t1 30.5928
R12496 a_14750_1527.t0 a_14750_1527.t1 31.1765
R12497 a_19302_8968.t0 a_19302_8968.t1 30.5717
R12498 top_conditionning_level_shifter_0.top_conditionning_inverter_0.X top_conditionning_level_shifter_0.top_conditionning_inverter_0.X.t0 18.211
R12499 top_conditionning_level_shifter_0.top_conditionning_inverter_0.X.n0 top_conditionning_level_shifter_0.top_conditionning_inverter_0.X.t2 5.04944
R12500 top_conditionning_level_shifter_0.top_conditionning_inverter_0.X.n1 top_conditionning_level_shifter_0.top_conditionning_inverter_0.X.t3 3.73567
R12501 top_conditionning_level_shifter_0.top_conditionning_inverter_0.X.n0 top_conditionning_level_shifter_0.top_conditionning_inverter_0.X.t1 2.16415
R12502 top_conditionning_level_shifter_0.top_conditionning_inverter_0.X top_conditionning_level_shifter_0.top_conditionning_inverter_0.X.n0 0.815132
R12503 top_conditionning_level_shifter_0.top_conditionning_inverter_0.X.n1 top_conditionning_level_shifter_0.top_conditionning_inverter_0.X 0.780382
R12504 top_conditionning_level_shifter_0.top_conditionning_inverter_0.X top_conditionning_level_shifter_0.top_conditionning_inverter_0.X.n1 0.0470773
R12505 two_stage_instrumentation_amplifier_0.ota_slow_gmid_0.ota_slow_gmid_common_0/ota_slow_gmid_pairs_0.tail.n0 two_stage_instrumentation_amplifier_0.ota_slow_gmid_0.ota_slow_gmid_common_0/ota_slow_gmid_pairs_0.tail.t3 7.71313
R12506 two_stage_instrumentation_amplifier_0.ota_slow_gmid_0.ota_slow_gmid_common_0/ota_slow_gmid_pairs_0.tail.n0 two_stage_instrumentation_amplifier_0.ota_slow_gmid_0.ota_slow_gmid_common_0/ota_slow_gmid_pairs_0.tail.t2 5.6454
R12507 two_stage_instrumentation_amplifier_0.ota_slow_gmid_0.ota_slow_gmid_common_0/ota_slow_gmid_pairs_0.tail.n1 two_stage_instrumentation_amplifier_0.ota_slow_gmid_0.ota_slow_gmid_common_0/ota_slow_gmid_pairs_0.tail.n0 5.31864
R12508 two_stage_instrumentation_amplifier_0.ota_slow_gmid_0.ota_slow_gmid_common_0/ota_slow_gmid_pairs_0.tail.n3 two_stage_instrumentation_amplifier_0.ota_slow_gmid_0.ota_slow_gmid_common_0/ota_slow_gmid_pairs_0.tail.t1 4.22086
R12509 two_stage_instrumentation_amplifier_0.ota_slow_gmid_0.ota_slow_gmid_common_0/ota_slow_gmid_pairs_0.tail two_stage_instrumentation_amplifier_0.ota_slow_gmid_0.ota_slow_gmid_common_0/ota_slow_gmid_pairs_0.tail.n3 3.42128
R12510 two_stage_instrumentation_amplifier_0.ota_slow_gmid_0.ota_slow_gmid_common_0/ota_slow_gmid_pairs_0.tail.n3 two_stage_instrumentation_amplifier_0.ota_slow_gmid_0.ota_slow_gmid_common_0/ota_slow_gmid_pairs_0.tail.t0 2.31228
R12511 two_stage_instrumentation_amplifier_0.ota_slow_gmid_0.ota_slow_gmid_common_0/ota_slow_gmid_pairs_0.tail two_stage_instrumentation_amplifier_0.ota_slow_gmid_0.ota_slow_gmid_common_0/ota_slow_gmid_pairs_0.tail.n2 0.2953
R12512 two_stage_instrumentation_amplifier_0.ota_slow_gmid_0.ota_slow_gmid_common_0/ota_slow_gmid_pairs_0.tail.n2 two_stage_instrumentation_amplifier_0.ota_slow_gmid_0.ota_slow_gmid_common_0/ota_slow_gmid_pairs_0.tail.n1 0.161833
R12513 two_stage_instrumentation_amplifier_0.ota_slow_gmid_0.ota_slow_gmid_common_0/ota_slow_gmid_pairs_0.tail.n2 two_stage_instrumentation_amplifier_0.ota_slow_gmid_0.ota_slow_gmid_common_0/ota_slow_gmid_pairs_0.tail 0.123333
R12514 two_stage_instrumentation_amplifier_0.ota_slow_gmid_0.ota_slow_gmid_common_0/ota_slow_gmid_pairs_0.tail.n1 two_stage_instrumentation_amplifier_0.ota_slow_gmid_0.ota_slow_gmid_common_0/ota_slow_gmid_pairs_0.tail 0.1061
R12515 two_stage_instrumentation_amplifier_0.ota_slow_gmid_0.ota_slow_gmid_common_0/ota_slow_gmid_pairs_0.tail.n1 two_stage_instrumentation_amplifier_0.ota_slow_gmid_0.ota_slow_gmid_common_0/ota_slow_gmid_pairs_0.tail 0.0371667
R12516 a_17682_7112.t0 a_17682_7112.t1 30.5717
R12517 a_19302_6864.t0 a_19302_6864.t1 30.5717
R12518 a_8533_1799.t0 a_8533_1799.t1 30.5717
R12519 S2.n0 S2 57.4373
R12520 S2 S2.t0 24.4581
R12521 S2.n0 S2 9.70895
R12522 S2 S2.n0 0.688645
R12523 ref_selector_0.ref_selector_r_refs_0.R2 ref_selector_0.ref_selector_r_refs_0.R2.t0 21.0606
R12524 ref_selector_0.ref_selector_r_refs_0.R2 ref_selector_0.ref_selector_r_refs_0.R2.t1 4.91069
R12525 a_n9874_4739.t0 a_n9874_4739.t1 30.5717
R12526 a_17952_8442.t0 a_17952_8442.t1 41.3337
R12527 a_n9604_2009.t0 a_n9604_2009.t1 30.5717
R12528 a_17682_8968.t0 a_17682_8968.t1 30.5717
R12529 a_8533_2609.t0 a_8533_2609.t1 30.5717
R12530 a_8939_2339.t0 a_8939_2339.t1 30.5717
R12531 a_7631_2879.t0 a_7631_2879.t1 33.6319
R12532 a_8939_2069.t0 a_8939_2069.t1 35.4926
R12533 a_17682_6864.t0 a_17682_6864.t1 30.5717
R12534 a_n9604_4085.t0 a_n9604_4085.t1 30.5717
R12535 a_18492_7390.t0 a_18492_7390.t1 30.5717
R12536 a_n9604_3431.t0 a_n9604_3431.t1 30.5717
R12537 a_n9334_2535.t0 a_n9334_2535.t1 30.5717
R12538 a_19302_8442.t0 a_19302_8442.t1 30.5717
R12539 dw_n18308_4910.t0 dw_n18308_4910.n31 24.5377
R12540 dw_n18308_4910.n10 dw_n18308_4910.n0 17.001
R12541 dw_n18308_4910.n24 dw_n18308_4910.n12 17.0005
R12542 dw_n18308_4910.t6 dw_n18308_4910.n30 17.0005
R12543 dw_n18308_4910.t6 dw_n18308_4910.n1 17.0005
R12544 dw_n18308_4910.t6 dw_n18308_4910.n4 17.0005
R12545 dw_n18308_4910.t6 dw_n18308_4910.n2 17.0005
R12546 dw_n18308_4910.t6 dw_n18308_4910.n3 17.0005
R12547 dw_n18308_4910.n29 dw_n18308_4910.n28 17.0005
R12548 dw_n18308_4910.n28 dw_n18308_4910.n27 17.0005
R12549 dw_n18308_4910.n9 dw_n18308_4910.n7 17.0005
R12550 dw_n18308_4910.n9 dw_n18308_4910.n8 17.0005
R12551 dw_n18308_4910.n22 dw_n18308_4910.n21 9.59883
R12552 dw_n18308_4910.t4 dw_n18308_4910.n6 8.501
R12553 dw_n18308_4910.n26 dw_n18308_4910.t4 8.501
R12554 dw_n18308_4910.t4 dw_n18308_4910.n10 8.501
R12555 dw_n18308_4910.n11 dw_n18308_4910.n5 8.47419
R12556 dw_n18308_4910.n19 dw_n18308_4910.n18 5.63337
R12557 dw_n18308_4910.n31 dw_n18308_4910.t6 5.5825
R12558 dw_n18308_4910.n21 dw_n18308_4910.n13 4.83039
R12559 dw_n18308_4910.n16 dw_n18308_4910.t7 4.0444
R12560 dw_n18308_4910.n19 dw_n18308_4910.t3 3.74819
R12561 dw_n18308_4910.n12 dw_n18308_4910.t5 3.5691
R12562 dw_n18308_4910.n14 dw_n18308_4910.t2 2.52558
R12563 dw_n18308_4910.n15 dw_n18308_4910.t8 2.3576
R12564 dw_n18308_4910.n17 dw_n18308_4910.n16 2.29433
R12565 dw_n18308_4910.n21 dw_n18308_4910.n20 1.8005
R12566 dw_n18308_4910.n24 dw_n18308_4910.n23 1.35199
R12567 dw_n18308_4910.t4 dw_n18308_4910.n25 1.30869
R12568 dw_n18308_4910.n17 dw_n18308_4910.n15 1.29902
R12569 dw_n18308_4910.n18 dw_n18308_4910.t1 0.895237
R12570 dw_n18308_4910.t1 dw_n18308_4910.n17 0.895237
R12571 dw_n18308_4910.n18 dw_n18308_4910.n14 0.867725
R12572 dw_n18308_4910.n23 dw_n18308_4910.n5 0.704674
R12573 dw_n18308_4910.n20 dw_n18308_4910.n14 0.683595
R12574 dw_n18308_4910.n23 dw_n18308_4910.n22 0.543602
R12575 dw_n18308_4910.n15 dw_n18308_4910.n13 0.435339
R12576 dw_n18308_4910.n16 dw_n18308_4910.n13 0.371712
R12577 dw_n18308_4910.n31 dw_n18308_4910.n0 0.213093
R12578 dw_n18308_4910.n20 dw_n18308_4910.n19 0.145463
R12579 dw_n18308_4910.n30 dw_n18308_4910.n5 0.0620144
R12580 dw_n18308_4910.n22 dw_n18308_4910.n12 0.0588673
R12581 dw_n18308_4910.n8 dw_n18308_4910.n3 0.0230746
R12582 dw_n18308_4910.n30 dw_n18308_4910.n29 0.0210224
R12583 dw_n18308_4910.n7 dw_n18308_4910.n2 0.0193806
R12584 dw_n18308_4910.n3 dw_n18308_4910.n0 0.0189701
R12585 dw_n18308_4910.n27 dw_n18308_4910.n1 0.0169179
R12586 dw_n18308_4910.n27 dw_n18308_4910.n4 0.0156866
R12587 dw_n18308_4910.n7 dw_n18308_4910.n4 0.0132239
R12588 dw_n18308_4910.n29 dw_n18308_4910.n1 0.0119925
R12589 dw_n18308_4910.n8 dw_n18308_4910.n2 0.00952985
R12590 dw_n18308_4910.n25 dw_n18308_4910.n11 0.001
R12591 dw_n18308_4910.n11 dw_n18308_4910.n6 0.001
R12592 dw_n18308_4910.n28 dw_n18308_4910.n26 0.001
R12593 dw_n18308_4910.n10 dw_n18308_4910.n9 0.001
R12594 dw_n18308_4910.n25 dw_n18308_4910.n24 0.001
R12595 dw_n18308_4910.n28 dw_n18308_4910.n6 0.001
R12596 dw_n18308_4910.n26 dw_n18308_4910.n9 0.001
R12597 a_n5418_4249.t0 a_n5418_4249.t1 30.5928
R12598 a_n4832_4529.t0 a_n4832_4529.t1 32.8154
R12599 a_18492_8690.t0 a_18492_8690.t1 30.5717
R12600 a_n4533_4821.t0 a_n4533_4821.t1 30.5928
R12601 a_18492_6586.t0 a_18492_6586.t1 30.5717
R12602 a_5221_5436.t0 a_5221_5436.t1 30.5928
R12603 a_n4253_5507.t0 a_n4253_5507.t1 43.3937
R12604 a_n17989_4249.t0 a_n17989_4249.t1 30.5928
R12605 a_6571_989.t0 a_6571_989.t1 30.5717
R12606 a_9187_719.t0 a_9187_719.t1 30.5717
R12607 a_7879_719.t0 a_7879_719.t1 30.5717
R12608 a_n9334_1205.t0 a_n9334_1205.t1 30.5717
R12609 a_18492_8164.t0 a_18492_8164.t1 30.5717
R12610 a_n9604_2257.t0 a_n9604_2257.t1 30.5717
R12611 a_6571_1529.t0 a_6571_1529.t1 30.5717
R12612 a_6977_1259.t0 a_6977_1259.t1 30.5717
R12613 ref_selector_0.ref_selector_r_refs_0.R1 ref_selector_0.ref_selector_r_refs_0.R1.t0 21.0606
R12614 ref_selector_0.ref_selector_r_refs_0.R1.n0 ref_selector_0.ref_selector_r_refs_0.R1.t1 4.77868
R12615 ref_selector_0.ref_selector_r_refs_0.R1 ref_selector_0.ref_selector_r_refs_0.R1.n0 1.21767
R12616 ref_selector_0.ref_selector_r_refs_0.R1.n0 ref_selector_0.ref_selector_r_refs_0.R1 0.0298333
R12617 a_17412_7948.t0 a_17412_7948.t1 40.5169
R12618 a_9187_1259.t0 a_9187_1259.t1 30.5717
R12619 a_9593_989.t0 a_9593_989.t1 30.5717
R12620 a_19572_8164.t0 a_19572_8164.t1 31.7525
R12621 ota_lv_gmid_comparator_0.ota_slow_gmid_common_0/ota_slow_gmid_tail_0.ibiasn.n0 ota_lv_gmid_comparator_0.ota_slow_gmid_common_0/ota_slow_gmid_tail_0.ibiasn.t0 10.2769
R12622 ota_lv_gmid_comparator_0.ota_slow_gmid_common_0/ota_slow_gmid_tail_0.ibiasn ota_lv_gmid_comparator_0.ota_slow_gmid_common_0/ota_slow_gmid_tail_0.ibiasn.n0 5.8926
R12623 ota_lv_gmid_comparator_0.ota_slow_gmid_common_0/ota_slow_gmid_tail_0.ibiasn.n0 ota_lv_gmid_comparator_0.ota_slow_gmid_common_0/ota_slow_gmid_tail_0.ibiasn.t1 5.69411
R12624 S1.n0 S1 60.0596
R12625 S1 S1.t0 24.4581
R12626 S1.n0 S1 14.9013
R12627 S1 S1.n0 0.5571
R12628 a_6977_1799.t0 a_6977_1799.t1 30.5717
R12629 a_6977_2339.t0 a_6977_2339.t1 30.5717
R12630 a_6571_2069.t0 a_6571_2069.t1 30.5717
C601 VBG VSS 50.37963f
C602 COMPARATOR_RES VSS 18.8965f
C603 SEL_SENSOR VSS 28.66695f
C604 SENSOR VSS 15.56137f
C605 SEL_CAL VSS 35.28221f
C606 S0 VSS 26.58555f
C607 S1 VSS 31.80991f
C608 S3 VSS 31.00262f
C609 S2 VSS 29.95966f
C610 VBIASH VSS 37.03408f
C611 VBIAS VSS 23.37985f
C612 VOUT VSS 9.00151f
C613 EN VSS 34.18866f
C614 VDD VSS 33.00906f
C615 IOVDD VSS 10.04139f
C616 a_15414_530# VSS 0.57101f
C617 a_15014_530# VSS 0.35875f
C618 a_14614_530# VSS 0.42968f
C619 a_14214_530# VSS 0.38544f
C620 a_13814_530# VSS 0.5752f
C621 a_25180_4528# VSS 0.03459f $ **FLOATING
C622 a_22466_4528# VSS 0.04649f $ **FLOATING
C623 a_20434_4528# VSS 0.03459f $ **FLOATING
C624 a_15414_1176# VSS 0.58857f
C625 a_15014_1176# VSS 0.49392f
C626 a_14614_1176# VSS 0.35255f
C627 a_14214_1176# VSS 0.3777f
C628 a_13814_1176# VSS 0.56674f
C629 a_15414_1822# VSS 0.56077f
C630 a_15014_1822# VSS 0.36381f
C631 a_14614_1822# VSS 0.35696f
C632 a_14214_1822# VSS 0.36458f
C633 a_13814_1822# VSS 0.56725f
C634 a_13645_2486# VSS 0.03794f $ **FLOATING
C635 a_12547_246# VSS 0.26378f
C636 a_12277_246# VSS 0.22554f
C637 a_12007_246# VSS 0.1813f
C638 a_11737_246# VSS 0.21579f
C639 a_11467_246# VSS 0.19242f
C640 a_11197_246# VSS 0.21711f
C641 a_10927_246# VSS 0.18731f
C642 a_10657_246# VSS 0.22682f
C643 a_10387_246# VSS 0.27385f
C644 a_12547_900# VSS 0.26394f
C645 a_12277_900# VSS 0.22687f
C646 a_12007_900# VSS 0.1673f
C647 a_11737_900# VSS 0.16456f
C648 a_11467_900# VSS 0.16333f
C649 a_11197_900# VSS 0.16456f
C650 a_10927_900# VSS 0.16333f
C651 a_10657_900# VSS 0.22482f
C652 a_10387_900# VSS 0.27034f
C653 a_12547_1554# VSS 0.26382f
C654 a_12277_1554# VSS 0.22685f
C655 a_12007_1554# VSS 0.16458f
C656 a_11737_1554# VSS 0.15705f
C657 a_11467_1554# VSS 0.14351f
C658 a_11197_1554# VSS 0.15737f
C659 a_10927_1554# VSS 0.15944f
C660 a_10657_1554# VSS 0.2225f
C661 a_10387_1554# VSS 0.26864f
C662 current_source_1mA_0.ota_med_hv_gmid_0.ota_med_hv_gmid_mirror_0.vota VSS 7.93951f $ **FLOATING
C663 current_source_1mA_0.ota_med_hv_gmid_0.ota_med_hv_gmid_mirror_0.Iref VSS 4.15912f $ **FLOATING
C664 a_12547_2208# VSS 0.26407f
C665 a_12277_2208# VSS 0.22468f
C666 a_12007_2208# VSS 0.16382f
C667 a_11737_2208# VSS 0.16365f
C668 a_11467_2208# VSS 0.1573f
C669 a_11197_2208# VSS 0.15668f
C670 a_10927_2208# VSS 0.16344f
C671 a_10657_2208# VSS 0.22135f
C672 a_10387_2208# VSS 0.27034f
C673 current_source_1mA_0.current_source_1mA_2_stage_0.vcp VSS 3.19622f $ **FLOATING
C674 a_12547_2862# VSS 0.26393f
C675 a_12277_2862# VSS 0.22426f
C676 a_12007_2862# VSS 0.19269f
C677 a_11737_2862# VSS 0.17576f
C678 a_11467_2862# VSS 0.16294f
C679 a_11197_2862# VSS 0.17576f
C680 a_10927_2862# VSS 0.19274f
C681 a_10657_2862# VSS 0.22362f
C682 a_10387_2862# VSS 0.27034f
C683 current_source_1mA_0.ota_med_hv_gmid_0.ota_med_hv_gmid_tail_0.tail VSS 0.21231f $ **FLOATING
C684 current_source_1mA_0.current_source_1mA_2_stage_0.current_source_pass_element_0.vota VSS 10.31341f $ **FLOATING
C685 a_9273_164# VSS 0.29426f
C686 a_8619_164# VSS 0.29426f
C687 a_7965_164# VSS 0.29426f
C688 a_7311_164# VSS 0.29426f
C689 a_6657_164# VSS 0.29426f
C690 a_9273_434# VSS 0.24462f
C691 a_8619_434# VSS 0.24446f
C692 a_7965_434# VSS 0.24444f
C693 a_7311_434# VSS 0.24446f
C694 a_6657_434# VSS 0.24462f
C695 a_9273_719# VSS 0.16938f
C696 a_8619_719# VSS 0.17413f
C697 a_7965_719# VSS 0.16048f
C698 a_7311_719# VSS 0.16941f
C699 a_6657_719# VSS 0.1696f
C700 a_9273_989# VSS 0.16676f
C701 a_8619_989# VSS 0.1656f
C702 a_7965_989# VSS 0.15873f
C703 a_7311_989# VSS 0.16107f
C704 a_6657_989# VSS 0.16125f
C705 a_n6122_n36# VSS 0.02094f $ **FLOATING
C706 a_n2096_1164# VSS 0.01222f $ **FLOATING
C707 a_n2096_1197# VSS 0.01222f $ **FLOATING
C708 a_9273_1259# VSS 0.16595f
C709 a_8619_1259# VSS 0.16405f
C710 a_7965_1259# VSS 0.15873f
C711 a_7311_1259# VSS 0.15976f
C712 a_6657_1259# VSS 0.15994f
C713 a_9273_1529# VSS 0.16545f
C714 a_8619_1529# VSS 0.1635f
C715 a_7965_1529# VSS 0.15873f
C716 a_7311_1529# VSS 0.15873f
C717 a_6657_1529# VSS 0.15964f
C718 a_9273_1799# VSS 0.16513f
C719 a_8619_1799# VSS 0.16327f
C720 a_7965_1799# VSS 0.15873f
C721 a_7311_1799# VSS 0.15873f
C722 a_6657_1799# VSS 0.15964f
C723 a_n3796_1164# VSS 0.03755f $ **FLOATING
C724 a_9273_2069# VSS 0.16306f
C725 a_8619_2069# VSS 0.162f
C726 a_7965_2069# VSS 0.15873f
C727 a_7311_2069# VSS 0.15873f
C728 a_6657_2069# VSS 0.15964f
C729 a_9273_2339# VSS 0.16352f
C730 a_8619_2339# VSS 0.1623f
C731 a_7965_2339# VSS 0.15873f
C732 a_7311_2339# VSS 0.15976f
C733 a_6657_2339# VSS 0.15994f
C734 a_9273_2609# VSS 0.16483f
C735 a_8619_2609# VSS 0.16362f
C736 a_7965_2609# VSS 0.15873f
C737 a_7311_2609# VSS 0.16107f
C738 a_6657_2609# VSS 0.16125f
C739 a_9273_2879# VSS 0.17317f
C740 a_8619_2879# VSS 0.17198f
C741 a_7965_2879# VSS 0.16048f
C742 a_7311_2879# VSS 0.16944f
C743 a_6657_2879# VSS 0.1696f
C744 a_9273_3164# VSS 0.24476f
C745 a_8619_3164# VSS 0.24456f
C746 a_7965_3164# VSS 0.24444f
C747 a_7311_3164# VSS 0.24446f
C748 a_6657_3164# VSS 0.24462f
C749 a_9273_3434# VSS 0.29541f
C750 a_8619_3434# VSS 0.29332f
C751 a_7965_3434# VSS 0.29332f
C752 a_7311_3434# VSS 0.29245f
C753 a_6657_3434# VSS 0.29245f
C754 ota_lv_gmid_comparator_0.ota_slow_gmid_ctrl_buff_0.ota_slow_gmid_ctrl_inv_0.x VSS 1.16182f $ **FLOATING
C755 a_n5668_1164# VSS 0.01222f $ **FLOATING
C756 a_n5668_1197# VSS 0.01222f $ **FLOATING
C757 ota_lv_gmid_comparator_0.ota_slow_gmid_ctrl_buff_1.ota_slow_gmid_ctrl_inv_0.x VSS 1.14952f $ **FLOATING
C758 ota_lv_gmid_comparator_0.ota_slow_gmid_ctrl_buff_0.x VSS 4.3638f $ **FLOATING
C759 ota_lv_gmid_comparator_0.ota_slow_gmid_ctrl_buff_1.y VSS 4.96882f $ **FLOATING
C760 ref_selector_0.ref_selector_r_96_0.vcal VSS 21.85511f $ **FLOATING
C761 ref_selector_0.ref_selector_r_refs_0.R0 VSS 0.81949f $ **FLOATING
C762 ref_selector_0.ref_selector_r_refs_0.R1 VSS 1.04258f $ **FLOATING
C763 ref_selector_0.ref_selector_r_refs_0.R3 VSS 1.3057f $ **FLOATING
C764 ref_selector_0.ref_selector_r_refs_0.R2 VSS 1.61567f $ **FLOATING
C765 a_26010_5512# VSS 0.0201f $ **FLOATING
C766 a_20434_5512# VSS 0.0201f $ **FLOATING
C767 ref_selector_0.I1MA VSS 2.80258f $ **FLOATING
C768 current_source_1mA_0.current_source_1mA_2_stage_0.current_source_pass_element_0.iref VSS 5.06355f $ **FLOATING
C769 two_stage_instrumentation_amplifier_0.ota_slow_gmid_0.ota_slow_gmid_mirror_0.vref VSS 7.07306f $ **FLOATING
C770 a_n8794_1291# VSS 0.16227f
C771 a_n9064_1291# VSS 0.10167f
C772 a_n9334_1291# VSS 0.09751f
C773 a_n9604_1291# VSS 0.09751f
C774 a_n9874_1291# VSS 0.11402f
C775 a_n10144_1291# VSS 0.16268f
C776 a_n8794_1817# VSS 0.1623f
C777 a_n9064_1817# VSS 0.10157f
C778 a_n9334_1817# VSS 0.09737f
C779 a_n9604_1817# VSS 0.09737f
C780 a_n9874_1817# VSS 0.10154f
C781 a_n10144_1817# VSS 0.16228f
C782 a_n8794_2343# VSS 0.16227f
C783 a_n9064_2343# VSS 0.10167f
C784 a_n9334_2343# VSS 0.09751f
C785 a_n9604_2343# VSS 0.09751f
C786 a_n9874_2343# VSS 0.10166f
C787 a_n10144_2343# VSS 0.16218f
C788 a_n10344_2817# VSS 0.03228f $ **FLOATING
C789 two_stage_instrumentation_amplifier_0.VP VSS 34.04329f $ **FLOATING
C790 a_n8127_3486# VSS 0.03333f $ **FLOATING
C791 a_n8794_3111# VSS 0.27599f
C792 a_n9064_3111# VSS 0.16939f
C793 a_n9334_3111# VSS 0.16246f
C794 a_n9604_3111# VSS 0.16246f
C795 a_n9874_3111# VSS 0.16939f
C796 a_n10144_3111# VSS 0.27192f
C797 a_n12824_n36# VSS 0.02094f $ **FLOATING
C798 a_n14666_1164# VSS 0.01222f $ **FLOATING
C799 a_n14666_1197# VSS 0.01222f $ **FLOATING
C800 a_n16366_1164# VSS 0.03755f $ **FLOATING
C801 a_n18238_1164# VSS 0.01222f $ **FLOATING
C802 a_n18238_1197# VSS 0.01222f $ **FLOATING
C803 a_n8794_3765# VSS 0.27479f
C804 a_n9064_3765# VSS 0.16917f
C805 two_stage_instrumentation_amplifier_0.top_conditionning_gain_s2_0.vn2 VSS 3.81664f $ **FLOATING
C806 a_n9334_3765# VSS 0.16216f
C807 a_n9604_3765# VSS 0.16202f
C808 a_n9874_3765# VSS 0.1682f
C809 a_n10144_3765# VSS 0.2707f
C810 a_n12717_3486# VSS 0.03333f $ **FLOATING
C811 two_stage_instrumentation_amplifier_0.ota_slow_gmid_1.ota_slow_gmid_mirror_0.vref VSS 6.59101f $ **FLOATING
C812 two_stage_instrumentation_amplifier_0.ota_slow_gmid_1.VN VSS 4.99888f $ **FLOATING
C813 a_n1531_4249# VSS 0.19218f
C814 a_n5332_4249# VSS 0.19223f
C815 a_n7265_4254# VSS 0.43144f
C816 ota_lv_gmid_comparator_0.ota_slow_gmid_mirror_0.vref VSS 7.06002f $ **FLOATING
C817 ota_lv_gmid_comparator_0.ota_slow_gmid_mirror_0.vota VSS 16.10412f $ **FLOATING
C818 a_n1531_4529# VSS 0.23143f
C819 a_n5332_4529# VSS 0.23143f
C820 a_n7265_4534# VSS 0.36389f
C821 ref_selector_0.VMIN VSS 25.29646f $ **FLOATING
C822 a_4721_5436# VSS 0.19218f
C823 a_920_5436# VSS 0.19218f
C824 a_n1930_4907# VSS 0.28373f
C825 a_n2210_4907# VSS 0.28328f
C826 two_stage_instrumentation_amplifier_0.ota_slow_gmid_0.ota_slow_gmid_common_0/ota_slow_gmid_pairs_0.tail VSS 0.30272f $ **FLOATING
C827 two_stage_instrumentation_amplifier_0.ota_slow_gmid_0.vout1 VSS 10.55551f $ **FLOATING
C828 two_stage_instrumentation_amplifier_0.ota_slow_gmid_0.ota_slow_gmid_buffer_0.ibiasn VSS 18.79599f $ **FLOATING
C829 a_n4253_4907# VSS 0.28822f
C830 a_n4533_4907# VSS 0.28362f
C831 two_stage_instrumentation_amplifier_0.ota_slow_gmid_0.vota VSS 16.71245f $ **FLOATING
C832 a_n7664_4912# VSS 0.41329f
C833 a_n7944_4912# VSS 0.46805f
C834 a_n8794_4419# VSS 0.27277f
C835 a_n9064_4419# VSS 0.16939f
C836 a_n9334_4419# VSS 0.16246f
C837 a_n9604_4419# VSS 0.16246f
C838 a_n9874_4419# VSS 0.16939f
C839 a_n10144_4419# VSS 0.27254f
C840 a_n12169_4254# VSS 0.43144f
C841 a_n14102_4249# VSS 0.19223f
C842 a_n17903_4249# VSS 0.19218f
C843 a_n12169_4534# VSS 0.36389f
C844 a_n14102_4529# VSS 0.23143f
C845 a_n17903_4529# VSS 0.23143f
C846 a_n11090_4912# VSS 0.46786f
C847 a_n11370_4912# VSS 0.41329f
C848 a_n14501_4907# VSS 0.28362f
C849 a_n14781_4907# VSS 0.2829f
C850 two_stage_instrumentation_amplifier_0.ota_slow_gmid_1.ota_slow_gmid_common_0/ota_slow_gmid_pairs_0.tail VSS 0.30272f $ **FLOATING
C851 two_stage_instrumentation_amplifier_0.ota_slow_gmid_1.ota_slow_gmid_buffer_0.ibiasn VSS 18.78867f $ **FLOATING
C852 two_stage_instrumentation_amplifier_0.ota_slow_gmid_1.vout1 VSS 10.24846f $ **FLOATING
C853 a_n16824_4907# VSS 0.2886f
C854 a_n17104_4907# VSS 0.28373f
C855 a_4721_5716# VSS 0.23143f
C856 a_920_5716# VSS 0.23143f
C857 a_19842_6672# VSS 0.15943f
C858 a_19572_6672# VSS 0.10117f
C859 a_19302_6672# VSS 0.09686f
C860 a_19032_6672# VSS 0.09602f
C861 a_18762_6672# VSS 0.09585f
C862 a_18492_6672# VSS 0.09582f
C863 a_18222_6672# VSS 0.09585f
C864 a_17952_6672# VSS 0.09602f
C865 a_17682_6672# VSS 0.09686f
C866 a_17412_6672# VSS 0.10133f
C867 a_17142_6672# VSS 0.16297f
C868 a_4666_5942# VSS 0.4272f $ **FLOATING
C869 a_4322_6094# VSS 0.28373f
C870 a_4042_6094# VSS 0.2829f
C871 ota_lv_gmid_comparator_0.ota_slow_gmid_common_0/ota_slow_gmid_pairs_0.tail VSS 0.3026f $ **FLOATING
C872 ota_lv_gmid_comparator_0.ota_slow_gmid_common_0/ota_slow_gmid_tail_0.ibiasn VSS 0.03707f $ **FLOATING
C873 ota_lv_gmid_comparator_0.ota_slow_gmid_mirror_0.vout1 VSS 8.80512f $ **FLOATING
C874 a_1999_6094# VSS 0.2886f
C875 a_1719_6094# VSS 0.28373f
C876 a_875_5942# VSS 0.42734f $ **FLOATING
C877 a_19842_7198# VSS 0.15752f
C878 a_19572_7198# VSS 0.09524f
C879 a_19302_7198# VSS 0.09524f
C880 a_19032_7198# VSS 0.09524f
C881 a_18762_7198# VSS 0.09536f
C882 a_18492_7198# VSS 0.09546f
C883 a_18222_7198# VSS 0.09559f
C884 a_17952_7198# VSS 0.09588f
C885 a_17682_7198# VSS 0.09673f
C886 a_17412_7198# VSS 0.10131f
C887 a_17142_7198# VSS 0.16295f
C888 non_inverting_amplifier_hv_0.ota_hv_slow_gmid_0.ota_hv_slow_gmid_tail_0.tail VSS 0.18919f $ **FLOATING
C889 a_19842_7724# VSS 0.15918f
C890 rmod VSS 0.36232f $ **FLOATING
C891 a_19574_7702# VSS 0.13359f
C892 a_19302_7724# VSS 0.09538f
C893 a_19032_7724# VSS 0.09524f
C894 a_18762_7724# VSS 0.09536f
C895 a_18492_7724# VSS 0.09582f
C896 a_18222_7724# VSS 0.0961f
C897 a_17952_7724# VSS 0.09666f
C898 a_17682_7724# VSS 0.09804f
C899 a_17412_7702# VSS 0.15245f
C900 non_inverting_amplifier_hv_0.top_conditionning_gain_s3_0.vn3 VSS 3.31632f $ **FLOATING
C901 a_17142_7724# VSS 0.16644f
C902 a_19842_8250# VSS 0.1574f
C903 a_19572_8250# VSS 0.09524f
C904 a_19302_8250# VSS 0.09524f
C905 a_19032_8250# VSS 0.09524f
C906 a_18762_8250# VSS 0.09536f
C907 a_18492_8250# VSS 0.09546f
C908 a_18222_8250# VSS 0.09559f
C909 a_17952_8250# VSS 0.09588f
C910 a_17682_8250# VSS 0.09673f
C911 a_17412_8250# VSS 0.10117f
C912 a_17142_8250# VSS 0.15771f
C913 a_19842_8776# VSS 0.15752f
C914 a_19572_8776# VSS 0.10131f
C915 a_19302_8776# VSS 0.09686f
C916 a_19032_8776# VSS 0.09602f
C917 a_18762_8776# VSS 0.09585f
C918 a_18492_8776# VSS 0.09582f
C919 a_18222_8776# VSS 0.09585f
C920 a_17952_8776# VSS 0.09602f
C921 a_17682_8776# VSS 0.09686f
C922 a_17412_8776# VSS 0.10117f
C923 a_17142_8776# VSS 0.15534f
C924 top_conditionning_level_shifter_0.top_conditionning_inverter_0.X VSS 1.69028f $ **FLOATING
C925 S1.n0 VSS 21.506f $ **FLOATING
C926 S1.t0 VSS 0.64807f $ **FLOATING
C927 a_n4253_5507.t1 VSS 1.20131f $ **FLOATING
C928 a_n4253_5507.t0 VSS 1.19869f $ **FLOATING
C929 dw_n18308_4910.n0 VSS 0.03479f $ **FLOATING
C930 dw_n18308_4910.n1 VSS 0.0159f $ **FLOATING
C931 dw_n18308_4910.n2 VSS 0.0159f $ **FLOATING
C932 dw_n18308_4910.n3 VSS 0.02339f $ **FLOATING
C933 dw_n18308_4910.n4 VSS 0.0159f $ **FLOATING
C934 dw_n18308_4910.n5 VSS 0.02973f $ **FLOATING
C935 dw_n18308_4910.n7 VSS 0.01801f $ **FLOATING
C936 dw_n18308_4910.n8 VSS 0.01801f $ **FLOATING
C937 dw_n18308_4910.n9 VSS 0.01592f $ **FLOATING
C938 dw_n18308_4910.n10 VSS 0.01037f $ **FLOATING
C939 dw_n18308_4910.n11 VSS 0.01424f $ **FLOATING
C940 dw_n18308_4910.t5 VSS 0.08699f $ **FLOATING
C941 dw_n18308_4910.n12 VSS 0.06174f $ **FLOATING
C942 dw_n18308_4910.n13 VSS 0.12151f $ **FLOATING
C943 dw_n18308_4910.t2 VSS 0.106f $ **FLOATING
C944 dw_n18308_4910.n14 VSS 0.21713f $ **FLOATING
C945 dw_n18308_4910.t3 VSS 0.08908f $ **FLOATING
C946 dw_n18308_4910.t8 VSS 0.09126f $ **FLOATING
C947 dw_n18308_4910.n15 VSS 0.21161f $ **FLOATING
C948 dw_n18308_4910.t7 VSS 0.09375f $ **FLOATING
C949 dw_n18308_4910.n16 VSS 0.07441f $ **FLOATING
C950 dw_n18308_4910.n17 VSS 0.14637f $ **FLOATING
C951 dw_n18308_4910.t1 VSS 4.46528f $ **FLOATING
C952 dw_n18308_4910.n18 VSS 0.14637f $ **FLOATING
C953 dw_n18308_4910.n19 VSS 0.06583f $ **FLOATING
C954 dw_n18308_4910.n20 VSS 0.05879f $ **FLOATING
C955 dw_n18308_4910.n21 VSS 0.27865f $ **FLOATING
C956 dw_n18308_4910.n22 VSS 0.18185f $ **FLOATING
C957 dw_n18308_4910.n23 VSS 0.03129f $ **FLOATING
C958 dw_n18308_4910.n24 VSS 0.0908f $ **FLOATING
C959 dw_n18308_4910.t4 VSS 1.81506f $ **FLOATING
C960 dw_n18308_4910.n27 VSS 0.01801f $ **FLOATING
C961 dw_n18308_4910.n28 VSS 0.01424f $ **FLOATING
C962 dw_n18308_4910.n29 VSS 0.01824f $ **FLOATING
C963 dw_n18308_4910.n30 VSS 0.0269f $ **FLOATING
C964 dw_n18308_4910.t6 VSS 0.07122f $ **FLOATING
C965 dw_n18308_4910.n31 VSS 0.15124f $ **FLOATING
C966 dw_n18308_4910.t0 VSS 0.05419f $ **FLOATING
C967 S2.n0 VSS 20.6283f $ **FLOATING
C968 S2.t0 VSS 0.66674f $ **FLOATING
C969 two_stage_instrumentation_amplifier_0.top_conditionning_gain_s2_0.vn2.t2 VSS 1.49137f $ **FLOATING
C970 two_stage_instrumentation_amplifier_0.top_conditionning_gain_s2_0.vn2.t3 VSS 1.45881f $ **FLOATING
C971 two_stage_instrumentation_amplifier_0.top_conditionning_gain_s2_0.vn2.n0 VSS 0.34238f $ **FLOATING
C972 two_stage_instrumentation_amplifier_0.top_conditionning_gain_s2_0.vn2.t1 VSS 0.02427f $ **FLOATING
C973 two_stage_instrumentation_amplifier_0.top_conditionning_gain_s2_0.vn2.t0 VSS 0.02442f $ **FLOATING
C974 two_stage_instrumentation_amplifier_0.top_conditionning_gain_s2_0.vn2.n1 VSS 0.07122f $ **FLOATING
C975 ota_lv_gmid_comparator_0.ota_slow_gmid_mirror_0.vref.t0 VSS 0.28711f $ **FLOATING
C976 ota_lv_gmid_comparator_0.ota_slow_gmid_mirror_0.vref.t4 VSS 0.04275f $ **FLOATING
C977 ota_lv_gmid_comparator_0.ota_slow_gmid_mirror_0.vref.t2 VSS 6.91168f $ **FLOATING
C978 ota_lv_gmid_comparator_0.ota_slow_gmid_mirror_0.vref.t3 VSS 0.08315f $ **FLOATING
C979 ota_lv_gmid_comparator_0.ota_slow_gmid_mirror_0.vref.n0 VSS 1.75279f $ **FLOATING
C980 ota_lv_gmid_comparator_0.ota_slow_gmid_mirror_0.vref.n1 VSS 0.31896f $ **FLOATING
C981 ota_lv_gmid_comparator_0.ota_slow_gmid_mirror_0.vref.t1 VSS 0.51369f $ **FLOATING
C982 ota_lv_gmid_comparator_0.ota_slow_gmid_mirror_0.vref.n2 VSS 1.04645f $ **FLOATING
C983 ota_lv_gmid_comparator_0.ota_slow_gmid_mirror_0.vref.n3 VSS 0.44097f $ **FLOATING
C984 VBG.t1 VSS 2.31288f $ **FLOATING
C985 VBG.t0 VSS 2.29222f $ **FLOATING
C986 VBG.n0 VSS 0.80771f $ **FLOATING
C987 ota_lv_gmid_comparator_0.ota_slow_gmid_mirror_0.vota.t1 VSS 0.29967f $ **FLOATING
C988 ota_lv_gmid_comparator_0.ota_slow_gmid_mirror_0.vota.t0 VSS 0.41627f $ **FLOATING
C989 ota_lv_gmid_comparator_0.ota_slow_gmid_mirror_0.vota.n0 VSS 0.51021f $ **FLOATING
C990 ota_lv_gmid_comparator_0.ota_slow_gmid_mirror_0.vota.t5 VSS 3.88659f $ **FLOATING
C991 ota_lv_gmid_comparator_0.ota_slow_gmid_mirror_0.vota.t3 VSS 0.03793f $ **FLOATING
C992 ota_lv_gmid_comparator_0.ota_slow_gmid_mirror_0.vota.n1 VSS 0.195f $ **FLOATING
C993 ota_lv_gmid_comparator_0.ota_slow_gmid_mirror_0.vota.t4 VSS 3.88501f $ **FLOATING
C994 ota_lv_gmid_comparator_0.ota_slow_gmid_mirror_0.vota.t2 VSS 0.33873f $ **FLOATING
C995 ota_lv_gmid_comparator_0.ota_slow_gmid_mirror_0.vota.n2 VSS 1.04386f $ **FLOATING
C996 ota_lv_gmid_comparator_0.ota_slow_gmid_mirror_0.vota.n3 VSS 0.06081f $ **FLOATING
C997 EN.t2 VSS 3.56825f $ **FLOATING
C998 EN.t0 VSS 0.73392f $ **FLOATING
C999 EN.n0 VSS 0.27096f $ **FLOATING
C1000 EN.t3 VSS 0.73411f $ **FLOATING
C1001 EN.n1 VSS 0.75864f $ **FLOATING
C1002 EN.n2 VSS 15.6465f $ **FLOATING
C1003 EN.t1 VSS 0.73347f $ **FLOATING
C1004 EN.n3 VSS 0.58036f $ **FLOATING
C1005 EN.n4 VSS 15.7572f $ **FLOATING
C1006 EN.n5 VSS 4.0498f $ **FLOATING
C1007 EN.n6 VSS 22.6652f $ **FLOATING
C1008 a_n16824_5507.t1 VSS 1.20131f $ **FLOATING
C1009 a_n16824_5507.t0 VSS 1.19869f $ **FLOATING
C1010 non_inverting_amplifier_hv_0.top_conditionning_gain_s3_0.vn3.t3 VSS 1.79178f $ **FLOATING
C1011 non_inverting_amplifier_hv_0.top_conditionning_gain_s3_0.vn3.n0 VSS 0.56606f $ **FLOATING
C1012 non_inverting_amplifier_hv_0.top_conditionning_gain_s3_0.vn3.t2 VSS 1.85062f $ **FLOATING
C1013 non_inverting_amplifier_hv_0.top_conditionning_gain_s3_0.vn3.n1 VSS 1.10257f $ **FLOATING
C1014 non_inverting_amplifier_hv_0.top_conditionning_gain_s3_0.vn3.t1 VSS 0.10752f $ **FLOATING
C1015 non_inverting_amplifier_hv_0.top_conditionning_gain_s3_0.vn3.t0 VSS 0.06763f $ **FLOATING
C1016 non_inverting_amplifier_hv_0.top_conditionning_gain_s3_0.vn3.n2 VSS 0.60004f $ **FLOATING
C1017 two_stage_instrumentation_amplifier_0.ota_slow_gmid_0.ota_slow_gmid_mirror_0.vref.t5 VSS 0.02895f $ **FLOATING
C1018 two_stage_instrumentation_amplifier_0.ota_slow_gmid_0.ota_slow_gmid_mirror_0.vref.t4 VSS 2.58372f $ **FLOATING
C1019 two_stage_instrumentation_amplifier_0.ota_slow_gmid_0.ota_slow_gmid_mirror_0.vref.t3 VSS 0.03555f $ **FLOATING
C1020 two_stage_instrumentation_amplifier_0.ota_slow_gmid_0.ota_slow_gmid_mirror_0.vref.n0 VSS 0.1857f $ **FLOATING
C1021 two_stage_instrumentation_amplifier_0.ota_slow_gmid_0.ota_slow_gmid_mirror_0.vref.t2 VSS 2.0671f $ **FLOATING
C1022 two_stage_instrumentation_amplifier_0.ota_slow_gmid_0.ota_slow_gmid_mirror_0.vref.n1 VSS 0.03034f $ **FLOATING
C1023 two_stage_instrumentation_amplifier_0.ota_slow_gmid_0.ota_slow_gmid_mirror_0.vref.n2 VSS 0.55091f $ **FLOATING
C1024 two_stage_instrumentation_amplifier_0.ota_slow_gmid_0.ota_slow_gmid_mirror_0.vref.n3 VSS 0.59778f $ **FLOATING
C1025 two_stage_instrumentation_amplifier_0.ota_slow_gmid_0.ota_slow_gmid_mirror_0.vref.n4 VSS 0.08942f $ **FLOATING
C1026 two_stage_instrumentation_amplifier_0.ota_slow_gmid_0.ota_slow_gmid_mirror_0.vref.t1 VSS 0.34793f $ **FLOATING
C1027 two_stage_instrumentation_amplifier_0.ota_slow_gmid_0.ota_slow_gmid_mirror_0.vref.n5 VSS 0.61042f $ **FLOATING
C1028 two_stage_instrumentation_amplifier_0.ota_slow_gmid_0.ota_slow_gmid_mirror_0.vref.t0 VSS 0.19445f $ **FLOATING
C1029 two_stage_instrumentation_amplifier_0.ota_slow_gmid_0.ota_slow_gmid_mirror_0.vref.n6 VSS 0.11195f $ **FLOATING
C1030 S0.n0 VSS 16.6851f $ **FLOATING
C1031 S0.t0 VSS 0.48259f $ **FLOATING
C1032 top_conditionning_level_shifter_0.EN_HV.t1 VSS 0.16332f $ **FLOATING
C1033 top_conditionning_level_shifter_0.top_conditionning_inverter_0.Y VSS 0.07241f $ **FLOATING
C1034 top_conditionning_level_shifter_0.EN_HV.t2 VSS 8.16875f $ **FLOATING
C1035 current_source_1mA_0.ota_med_hv_gmid_0.ota_med_hv_gmid_enable_0.en_in VSS 0.67862f $ **FLOATING
C1036 current_source_1mA_0.EN_IN VSS 0.10063f $ **FLOATING
C1037 top_conditionning_level_shifter_0.EN_HV.n0 VSS 0.34206f $ **FLOATING
C1038 top_conditionning_level_shifter_0.EN_HV.t3 VSS 0.96061f $ **FLOATING
C1039 non_inverting_amplifier_hv_0.ota_hv_slow_gmid_0.ota_hv_slow_gmid_ctrl_inv_1.A VSS 0.34544f $ **FLOATING
C1040 non_inverting_amplifier_hv_0.ota_hv_slow_gmid_0.EN_IN VSS 0.44004f $ **FLOATING
C1041 top_conditionning_level_shifter_0.EN_HV.n1 VSS 2.08546f $ **FLOATING
C1042 top_conditionning_level_shifter_0.EN_HV.t0 VSS 0.30558f $ **FLOATING
C1043 top_conditionning_level_shifter_0.EN_HV.n2 VSS 2.0362f $ **FLOATING
C1044 current_source_1mA_0.ota_med_hv_gmid_0.ota_med_hv_gmid_mirror_0.vota.t4 VSS 0.05949f $ **FLOATING
C1045 current_source_1mA_0.ota_med_hv_gmid_0.ota_med_hv_gmid_mirror_0.vota.t2 VSS 0.1355f $ **FLOATING
C1046 current_source_1mA_0.ota_med_hv_gmid_0.ota_med_hv_gmid_mirror_0.vota.n0 VSS 0.1195f $ **FLOATING
C1047 current_source_1mA_0.ota_med_hv_gmid_0.ota_med_hv_gmid_mirror_0.vota.t3 VSS 32.8434f $ **FLOATING
C1048 current_source_1mA_0.ota_med_hv_gmid_0.ota_med_hv_gmid_mirror_0.vota.n1 VSS 0.05822f $ **FLOATING
C1049 current_source_1mA_0.ota_med_hv_gmid_0.ota_med_hv_gmid_mirror_0.vota.t0 VSS 0.04748f $ **FLOATING
C1050 current_source_1mA_0.ota_med_hv_gmid_0.ota_med_hv_gmid_mirror_0.vota.t5 VSS 0.4777f $ **FLOATING
C1051 current_source_1mA_0.ota_med_hv_gmid_0.ota_med_hv_gmid_mirror_0.vota.n2 VSS 0.08569f $ **FLOATING
C1052 current_source_1mA_0.ota_med_hv_gmid_0.ota_med_hv_gmid_mirror_0.vota.t6 VSS 0.47775f $ **FLOATING
C1053 current_source_1mA_0.ota_med_hv_gmid_0.ota_med_hv_gmid_mirror_0.vota.n3 VSS 0.06557f $ **FLOATING
C1054 current_source_1mA_0.ota_med_hv_gmid_0.ota_med_hv_gmid_mirror_0.vota.t1 VSS 0.04647f $ **FLOATING
C1055 current_source_1mA_0.ota_med_hv_gmid_0.ota_med_hv_gmid_mirror_0.vota.n4 VSS 0.02838f $ **FLOATING
C1056 ref_selector_0.VMIN.t2 VSS 0.01736f $ **FLOATING
C1057 ref_selector_0.VMIN.t19 VSS 0.01736f $ **FLOATING
C1058 ref_selector_0.VMIN.t18 VSS 0.02382f $ **FLOATING
C1059 ref_selector_0.VMIN.t1 VSS 0.02234f $ **FLOATING
C1060 ref_selector_0.VMIN.n0 VSS 0.14662f $ **FLOATING
C1061 ref_selector_0.VMIN.t15 VSS 0.0172f $ **FLOATING
C1062 ref_selector_0.VMIN.t6 VSS 0.01798f $ **FLOATING
C1063 ref_selector_0.VMIN.t9 VSS 0.01719f $ **FLOATING
C1064 ref_selector_0.VMIN.n1 VSS 0.0466f $ **FLOATING
C1065 ref_selector_0.VMIN.t7 VSS 0.01798f $ **FLOATING
C1066 ref_selector_0.VMIN.n2 VSS 0.04683f $ **FLOATING
C1067 ref_selector_0.VMIN.t3 VSS 0.02276f $ **FLOATING
C1068 ref_selector_0.VMIN.n3 VSS 0.16715f $ **FLOATING
C1069 ref_selector_0.VMIN.n4 VSS 0.04722f $ **FLOATING
C1070 ref_selector_0.VMIN.t12 VSS 0.01798f $ **FLOATING
C1071 ref_selector_0.VMIN.t5 VSS 0.01719f $ **FLOATING
C1072 ref_selector_0.VMIN.n5 VSS 0.06582f $ **FLOATING
C1073 ref_selector_0.VMIN.t11 VSS 0.01719f $ **FLOATING
C1074 ref_selector_0.VMIN.n6 VSS 0.03864f $ **FLOATING
C1075 ref_selector_0.VMIN.t14 VSS 0.01719f $ **FLOATING
C1076 ref_selector_0.VMIN.n7 VSS 0.03864f $ **FLOATING
C1077 ref_selector_0.VMIN.t0 VSS 0.01719f $ **FLOATING
C1078 ref_selector_0.VMIN.n8 VSS 0.02364f $ **FLOATING
C1079 ref_selector_0.VMIN.n9 VSS 0.05624f $ **FLOATING
C1080 ref_selector_0.VMIN.n10 VSS 0.06435f $ **FLOATING
C1081 ref_selector_0.VMIN.n11 VSS 0.0495f $ **FLOATING
C1082 ref_selector_0.VMIN.n12 VSS 0.06576f $ **FLOATING
C1083 ref_selector_0.VMIN.t8 VSS 0.01722f $ **FLOATING
C1084 ref_selector_0.VMIN.n13 VSS 0.05188f $ **FLOATING
C1085 ref_selector_0.VMIN.t17 VSS 0.01876f $ **FLOATING
C1086 ref_selector_0.VMIN.t4 VSS 0.02766f $ **FLOATING
C1087 ref_selector_0.VMIN.t13 VSS 0.01858f $ **FLOATING
C1088 ref_selector_0.VMIN.t20 VSS 1.04269f $ **FLOATING
C1089 ref_selector_0.VMIN.n14 VSS 0.20207f $ **FLOATING
C1090 ref_selector_0.VMIN.t21 VSS 1.05582f $ **FLOATING
C1091 ref_selector_0.VMIN.n15 VSS 0.15387f $ **FLOATING
C1092 ref_selector_0.VMIN.n16 VSS 0.82833f $ **FLOATING
C1093 ref_selector_0.VMIN.t16 VSS 0.01847f $ **FLOATING
C1094 ref_selector_0.VMIN.n17 VSS 0.96413f $ **FLOATING
C1095 ref_selector_0.VMIN.n18 VSS 0.13609f $ **FLOATING
C1096 ref_selector_0.VMIN.t10 VSS 18.9609f $ **FLOATING
C1097 ref_selector_0.VMIN.n19 VSS 0.15102f $ **FLOATING
C1098 ref_selector_0.VMIN.n20 VSS 0.1746f $ **FLOATING
C1099 ref_selector_0.VMIN.n21 VSS 0.0995f $ **FLOATING
C1100 ref_selector_0.VMIN.n22 VSS 0.12235f $ **FLOATING
C1101 current_source_1mA_0.current_source_1mA_2_stage_0.current_source_pass_element_0.vota.t1 VSS 0.01079f $ **FLOATING
C1102 current_source_1mA_0.current_source_1mA_2_stage_0.current_source_pass_element_0.vota.t0 VSS 0.02111f $ **FLOATING
C1103 current_source_1mA_0.current_source_1mA_2_stage_0.current_source_pass_element_0.vota.n0 VSS 0.05131f $ **FLOATING
C1104 current_source_1mA_0.current_source_1mA_2_stage_0.current_source_pass_element_0.vota.t7 VSS 31.1205f $ **FLOATING
C1105 current_source_1mA_0.current_source_1mA_2_stage_0.current_source_pass_element_0.vota.t3 VSS 0.02001f $ **FLOATING
C1106 current_source_1mA_0.current_source_1mA_2_stage_0.current_source_pass_element_0.vota.t5 VSS 0.01998f $ **FLOATING
C1107 current_source_1mA_0.current_source_1mA_2_stage_0.current_source_pass_element_0.vota.t4 VSS 0.02373f $ **FLOATING
C1108 current_source_1mA_0.current_source_1mA_2_stage_0.current_source_pass_element_0.vota.n1 VSS 0.05978f $ **FLOATING
C1109 current_source_1mA_0.current_source_1mA_2_stage_0.current_source_pass_element_0.vota.t2 VSS 0.01998f $ **FLOATING
C1110 current_source_1mA_0.current_source_1mA_2_stage_0.current_source_pass_element_0.vota.n2 VSS 0.05215f $ **FLOATING
C1111 current_source_1mA_0.current_source_1mA_2_stage_0.current_source_pass_element_0.vota.n3 VSS 0.01373f $ **FLOATING
C1112 current_source_1mA_0.current_source_1mA_2_stage_0.current_source_pass_element_0.vota.t6 VSS 0.26396f $ **FLOATING
C1113 current_source_1mA_0.current_source_1mA_2_stage_0.current_source_pass_element_0.vota.n4 VSS 0.20333f $ **FLOATING
C1114 current_source_1mA_0.current_source_1mA_2_stage_0.current_source_pass_element_0.vota.n5 VSS 0.16963f $ **FLOATING
C1115 current_source_1mA_0.current_source_1mA_2_stage_0.current_source_pass_element_0.vota.n6 VSS 0.16189f $ **FLOATING
C1116 two_stage_instrumentation_amplifier_0.ota_slow_gmid_0.vout1.t17 VSS 0.08898f $ **FLOATING
C1117 two_stage_instrumentation_amplifier_0.ota_slow_gmid_0.vout1.t18 VSS 0.06958f $ **FLOATING
C1118 two_stage_instrumentation_amplifier_0.ota_slow_gmid_0.vout1.n0 VSS 0.13698f $ **FLOATING
C1119 two_stage_instrumentation_amplifier_0.ota_slow_gmid_0.vout1.t14 VSS 0.09588f $ **FLOATING
C1120 two_stage_instrumentation_amplifier_0.ota_slow_gmid_0.vout1.t13 VSS 0.09588f $ **FLOATING
C1121 two_stage_instrumentation_amplifier_0.ota_slow_gmid_0.vout1.t15 VSS 0.09588f $ **FLOATING
C1122 two_stage_instrumentation_amplifier_0.ota_slow_gmid_0.vout1.t11 VSS 0.09588f $ **FLOATING
C1123 two_stage_instrumentation_amplifier_0.ota_slow_gmid_0.vout1.t16 VSS 0.09248f $ **FLOATING
C1124 two_stage_instrumentation_amplifier_0.ota_slow_gmid_0.vout1.n1 VSS 0.13143f $ **FLOATING
C1125 two_stage_instrumentation_amplifier_0.ota_slow_gmid_0.vout1.n2 VSS 0.07596f $ **FLOATING
C1126 two_stage_instrumentation_amplifier_0.ota_slow_gmid_0.vout1.n3 VSS 0.07596f $ **FLOATING
C1127 two_stage_instrumentation_amplifier_0.ota_slow_gmid_0.vout1.n4 VSS 0.07451f $ **FLOATING
C1128 two_stage_instrumentation_amplifier_0.ota_slow_gmid_0.vout1.t12 VSS 0.08625f $ **FLOATING
C1129 two_stage_instrumentation_amplifier_0.ota_slow_gmid_0.vout1.n5 VSS 0.07129f $ **FLOATING
C1130 two_stage_instrumentation_amplifier_0.ota_slow_gmid_0.vout1.t2 VSS 0.03478f $ **FLOATING
C1131 two_stage_instrumentation_amplifier_0.ota_slow_gmid_0.vout1.t1 VSS 0.03512f $ **FLOATING
C1132 two_stage_instrumentation_amplifier_0.ota_slow_gmid_0.vout1.t4 VSS 0.19884f $ **FLOATING
C1133 two_stage_instrumentation_amplifier_0.ota_slow_gmid_0.vout1.t3 VSS 0.03512f $ **FLOATING
C1134 two_stage_instrumentation_amplifier_0.ota_slow_gmid_0.vout1.n6 VSS 0.68438f $ **FLOATING
C1135 two_stage_instrumentation_amplifier_0.ota_slow_gmid_0.vout1.n7 VSS 0.49102f $ **FLOATING
C1136 two_stage_instrumentation_amplifier_0.ota_slow_gmid_0.vout1.n8 VSS 0.35304f $ **FLOATING
C1137 two_stage_instrumentation_amplifier_0.ota_slow_gmid_0.vout1.n9 VSS 0.42926f $ **FLOATING
C1138 two_stage_instrumentation_amplifier_0.ota_slow_gmid_0.vout1.t10 VSS 0.08625f $ **FLOATING
C1139 two_stage_instrumentation_amplifier_0.ota_slow_gmid_0.vout1.t9 VSS 0.09588f $ **FLOATING
C1140 two_stage_instrumentation_amplifier_0.ota_slow_gmid_0.vout1.t7 VSS 0.09588f $ **FLOATING
C1141 two_stage_instrumentation_amplifier_0.ota_slow_gmid_0.vout1.t5 VSS 0.09588f $ **FLOATING
C1142 two_stage_instrumentation_amplifier_0.ota_slow_gmid_0.vout1.t8 VSS 0.09588f $ **FLOATING
C1143 two_stage_instrumentation_amplifier_0.ota_slow_gmid_0.vout1.t6 VSS 0.09248f $ **FLOATING
C1144 two_stage_instrumentation_amplifier_0.ota_slow_gmid_0.vout1.n10 VSS 0.13143f $ **FLOATING
C1145 two_stage_instrumentation_amplifier_0.ota_slow_gmid_0.vout1.n11 VSS 0.07596f $ **FLOATING
C1146 two_stage_instrumentation_amplifier_0.ota_slow_gmid_0.vout1.n12 VSS 0.07596f $ **FLOATING
C1147 two_stage_instrumentation_amplifier_0.ota_slow_gmid_0.vout1.n13 VSS 0.07451f $ **FLOATING
C1148 two_stage_instrumentation_amplifier_0.ota_slow_gmid_0.vout1.n14 VSS 0.06014f $ **FLOATING
C1149 two_stage_instrumentation_amplifier_0.ota_slow_gmid_0.vout1.n15 VSS 0.57179f $ **FLOATING
C1150 two_stage_instrumentation_amplifier_0.ota_slow_gmid_0.vout1.t19 VSS 0.10614f $ **FLOATING
C1151 two_stage_instrumentation_amplifier_0.ota_slow_gmid_0.vout1.n16 VSS 0.65508f $ **FLOATING
C1152 two_stage_instrumentation_amplifier_0.ota_slow_gmid_0.vout1.t0 VSS 0.2004f $ **FLOATING
C1153 two_stage_instrumentation_amplifier_0.ota_slow_gmid_0.vout1.n17 VSS 0.32017f $ **FLOATING
C1154 two_stage_instrumentation_amplifier_0.ota_slow_gmid_0.vota.t5 VSS 2.57539f $ **FLOATING
C1155 two_stage_instrumentation_amplifier_0.ota_slow_gmid_0.vota.t8 VSS 2.48085f $ **FLOATING
C1156 two_stage_instrumentation_amplifier_0.ota_slow_gmid_0.vota.n0 VSS 0.92546f $ **FLOATING
C1157 two_stage_instrumentation_amplifier_0.ota_slow_gmid_0.vota.t7 VSS 2.48267f $ **FLOATING
C1158 two_stage_instrumentation_amplifier_0.ota_slow_gmid_0.vota.n1 VSS 0.91617f $ **FLOATING
C1159 two_stage_instrumentation_amplifier_0.ota_slow_gmid_0.vota.t6 VSS 4.3021f $ **FLOATING
C1160 two_stage_instrumentation_amplifier_0.ota_slow_gmid_0.vota.t2 VSS 0.04196f $ **FLOATING
C1161 two_stage_instrumentation_amplifier_0.ota_slow_gmid_0.vota.n2 VSS 0.21307f $ **FLOATING
C1162 two_stage_instrumentation_amplifier_0.ota_slow_gmid_0.vota.t4 VSS 4.29776f $ **FLOATING
C1163 two_stage_instrumentation_amplifier_0.ota_slow_gmid_0.vota.t3 VSS 0.37471f $ **FLOATING
C1164 two_stage_instrumentation_amplifier_0.ota_slow_gmid_0.vota.n3 VSS 1.15468f $ **FLOATING
C1165 two_stage_instrumentation_amplifier_0.ota_slow_gmid_0.vota.n4 VSS 0.06727f $ **FLOATING
C1166 two_stage_instrumentation_amplifier_0.ota_slow_gmid_0.vota.n5 VSS 0.14159f $ **FLOATING
C1167 two_stage_instrumentation_amplifier_0.ota_slow_gmid_0.vota.n6 VSS 0.77948f $ **FLOATING
C1168 two_stage_instrumentation_amplifier_0.ota_slow_gmid_0.vota.t0 VSS 0.33156f $ **FLOATING
C1169 two_stage_instrumentation_amplifier_0.ota_slow_gmid_0.vota.t1 VSS 0.46049f $ **FLOATING
C1170 two_stage_instrumentation_amplifier_0.ota_slow_gmid_0.vota.n7 VSS 0.5633f $ **FLOATING
C1171 two_stage_instrumentation_amplifier_0.ota_slow_gmid_0.vota.n8 VSS 0.45494f $ **FLOATING
C1172 two_stage_instrumentation_amplifier_0.ota_slow_gmid_1.en.t3 VSS 0.843f $ **FLOATING
C1173 two_stage_instrumentation_amplifier_0.ota_slow_gmid_1.en.t2 VSS 0.89302f $ **FLOATING
C1174 two_stage_instrumentation_amplifier_0.ota_slow_gmid_1.en.n0 VSS 0.84014f $ **FLOATING
C1175 two_stage_instrumentation_amplifier_0.ota_slow_gmid_1.en.t1 VSS 0.23338f $ **FLOATING
C1176 two_stage_instrumentation_amplifier_0.ota_slow_gmid_1.en.t0 VSS 0.23122f $ **FLOATING
C1177 two_stage_instrumentation_amplifier_0.ota_slow_gmid_1.en.n1 VSS 0.22738f $ **FLOATING
C1178 two_stage_instrumentation_amplifier_0.ota_slow_gmid_1.ota_slow_gmid_ctrl_buff_0.ota_slow_gmid_ctrl_inv_0.y VSS 0.03657f $ **FLOATING
C1179 two_stage_instrumentation_amplifier_0.ota_slow_gmid_1.ota_slow_gmid_ctrl_buff_0.y VSS 0.1953f $ **FLOATING
C1180 two_stage_instrumentation_amplifier_0.ota_slow_gmid_1.vota.t6 VSS 2.58663f $ **FLOATING
C1181 two_stage_instrumentation_amplifier_0.ota_slow_gmid_1.vota.t8 VSS 2.49169f $ **FLOATING
C1182 two_stage_instrumentation_amplifier_0.ota_slow_gmid_1.vota.n0 VSS 0.92951f $ **FLOATING
C1183 two_stage_instrumentation_amplifier_0.ota_slow_gmid_1.vota.t7 VSS 2.49351f $ **FLOATING
C1184 two_stage_instrumentation_amplifier_0.ota_slow_gmid_1.vota.n1 VSS 0.92017f $ **FLOATING
C1185 two_stage_instrumentation_amplifier_0.ota_slow_gmid_1.vota.t3 VSS 0.333f $ **FLOATING
C1186 two_stage_instrumentation_amplifier_0.ota_slow_gmid_1.vota.t2 VSS 0.4625f $ **FLOATING
C1187 two_stage_instrumentation_amplifier_0.ota_slow_gmid_1.vota.n2 VSS 0.56576f $ **FLOATING
C1188 two_stage_instrumentation_amplifier_0.ota_slow_gmid_1.ota_slow_gmid_common_0/ota_slow_gmid_pairs_0.vota VSS 0.3457f $ **FLOATING
C1189 two_stage_instrumentation_amplifier_0.ota_slow_gmid_1.vota.n3 VSS 0.11021f $ **FLOATING
C1190 two_stage_instrumentation_amplifier_0.ota_slow_gmid_1.vota.n4 VSS 0.92124f $ **FLOATING
C1191 two_stage_instrumentation_amplifier_0.ota_slow_gmid_1.ota_slow_gmid_mirror_0.vota VSS 0.34288f $ **FLOATING
C1192 two_stage_instrumentation_amplifier_0.ota_slow_gmid_1.vota.t5 VSS 4.31823f $ **FLOATING
C1193 two_stage_instrumentation_amplifier_0.ota_slow_gmid_1.vota.t1 VSS 0.04214f $ **FLOATING
C1194 two_stage_instrumentation_amplifier_0.ota_slow_gmid_1.vota.n5 VSS 0.21666f $ **FLOATING
C1195 two_stage_instrumentation_amplifier_0.ota_slow_gmid_1.vota.t4 VSS 4.31647f $ **FLOATING
C1196 two_stage_instrumentation_amplifier_0.ota_slow_gmid_1.vota.t0 VSS 0.37635f $ **FLOATING
C1197 two_stage_instrumentation_amplifier_0.ota_slow_gmid_1.vota.n6 VSS 1.15978f $ **FLOATING
C1198 two_stage_instrumentation_amplifier_0.ota_slow_gmid_1.vota.n7 VSS 0.06756f $ **FLOATING
C1199 COMPARATOR_RES.t1 VSS 0.51055f $ **FLOATING
C1200 COMPARATOR_RES.t0 VSS 0.50578f $ **FLOATING
C1201 COMPARATOR_RES.n0 VSS 0.4733f $ **FLOATING
C1202 COMPARATOR_RES.n1 VSS 0.06537f $ **FLOATING
C1203 COMPARATOR_RES.n2 VSS 11.3044f $ **FLOATING
C1204 vref.t5 VSS 0.12482f $ **FLOATING
C1205 ref_selector_0.ref_selector_r_96_0.vref VSS 0.80573f $ **FLOATING
C1206 vref.t8 VSS 3.52976f $ **FLOATING
C1207 vref.t7 VSS 3.32395f $ **FLOATING
C1208 vref.n0 VSS 0.61707f $ **FLOATING
C1209 two_stage_instrumentation_amplifier_0.ota_slow_gmid_1.ota_slow_gmid_common_0/ota_slow_gmid_pairs_0.vp VSS 0.27152f $ **FLOATING
C1210 two_stage_instrumentation_amplifier_0.VN VSS 5.22444f $ **FLOATING
C1211 vref.n1 VSS 20.6504f $ **FLOATING
C1212 vref.t2 VSS 0.17527f $ **FLOATING
C1213 vref.t3 VSS 0.16371f $ **FLOATING
C1214 vref.n2 VSS 0.29543f $ **FLOATING
C1215 current_source_1mA_0.current_source_1mA_2_stage_0.current_source_ref_0.i100ua VSS 0.01759f $ **FLOATING
C1216 vref.n3 VSS 0.70097f $ **FLOATING
C1217 current_source_1mA_0.I100UA VSS 3.96456f $ **FLOATING
C1218 vref.n4 VSS 4.70174f $ **FLOATING
C1219 vref.t0 VSS 0.26503f $ **FLOATING
C1220 vref.t1 VSS 0.37968f $ **FLOATING
C1221 vref.t6 VSS 0.26005f $ **FLOATING
C1222 vref.n5 VSS 0.65141f $ **FLOATING
C1223 vref.t4 VSS 0.26005f $ **FLOATING
C1224 vref.n6 VSS 0.35663f $ **FLOATING
C1225 vref.n7 VSS 0.1987f $ **FLOATING
C1226 vref.n8 VSS 0.21056f $ **FLOATING
C1227 vref.n9 VSS 1.6477f $ **FLOATING
C1228 ref_selector_0.ref_selector_r_switch_0.vref VSS 0.50319f $ **FLOATING
C1229 S3.n0 VSS 21.0176f $ **FLOATING
C1230 S3.t0 VSS 0.65494f $ **FLOATING
C1231 two_stage_instrumentation_amplifier_0.ota_slow_gmid_1.ota_slow_gmid_mirror_0.vref.t1 VSS 0.19445f $ **FLOATING
C1232 two_stage_instrumentation_amplifier_0.ota_slow_gmid_1.ota_slow_gmid_mirror_0.vref.t3 VSS 0.02895f $ **FLOATING
C1233 two_stage_instrumentation_amplifier_0.ota_slow_gmid_1.ota_slow_gmid_mirror_0.vref.t2 VSS 4.68107f $ **FLOATING
C1234 two_stage_instrumentation_amplifier_0.ota_slow_gmid_1.ota_slow_gmid_mirror_0.vref.t4 VSS 0.05631f $ **FLOATING
C1235 two_stage_instrumentation_amplifier_0.ota_slow_gmid_1.ota_slow_gmid_mirror_0.vref.n0 VSS 1.18711f $ **FLOATING
C1236 two_stage_instrumentation_amplifier_0.ota_slow_gmid_1.ota_slow_gmid_mirror_0.vref.n1 VSS 0.21602f $ **FLOATING
C1237 two_stage_instrumentation_amplifier_0.ota_slow_gmid_1.ota_slow_gmid_mirror_0.vref.n2 VSS 0.29299f $ **FLOATING
C1238 two_stage_instrumentation_amplifier_0.ota_slow_gmid_1.ota_slow_gmid_mirror_0.vref.t0 VSS 0.3479f $ **FLOATING
C1239 two_stage_instrumentation_amplifier_0.ota_slow_gmid_1.ota_slow_gmid_mirror_0.vref.n3 VSS 0.61287f $ **FLOATING
C1240 two_stage_instrumentation_amplifier_0.ota_slow_gmid_1.ota_slow_gmid_mirror_0.vref.n4 VSS 0.29865f $ **FLOATING
C1241 two_stage_instrumentation_amplifier_0.ota_slow_gmid_1.VN.t1 VSS 0.02279f $ **FLOATING
C1242 two_stage_instrumentation_amplifier_0.ota_slow_gmid_1.VN.t0 VSS 0.02265f $ **FLOATING
C1243 two_stage_instrumentation_amplifier_0.ota_slow_gmid_1.VN.n0 VSS 0.06959f $ **FLOATING
C1244 two_stage_instrumentation_amplifier_0.ota_slow_gmid_1.VN.t2 VSS 1.39203f $ **FLOATING
C1245 two_stage_instrumentation_amplifier_0.ota_slow_gmid_1.VN.t3 VSS 1.36163f $ **FLOATING
C1246 two_stage_instrumentation_amplifier_0.ota_slow_gmid_1.VN.n1 VSS 0.31698f $ **FLOATING
C1247 VBIASH.t19 VSS 4.38039f $ **FLOATING
C1248 VBIASH.t9 VSS 0.11849f $ **FLOATING
C1249 VBIASH.t4 VSS 0.11849f $ **FLOATING
C1250 VBIASH.t10 VSS 0.11849f $ **FLOATING
C1251 VBIASH.t12 VSS 0.11849f $ **FLOATING
C1252 VBIASH.t16 VSS 0.10546f $ **FLOATING
C1253 VBIASH.t8 VSS 0.23959f $ **FLOATING
C1254 VBIASH.t7 VSS 0.28543f $ **FLOATING
C1255 VBIASH.n0 VSS 0.89454f $ **FLOATING
C1256 VBIASH.n1 VSS 0.59623f $ **FLOATING
C1257 VBIASH.n2 VSS 0.33208f $ **FLOATING
C1258 VBIASH.n3 VSS 0.3104f $ **FLOATING
C1259 VBIASH.n4 VSS 0.28178f $ **FLOATING
C1260 VBIASH.n5 VSS 1.28315f $ **FLOATING
C1261 VBIASH.n6 VSS 1.76858f $ **FLOATING
C1262 VBIASH.t17 VSS 0.11849f $ **FLOATING
C1263 VBIASH.t14 VSS 0.11849f $ **FLOATING
C1264 VBIASH.t6 VSS 0.11849f $ **FLOATING
C1265 VBIASH.t11 VSS 0.11849f $ **FLOATING
C1266 VBIASH.t13 VSS 0.10546f $ **FLOATING
C1267 VBIASH.t5 VSS 0.23959f $ **FLOATING
C1268 VBIASH.t15 VSS 0.28543f $ **FLOATING
C1269 VBIASH.n7 VSS 0.89454f $ **FLOATING
C1270 VBIASH.n8 VSS 0.59623f $ **FLOATING
C1271 VBIASH.n9 VSS 0.33208f $ **FLOATING
C1272 VBIASH.n10 VSS 0.3104f $ **FLOATING
C1273 VBIASH.n11 VSS 0.28524f $ **FLOATING
C1274 VBIASH.n12 VSS 0.42179f $ **FLOATING
C1275 VBIASH.n13 VSS 3.27005f $ **FLOATING
C1276 VBIASH.n14 VSS 25.2378f $ **FLOATING
C1277 VBIASH.t1 VSS 0.64845f $ **FLOATING
C1278 VBIASH.t2 VSS 0.76568f $ **FLOATING
C1279 VBIASH.t3 VSS 0.76568f $ **FLOATING
C1280 VBIASH.t0 VSS 0.85818f $ **FLOATING
C1281 VBIASH.n15 VSS 0.87434f $ **FLOATING
C1282 VBIASH.n16 VSS 0.61339f $ **FLOATING
C1283 VBIASH.n17 VSS 0.51171f $ **FLOATING
C1284 VBIASH.t18 VSS 2.7279f $ **FLOATING
C1285 VBIASH.n18 VSS 1.02571f $ **FLOATING
C1286 non_inverting_amplifier_hv_0.ota_hv_slow_gmid_0.en.t0 VSS 0.33787f $ **FLOATING
C1287 non_inverting_amplifier_hv_0.ota_hv_slow_gmid_0.en.t4 VSS 0.64289f $ **FLOATING
C1288 non_inverting_amplifier_hv_0.ota_hv_slow_gmid_0.en.t2 VSS 2.66016f $ **FLOATING
C1289 non_inverting_amplifier_hv_0.ota_hv_slow_gmid_0.en.n0 VSS 1.4377f $ **FLOATING
C1290 non_inverting_amplifier_hv_0.ota_hv_slow_gmid_0.en.t3 VSS 2.66351f $ **FLOATING
C1291 non_inverting_amplifier_hv_0.ota_hv_slow_gmid_0.en.t5 VSS 0.64133f $ **FLOATING
C1292 non_inverting_amplifier_hv_0.ota_hv_slow_gmid_0.en.n1 VSS 0.69001f $ **FLOATING
C1293 non_inverting_amplifier_hv_0.ota_hv_slow_gmid_0.en.n2 VSS 1.7984f $ **FLOATING
C1294 non_inverting_amplifier_hv_0.ota_hv_slow_gmid_0.en.n3 VSS 0.20504f $ **FLOATING
C1295 non_inverting_amplifier_hv_0.ota_hv_slow_gmid_0.en.t1 VSS 0.21173f $ **FLOATING
C1296 non_inverting_amplifier_hv_0.ota_hv_slow_gmid_0.ota_hv_slow_gmid_ctrl_inv_0.Y VSS 0.21136f $ **FLOATING
C1297 ota_lv_gmid_comparator_0.ota_slow_gmid_ctrl_buff_1.y.t3 VSS 1.17819f $ **FLOATING
C1298 ota_lv_gmid_comparator_0.ota_slow_gmid_ctrl_buff_1.y.t2 VSS 1.17819f $ **FLOATING
C1299 ota_lv_gmid_comparator_0.ota_slow_gmid_ctrl_buff_1.y.n0 VSS 0.5985f $ **FLOATING
C1300 ota_lv_gmid_comparator_0.ota_slow_gmid_ctrl_buff_1.y.n1 VSS 0.82648f $ **FLOATING
C1301 ota_lv_gmid_comparator_0.ota_slow_gmid_ctrl_buff_1.y.t1 VSS 0.18946f $ **FLOATING
C1302 ota_lv_gmid_comparator_0.ota_slow_gmid_ctrl_buff_1.y.t0 VSS 0.18771f $ **FLOATING
C1303 ota_lv_gmid_comparator_0.ota_slow_gmid_ctrl_buff_1.y.n2 VSS 0.18459f $ **FLOATING
C1304 two_stage_instrumentation_amplifier_0.ota_slow_gmid_0.ota_slow_gmid_buffer_0.ibiasn.t6 VSS 0.02593f $ **FLOATING
C1305 two_stage_instrumentation_amplifier_0.ota_slow_gmid_0.ota_slow_gmid_buffer_0.ibiasn.t5 VSS 0.0484f $ **FLOATING
C1306 two_stage_instrumentation_amplifier_0.ota_slow_gmid_0.ota_slow_gmid_buffer_0.ibiasn.n0 VSS 0.09399f $ **FLOATING
C1307 two_stage_instrumentation_amplifier_0.ota_slow_gmid_0.ota_slow_gmid_buffer_0.ibiasn.n1 VSS 0.01138f $ **FLOATING
C1308 two_stage_instrumentation_amplifier_0.ota_slow_gmid_0.ota_slow_gmid_buffer_0.ibiasn.n2 VSS 0.02242f $ **FLOATING
C1309 two_stage_instrumentation_amplifier_0.ota_slow_gmid_0.ota_slow_gmid_buffer_0.ibiasn.n3 VSS 0.02204f $ **FLOATING
C1310 two_stage_instrumentation_amplifier_0.ota_slow_gmid_0.ota_slow_gmid_buffer_0.ibiasn.n4 VSS 0.02204f $ **FLOATING
C1311 two_stage_instrumentation_amplifier_0.ota_slow_gmid_0.ota_slow_gmid_buffer_0.ibiasn.n6 VSS 0.01306f $ **FLOATING
C1312 two_stage_instrumentation_amplifier_0.ota_slow_gmid_0.ota_slow_gmid_buffer_0.ibiasn.n9 VSS 0.02204f $ **FLOATING
C1313 two_stage_instrumentation_amplifier_0.ota_slow_gmid_0.ota_slow_gmid_buffer_0.ibiasn.t2 VSS 0.01668f $ **FLOATING
C1314 two_stage_instrumentation_amplifier_0.ota_slow_gmid_0.ota_slow_gmid_buffer_0.ibiasn.t4 VSS 0.01191f $ **FLOATING
C1315 two_stage_instrumentation_amplifier_0.ota_slow_gmid_0.ota_slow_gmid_buffer_0.ibiasn.n10 VSS 0.18047f $ **FLOATING
C1316 two_stage_instrumentation_amplifier_0.ota_slow_gmid_0.ota_slow_gmid_buffer_0.ibiasn.n11 VSS 0.03318f $ **FLOATING
C1317 two_stage_instrumentation_amplifier_0.ota_slow_gmid_0.ota_slow_gmid_buffer_0.ibiasn.n12 VSS 0.02242f $ **FLOATING
C1318 two_stage_instrumentation_amplifier_0.ota_slow_gmid_0.ota_slow_gmid_buffer_0.ibiasn.n13 VSS 0.02204f $ **FLOATING
C1319 two_stage_instrumentation_amplifier_0.ota_slow_gmid_0.ota_slow_gmid_buffer_0.ibiasn.n14 VSS 0.02204f $ **FLOATING
C1320 two_stage_instrumentation_amplifier_0.ota_slow_gmid_0.ota_slow_gmid_buffer_0.ibiasn.n15 VSS 0.02242f $ **FLOATING
C1321 two_stage_instrumentation_amplifier_0.ota_slow_gmid_0.ota_slow_gmid_buffer_0.ibiasn.n16 VSS 0.02242f $ **FLOATING
C1322 two_stage_instrumentation_amplifier_0.ota_slow_gmid_0.ota_slow_gmid_buffer_0.ibiasn.n17 VSS 0.02204f $ **FLOATING
C1323 two_stage_instrumentation_amplifier_0.ota_slow_gmid_0.ota_slow_gmid_buffer_0.ibiasn.n18 VSS 0.02204f $ **FLOATING
C1324 two_stage_instrumentation_amplifier_0.ota_slow_gmid_0.ota_slow_gmid_buffer_0.ibiasn.n19 VSS 0.02242f $ **FLOATING
C1325 two_stage_instrumentation_amplifier_0.ota_slow_gmid_0.ota_slow_gmid_buffer_0.ibiasn.n20 VSS 0.02242f $ **FLOATING
C1326 two_stage_instrumentation_amplifier_0.ota_slow_gmid_0.ota_slow_gmid_buffer_0.ibiasn.n21 VSS 0.02242f $ **FLOATING
C1327 two_stage_instrumentation_amplifier_0.ota_slow_gmid_0.ota_slow_gmid_buffer_0.ibiasn.n22 VSS 0.02204f $ **FLOATING
C1328 two_stage_instrumentation_amplifier_0.ota_slow_gmid_0.ota_slow_gmid_buffer_0.ibiasn.n25 VSS 0.02204f $ **FLOATING
C1329 two_stage_instrumentation_amplifier_0.ota_slow_gmid_0.ota_slow_gmid_buffer_0.ibiasn.n26 VSS 0.02204f $ **FLOATING
C1330 two_stage_instrumentation_amplifier_0.ota_slow_gmid_0.ota_slow_gmid_buffer_0.ibiasn.n27 VSS 0.02242f $ **FLOATING
C1331 two_stage_instrumentation_amplifier_0.ota_slow_gmid_0.ota_slow_gmid_buffer_0.ibiasn.n28 VSS 0.02242f $ **FLOATING
C1332 two_stage_instrumentation_amplifier_0.ota_slow_gmid_0.ota_slow_gmid_buffer_0.ibiasn.n29 VSS 0.02204f $ **FLOATING
C1333 two_stage_instrumentation_amplifier_0.ota_slow_gmid_0.ota_slow_gmid_buffer_0.ibiasn.n30 VSS 0.02204f $ **FLOATING
C1334 two_stage_instrumentation_amplifier_0.ota_slow_gmid_0.ota_slow_gmid_buffer_0.ibiasn.n31 VSS 0.02242f $ **FLOATING
C1335 two_stage_instrumentation_amplifier_0.ota_slow_gmid_0.ota_slow_gmid_buffer_0.ibiasn.n32 VSS 0.02242f $ **FLOATING
C1336 two_stage_instrumentation_amplifier_0.ota_slow_gmid_0.ota_slow_gmid_buffer_0.ibiasn.t1 VSS 0.01392f $ **FLOATING
C1337 two_stage_instrumentation_amplifier_0.ota_slow_gmid_0.ota_slow_gmid_buffer_0.ibiasn.t3 VSS 0.01336f $ **FLOATING
C1338 two_stage_instrumentation_amplifier_0.ota_slow_gmid_0.ota_slow_gmid_buffer_0.ibiasn.n33 VSS 0.18204f $ **FLOATING
C1339 two_stage_instrumentation_amplifier_0.ota_slow_gmid_0.ota_slow_gmid_buffer_0.ibiasn.n34 VSS 0.03321f $ **FLOATING
C1340 two_stage_instrumentation_amplifier_0.ota_slow_gmid_0.ota_slow_gmid_buffer_0.ibiasn.n35 VSS 0.01334f $ **FLOATING
C1341 two_stage_instrumentation_amplifier_0.ota_slow_gmid_0.ota_slow_gmid_buffer_0.ibiasn.t0 VSS 3.59733f $ **FLOATING
C1342 two_stage_instrumentation_amplifier_0.ota_slow_gmid_0.ota_slow_gmid_buffer_0.ibiasn.n37 VSS 0.02204f $ **FLOATING
C1343 two_stage_instrumentation_amplifier_0.ota_slow_gmid_0.ota_slow_gmid_buffer_0.ibiasn.n38 VSS 0.02225f $ **FLOATING
C1344 two_stage_instrumentation_amplifier_0.ota_slow_gmid_0.ota_slow_gmid_buffer_0.ibiasn.n39 VSS 0.0327f $ **FLOATING
C1345 two_stage_instrumentation_amplifier_0.ota_slow_gmid_1.ota_slow_gmid_buffer_0.ibiasn.n0 VSS 0.01138f $ **FLOATING
C1346 two_stage_instrumentation_amplifier_0.ota_slow_gmid_1.ota_slow_gmid_buffer_0.ibiasn.n1 VSS 0.02242f $ **FLOATING
C1347 two_stage_instrumentation_amplifier_0.ota_slow_gmid_1.ota_slow_gmid_buffer_0.ibiasn.n2 VSS 0.02204f $ **FLOATING
C1348 two_stage_instrumentation_amplifier_0.ota_slow_gmid_1.ota_slow_gmid_buffer_0.ibiasn.n3 VSS 0.02204f $ **FLOATING
C1349 two_stage_instrumentation_amplifier_0.ota_slow_gmid_1.ota_slow_gmid_buffer_0.ibiasn.n5 VSS 0.01306f $ **FLOATING
C1350 two_stage_instrumentation_amplifier_0.ota_slow_gmid_1.ota_slow_gmid_buffer_0.ibiasn.n8 VSS 0.02204f $ **FLOATING
C1351 two_stage_instrumentation_amplifier_0.ota_slow_gmid_1.ota_slow_gmid_buffer_0.ibiasn.t3 VSS 0.01668f $ **FLOATING
C1352 two_stage_instrumentation_amplifier_0.ota_slow_gmid_1.ota_slow_gmid_buffer_0.ibiasn.t2 VSS 0.01191f $ **FLOATING
C1353 two_stage_instrumentation_amplifier_0.ota_slow_gmid_1.ota_slow_gmid_buffer_0.ibiasn.n9 VSS 0.18047f $ **FLOATING
C1354 two_stage_instrumentation_amplifier_0.ota_slow_gmid_1.ota_slow_gmid_buffer_0.ibiasn.n10 VSS 0.03318f $ **FLOATING
C1355 two_stage_instrumentation_amplifier_0.ota_slow_gmid_1.ota_slow_gmid_buffer_0.ibiasn.n11 VSS 0.02242f $ **FLOATING
C1356 two_stage_instrumentation_amplifier_0.ota_slow_gmid_1.ota_slow_gmid_buffer_0.ibiasn.n12 VSS 0.02204f $ **FLOATING
C1357 two_stage_instrumentation_amplifier_0.ota_slow_gmid_1.ota_slow_gmid_buffer_0.ibiasn.n13 VSS 0.02204f $ **FLOATING
C1358 two_stage_instrumentation_amplifier_0.ota_slow_gmid_1.ota_slow_gmid_buffer_0.ibiasn.n14 VSS 0.02242f $ **FLOATING
C1359 two_stage_instrumentation_amplifier_0.ota_slow_gmid_1.ota_slow_gmid_buffer_0.ibiasn.n15 VSS 0.02242f $ **FLOATING
C1360 two_stage_instrumentation_amplifier_0.ota_slow_gmid_1.ota_slow_gmid_buffer_0.ibiasn.n16 VSS 0.02204f $ **FLOATING
C1361 two_stage_instrumentation_amplifier_0.ota_slow_gmid_1.ota_slow_gmid_buffer_0.ibiasn.n17 VSS 0.02204f $ **FLOATING
C1362 two_stage_instrumentation_amplifier_0.ota_slow_gmid_1.ota_slow_gmid_buffer_0.ibiasn.n18 VSS 0.02242f $ **FLOATING
C1363 two_stage_instrumentation_amplifier_0.ota_slow_gmid_1.ota_slow_gmid_buffer_0.ibiasn.n19 VSS 0.02242f $ **FLOATING
C1364 two_stage_instrumentation_amplifier_0.ota_slow_gmid_1.ota_slow_gmid_buffer_0.ibiasn.n20 VSS 0.02242f $ **FLOATING
C1365 two_stage_instrumentation_amplifier_0.ota_slow_gmid_1.ota_slow_gmid_buffer_0.ibiasn.n21 VSS 0.02204f $ **FLOATING
C1366 two_stage_instrumentation_amplifier_0.ota_slow_gmid_1.ota_slow_gmid_buffer_0.ibiasn.n24 VSS 0.02204f $ **FLOATING
C1367 two_stage_instrumentation_amplifier_0.ota_slow_gmid_1.ota_slow_gmid_buffer_0.ibiasn.n25 VSS 0.02204f $ **FLOATING
C1368 two_stage_instrumentation_amplifier_0.ota_slow_gmid_1.ota_slow_gmid_buffer_0.ibiasn.n26 VSS 0.02242f $ **FLOATING
C1369 two_stage_instrumentation_amplifier_0.ota_slow_gmid_1.ota_slow_gmid_buffer_0.ibiasn.n27 VSS 0.02242f $ **FLOATING
C1370 two_stage_instrumentation_amplifier_0.ota_slow_gmid_1.ota_slow_gmid_buffer_0.ibiasn.n28 VSS 0.02204f $ **FLOATING
C1371 two_stage_instrumentation_amplifier_0.ota_slow_gmid_1.ota_slow_gmid_buffer_0.ibiasn.n29 VSS 0.02204f $ **FLOATING
C1372 two_stage_instrumentation_amplifier_0.ota_slow_gmid_1.ota_slow_gmid_buffer_0.ibiasn.n30 VSS 0.02242f $ **FLOATING
C1373 two_stage_instrumentation_amplifier_0.ota_slow_gmid_1.ota_slow_gmid_buffer_0.ibiasn.n31 VSS 0.02242f $ **FLOATING
C1374 two_stage_instrumentation_amplifier_0.ota_slow_gmid_1.ota_slow_gmid_buffer_0.ibiasn.t1 VSS 0.01336f $ **FLOATING
C1375 two_stage_instrumentation_amplifier_0.ota_slow_gmid_1.ota_slow_gmid_buffer_0.ibiasn.t4 VSS 0.01392f $ **FLOATING
C1376 two_stage_instrumentation_amplifier_0.ota_slow_gmid_1.ota_slow_gmid_buffer_0.ibiasn.n32 VSS 0.18204f $ **FLOATING
C1377 two_stage_instrumentation_amplifier_0.ota_slow_gmid_1.ota_slow_gmid_buffer_0.ibiasn.n33 VSS 0.03321f $ **FLOATING
C1378 two_stage_instrumentation_amplifier_0.ota_slow_gmid_1.ota_slow_gmid_buffer_0.ibiasn.n34 VSS 0.01334f $ **FLOATING
C1379 two_stage_instrumentation_amplifier_0.ota_slow_gmid_1.ota_slow_gmid_buffer_0.ibiasn.t0 VSS 3.59733f $ **FLOATING
C1380 two_stage_instrumentation_amplifier_0.ota_slow_gmid_1.ota_slow_gmid_buffer_0.ibiasn.n36 VSS 0.02204f $ **FLOATING
C1381 two_stage_instrumentation_amplifier_0.ota_slow_gmid_1.ota_slow_gmid_buffer_0.ibiasn.n37 VSS 0.02225f $ **FLOATING
C1382 two_stage_instrumentation_amplifier_0.ota_slow_gmid_1.ota_slow_gmid_buffer_0.ibiasn.n38 VSS 0.03478f $ **FLOATING
C1383 two_stage_instrumentation_amplifier_0.ota_slow_gmid_1.ota_slow_gmid_buffer_0.ibiasn.t5 VSS 0.02593f $ **FLOATING
C1384 two_stage_instrumentation_amplifier_0.ota_slow_gmid_1.ota_slow_gmid_buffer_0.ibiasn.t6 VSS 0.0484f $ **FLOATING
C1385 two_stage_instrumentation_amplifier_0.ota_slow_gmid_1.ota_slow_gmid_buffer_0.ibiasn.n39 VSS 0.09313f $ **FLOATING
C1386 ota_lv_gmid_comparator_0.ota_slow_gmid_ctrl_buff_0.x.t7 VSS 0.6053f $ **FLOATING
C1387 ota_lv_gmid_comparator_0.ota_slow_gmid_ctrl_buff_0.x.t4 VSS 0.10344f $ **FLOATING
C1388 ota_lv_gmid_comparator_0.ota_slow_gmid_ctrl_buff_0.x.t3 VSS 0.11471f $ **FLOATING
C1389 ota_lv_gmid_comparator_0.ota_slow_gmid_ctrl_buff_0.x.t5 VSS 0.12408f $ **FLOATING
C1390 ota_lv_gmid_comparator_0.ota_slow_gmid_ctrl_buff_0.x.n0 VSS 0.11004f $ **FLOATING
C1391 ota_lv_gmid_comparator_0.ota_slow_gmid_ctrl_buff_0.x.n1 VSS 0.05683f $ **FLOATING
C1392 ota_lv_gmid_comparator_0.ota_slow_gmid_ctrl_buff_0.x.t0 VSS 0.06885f $ **FLOATING
C1393 ota_lv_gmid_comparator_0.ota_slow_gmid_ctrl_buff_0.x.t2 VSS 0.07337f $ **FLOATING
C1394 ota_lv_gmid_comparator_0.ota_slow_gmid_ctrl_buff_0.x.n2 VSS 0.09246f $ **FLOATING
C1395 ota_lv_gmid_comparator_0.ota_slow_gmid_ctrl_buff_0.x.t1 VSS 0.0618f $ **FLOATING
C1396 ota_lv_gmid_comparator_0.ota_slow_gmid_ctrl_buff_0.x.n3 VSS 0.0459f $ **FLOATING
C1397 ota_lv_gmid_comparator_0.ota_slow_gmid_ctrl_buff_0.x.n4 VSS 0.21461f $ **FLOATING
C1398 ota_lv_gmid_comparator_0.ota_slow_gmid_ctrl_buff_0.x.n5 VSS 0.18088f $ **FLOATING
C1399 ota_lv_gmid_comparator_0.ota_slow_gmid_ctrl_buff_0.x.t6 VSS 0.60374f $ **FLOATING
C1400 ota_lv_gmid_comparator_0.ota_slow_gmid_ctrl_buff_0.x.t8 VSS 0.11643f $ **FLOATING
C1401 ota_lv_gmid_comparator_0.ota_slow_gmid_ctrl_buff_0.x.n6 VSS 0.0357f $ **FLOATING
C1402 ota_lv_gmid_comparator_0.ota_slow_gmid_ctrl_buff_0.x.n7 VSS 0.22171f $ **FLOATING
C1403 VOUT.t7 VSS 0.07718f $ **FLOATING
C1404 VOUT.t2 VSS 0.08464f $ **FLOATING
C1405 VOUT.t0 VSS 0.08639f $ **FLOATING
C1406 VOUT.t6 VSS 0.09518f $ **FLOATING
C1407 VOUT.n0 VSS 0.31818f $ **FLOATING
C1408 VOUT.n1 VSS 0.12294f $ **FLOATING
C1409 VOUT.t5 VSS 0.08588f $ **FLOATING
C1410 VOUT.t3 VSS 0.09656f $ **FLOATING
C1411 VOUT.n2 VSS 0.25798f $ **FLOATING
C1412 VOUT.t4 VSS 0.07759f $ **FLOATING
C1413 VOUT.n3 VSS 0.12143f $ **FLOATING
C1414 VOUT.n4 VSS 0.11956f $ **FLOATING
C1415 VOUT.n5 VSS 0.43061f $ **FLOATING
C1416 VOUT.t1 VSS 0.10383f $ **FLOATING
C1417 VOUT.n6 VSS 3.87798f $ **FLOATING
C1418 two_stage_instrumentation_amplifier_0.vamp1.t0 VSS 0.06066f $ **FLOATING
C1419 two_stage_instrumentation_amplifier_0.vamp1.t62 VSS 0.05715f $ **FLOATING
C1420 two_stage_instrumentation_amplifier_0.top_conditionning_gain_s2_0.vamp1 VSS 0.35335f $ **FLOATING
C1421 two_stage_instrumentation_amplifier_0.vamp1.t1 VSS 0.16446f $ **FLOATING
C1422 two_stage_instrumentation_amplifier_0.vamp1.t20 VSS 0.01493f $ **FLOATING
C1423 two_stage_instrumentation_amplifier_0.vamp1.t4 VSS 0.01493f $ **FLOATING
C1424 two_stage_instrumentation_amplifier_0.vamp1.n0 VSS 0.28993f $ **FLOATING
C1425 two_stage_instrumentation_amplifier_0.vamp1.t45 VSS 0.01493f $ **FLOATING
C1426 two_stage_instrumentation_amplifier_0.vamp1.t29 VSS 0.01493f $ **FLOATING
C1427 two_stage_instrumentation_amplifier_0.vamp1.n1 VSS 0.10002f $ **FLOATING
C1428 two_stage_instrumentation_amplifier_0.vamp1.t10 VSS 0.01493f $ **FLOATING
C1429 two_stage_instrumentation_amplifier_0.vamp1.t53 VSS 0.01493f $ **FLOATING
C1430 two_stage_instrumentation_amplifier_0.vamp1.n2 VSS 0.07216f $ **FLOATING
C1431 two_stage_instrumentation_amplifier_0.vamp1.t34 VSS 0.01493f $ **FLOATING
C1432 two_stage_instrumentation_amplifier_0.vamp1.n3 VSS 0.02038f $ **FLOATING
C1433 two_stage_instrumentation_amplifier_0.vamp1.t55 VSS 0.01493f $ **FLOATING
C1434 two_stage_instrumentation_amplifier_0.vamp1.t41 VSS 0.01493f $ **FLOATING
C1435 two_stage_instrumentation_amplifier_0.vamp1.n4 VSS 0.07216f $ **FLOATING
C1436 two_stage_instrumentation_amplifier_0.vamp1.t18 VSS 0.01493f $ **FLOATING
C1437 two_stage_instrumentation_amplifier_0.vamp1.t2 VSS 0.01493f $ **FLOATING
C1438 two_stage_instrumentation_amplifier_0.vamp1.n5 VSS 0.07627f $ **FLOATING
C1439 two_stage_instrumentation_amplifier_0.vamp1.t44 VSS 0.01493f $ **FLOATING
C1440 two_stage_instrumentation_amplifier_0.vamp1.t7 VSS 0.01493f $ **FLOATING
C1441 two_stage_instrumentation_amplifier_0.vamp1.t32 VSS 0.01493f $ **FLOATING
C1442 two_stage_instrumentation_amplifier_0.vamp1.t54 VSS 0.01493f $ **FLOATING
C1443 two_stage_instrumentation_amplifier_0.vamp1.t16 VSS 0.01493f $ **FLOATING
C1444 two_stage_instrumentation_amplifier_0.vamp1.t42 VSS 0.01493f $ **FLOATING
C1445 two_stage_instrumentation_amplifier_0.vamp1.t17 VSS 0.01493f $ **FLOATING
C1446 two_stage_instrumentation_amplifier_0.vamp1.t43 VSS 0.01493f $ **FLOATING
C1447 two_stage_instrumentation_amplifier_0.vamp1.t28 VSS 0.01493f $ **FLOATING
C1448 two_stage_instrumentation_amplifier_0.vamp1.t50 VSS 0.01511f $ **FLOATING
C1449 two_stage_instrumentation_amplifier_0.vamp1.t12 VSS 0.01493f $ **FLOATING
C1450 two_stage_instrumentation_amplifier_0.vamp1.n6 VSS 0.0355f $ **FLOATING
C1451 two_stage_instrumentation_amplifier_0.vamp1.t36 VSS 0.01493f $ **FLOATING
C1452 two_stage_instrumentation_amplifier_0.vamp1.n7 VSS 0.01986f $ **FLOATING
C1453 two_stage_instrumentation_amplifier_0.vamp1.t39 VSS 0.01493f $ **FLOATING
C1454 two_stage_instrumentation_amplifier_0.vamp1.t61 VSS 0.01493f $ **FLOATING
C1455 two_stage_instrumentation_amplifier_0.vamp1.n8 VSS 0.07216f $ **FLOATING
C1456 two_stage_instrumentation_amplifier_0.vamp1.t59 VSS 0.01493f $ **FLOATING
C1457 two_stage_instrumentation_amplifier_0.vamp1.t26 VSS 0.01493f $ **FLOATING
C1458 two_stage_instrumentation_amplifier_0.vamp1.n9 VSS 0.10002f $ **FLOATING
C1459 two_stage_instrumentation_amplifier_0.vamp1.t24 VSS 0.01493f $ **FLOATING
C1460 two_stage_instrumentation_amplifier_0.vamp1.t49 VSS 0.01493f $ **FLOATING
C1461 two_stage_instrumentation_amplifier_0.vamp1.n10 VSS 0.10002f $ **FLOATING
C1462 two_stage_instrumentation_amplifier_0.vamp1.t48 VSS 0.01493f $ **FLOATING
C1463 two_stage_instrumentation_amplifier_0.vamp1.t9 VSS 0.01493f $ **FLOATING
C1464 two_stage_instrumentation_amplifier_0.vamp1.n11 VSS 0.10002f $ **FLOATING
C1465 two_stage_instrumentation_amplifier_0.vamp1.t8 VSS 0.01493f $ **FLOATING
C1466 two_stage_instrumentation_amplifier_0.vamp1.t33 VSS 0.01493f $ **FLOATING
C1467 two_stage_instrumentation_amplifier_0.vamp1.n12 VSS 0.10002f $ **FLOATING
C1468 two_stage_instrumentation_amplifier_0.vamp1.t37 VSS 0.01493f $ **FLOATING
C1469 two_stage_instrumentation_amplifier_0.vamp1.t57 VSS 0.01493f $ **FLOATING
C1470 two_stage_instrumentation_amplifier_0.vamp1.n13 VSS 0.10002f $ **FLOATING
C1471 two_stage_instrumentation_amplifier_0.vamp1.t56 VSS 0.01493f $ **FLOATING
C1472 two_stage_instrumentation_amplifier_0.vamp1.t22 VSS 0.01493f $ **FLOATING
C1473 two_stage_instrumentation_amplifier_0.vamp1.n14 VSS 0.10002f $ **FLOATING
C1474 two_stage_instrumentation_amplifier_0.vamp1.t21 VSS 0.01493f $ **FLOATING
C1475 two_stage_instrumentation_amplifier_0.vamp1.t47 VSS 0.01493f $ **FLOATING
C1476 two_stage_instrumentation_amplifier_0.vamp1.n15 VSS 0.10002f $ **FLOATING
C1477 two_stage_instrumentation_amplifier_0.vamp1.t46 VSS 0.01493f $ **FLOATING
C1478 two_stage_instrumentation_amplifier_0.vamp1.t6 VSS 0.01493f $ **FLOATING
C1479 two_stage_instrumentation_amplifier_0.vamp1.n16 VSS 0.10002f $ **FLOATING
C1480 two_stage_instrumentation_amplifier_0.vamp1.t5 VSS 0.01493f $ **FLOATING
C1481 two_stage_instrumentation_amplifier_0.vamp1.t31 VSS 0.01493f $ **FLOATING
C1482 two_stage_instrumentation_amplifier_0.vamp1.n17 VSS 0.07216f $ **FLOATING
C1483 two_stage_instrumentation_amplifier_0.vamp1.t14 VSS 0.01493f $ **FLOATING
C1484 two_stage_instrumentation_amplifier_0.vamp1.n18 VSS 0.02038f $ **FLOATING
C1485 two_stage_instrumentation_amplifier_0.vamp1.t30 VSS 0.01493f $ **FLOATING
C1486 two_stage_instrumentation_amplifier_0.vamp1.t38 VSS 0.01493f $ **FLOATING
C1487 two_stage_instrumentation_amplifier_0.vamp1.n19 VSS 0.07216f $ **FLOATING
C1488 two_stage_instrumentation_amplifier_0.vamp1.t51 VSS 0.01493f $ **FLOATING
C1489 two_stage_instrumentation_amplifier_0.vamp1.t58 VSS 0.01493f $ **FLOATING
C1490 two_stage_instrumentation_amplifier_0.vamp1.n20 VSS 0.10002f $ **FLOATING
C1491 two_stage_instrumentation_amplifier_0.vamp1.t13 VSS 0.01493f $ **FLOATING
C1492 two_stage_instrumentation_amplifier_0.vamp1.t23 VSS 0.01493f $ **FLOATING
C1493 two_stage_instrumentation_amplifier_0.vamp1.n21 VSS 0.12163f $ **FLOATING
C1494 two_stage_instrumentation_amplifier_0.vamp1.t19 VSS 0.01493f $ **FLOATING
C1495 two_stage_instrumentation_amplifier_0.vamp1.n22 VSS 0.05758f $ **FLOATING
C1496 two_stage_instrumentation_amplifier_0.vamp1.n23 VSS 0.04018f $ **FLOATING
C1497 two_stage_instrumentation_amplifier_0.vamp1.t3 VSS 0.01493f $ **FLOATING
C1498 two_stage_instrumentation_amplifier_0.vamp1.n24 VSS 0.01986f $ **FLOATING
C1499 two_stage_instrumentation_amplifier_0.vamp1.t35 VSS 0.01493f $ **FLOATING
C1500 two_stage_instrumentation_amplifier_0.vamp1.n25 VSS 0.07216f $ **FLOATING
C1501 two_stage_instrumentation_amplifier_0.vamp1.t11 VSS 0.01493f $ **FLOATING
C1502 two_stage_instrumentation_amplifier_0.vamp1.n26 VSS 0.10002f $ **FLOATING
C1503 two_stage_instrumentation_amplifier_0.vamp1.t25 VSS 0.01493f $ **FLOATING
C1504 two_stage_instrumentation_amplifier_0.vamp1.n27 VSS 0.10002f $ **FLOATING
C1505 two_stage_instrumentation_amplifier_0.vamp1.t60 VSS 0.01493f $ **FLOATING
C1506 two_stage_instrumentation_amplifier_0.vamp1.n28 VSS 0.10002f $ **FLOATING
C1507 two_stage_instrumentation_amplifier_0.vamp1.t40 VSS 0.01493f $ **FLOATING
C1508 two_stage_instrumentation_amplifier_0.vamp1.n29 VSS 0.10002f $ **FLOATING
C1509 two_stage_instrumentation_amplifier_0.vamp1.t15 VSS 0.01493f $ **FLOATING
C1510 two_stage_instrumentation_amplifier_0.vamp1.n30 VSS 0.10002f $ **FLOATING
C1511 two_stage_instrumentation_amplifier_0.vamp1.t52 VSS 0.01493f $ **FLOATING
C1512 two_stage_instrumentation_amplifier_0.vamp1.n31 VSS 0.10002f $ **FLOATING
C1513 two_stage_instrumentation_amplifier_0.vamp1.t27 VSS 0.01493f $ **FLOATING
C1514 two_stage_instrumentation_amplifier_0.vamp1.n32 VSS 0.07377f $ **FLOATING
C1515 two_stage_instrumentation_amplifier_0.vamp1.n33 VSS 0.07962f $ **FLOATING
C1516 two_stage_instrumentation_amplifier_0.ota_slow_gmid_1.ota_slow_gmid_buffer_0.vout VSS 0.30108f $ **FLOATING
C1517 two_stage_instrumentation_amplifier_0.ota_slow_gmid_1.VOUT VSS 0.0669f $ **FLOATING
C1518 two_stage_instrumentation_amplifier_0.vamp1.n34 VSS 0.30708f $ **FLOATING
C1519 two_stage_instrumentation_amplifier_0.top_conditionning_gain_s1_0.vamp1 VSS 0.3048f $ **FLOATING
C1520 current_source_1mA_0.current_source_1mA_2_stage_0.current_source_pass_element_0.iref.t2 VSS 0.20781f $ **FLOATING
C1521 current_source_1mA_0.current_source_1mA_2_stage_0.current_source_pass_element_0.iref.t0 VSS 0.24537f $ **FLOATING
C1522 current_source_1mA_0.current_source_1mA_2_stage_0.current_source_pass_element_0.iref.t1 VSS 0.24537f $ **FLOATING
C1523 current_source_1mA_0.current_source_1mA_2_stage_0.current_source_pass_element_0.iref.t3 VSS 0.275f $ **FLOATING
C1524 current_source_1mA_0.current_source_1mA_2_stage_0.current_source_pass_element_0.iref.n0 VSS 0.28019f $ **FLOATING
C1525 current_source_1mA_0.current_source_1mA_2_stage_0.current_source_pass_element_0.iref.n1 VSS 0.19656f $ **FLOATING
C1526 current_source_1mA_0.current_source_1mA_2_stage_0.current_source_pass_element_0.iref.n2 VSS 0.16805f $ **FLOATING
C1527 current_source_1mA_0.current_source_1mA_2_stage_0.current_source_pass_element_0.iref.n3 VSS 0.49564f $ **FLOATING
C1528 current_source_1mA_0.current_source_1mA_2_stage_0.current_source_pass_element_0.iref.n4 VSS 0.54417f $ **FLOATING
C1529 current_source_1mA_0.current_source_1mA_2_stage_0.current_source_pass_element_0.iref.t8 VSS 0.08705f $ **FLOATING
C1530 current_source_1mA_0.current_source_1mA_2_stage_0.current_source_pass_element_0.iref.t7 VSS 0.09566f $ **FLOATING
C1531 current_source_1mA_0.current_source_1mA_2_stage_0.current_source_pass_element_0.iref.n5 VSS 0.31178f $ **FLOATING
C1532 current_source_1mA_0.current_source_1mA_2_stage_0.current_source_pass_element_0.iref.t9 VSS 0.08705f $ **FLOATING
C1533 current_source_1mA_0.current_source_1mA_2_stage_0.current_source_pass_element_0.iref.t10 VSS 0.09566f $ **FLOATING
C1534 current_source_1mA_0.current_source_1mA_2_stage_0.current_source_pass_element_0.iref.n6 VSS 0.31178f $ **FLOATING
C1535 current_source_1mA_0.current_source_1mA_2_stage_0.current_source_pass_element_0.iref.n7 VSS 0.07467f $ **FLOATING
C1536 current_source_1mA_0.current_source_1mA_2_stage_0.current_source_pass_element_0.iref.t5 VSS 0.1536f $ **FLOATING
C1537 current_source_1mA_0.current_source_1mA_2_stage_0.current_source_pass_element_0.iref.n8 VSS 0.11403f $ **FLOATING
C1538 current_source_1mA_0.current_source_1mA_2_stage_0.current_source_pass_element_0.iref.n9 VSS 0.10939f $ **FLOATING
C1539 current_source_1mA_0.current_source_1mA_2_stage_0.current_source_pass_element_0.iref.n10 VSS 0.47439f $ **FLOATING
C1540 current_source_1mA_0.current_source_1mA_2_stage_0.current_source_pass_element_0.iref.t6 VSS 0.16098f $ **FLOATING
C1541 current_source_1mA_0.current_source_1mA_2_stage_0.current_source_pass_element_0.iref.n11 VSS 0.1603f $ **FLOATING
C1542 current_source_1mA_0.current_source_1mA_2_stage_0.current_source_pass_element_0.iref.n12 VSS 0.21459f $ **FLOATING
C1543 current_source_1mA_0.current_source_1mA_2_stage_0.current_source_pass_element_0.iref.t4 VSS 7.52697f $ **FLOATING
C1544 current_source_1mA_0.current_source_1mA_2_stage_0.current_source_pass_element_0.iref.n13 VSS 0.2146f $ **FLOATING
C1545 current_source_1mA_0.current_source_1mA_2_stage_0.current_source_pass_element_0.iref.n14 VSS 0.44319f $ **FLOATING
C1546 current_source_1mA_0.current_source_1mA_2_stage_0.current_source_pass_element_0.iref.n15 VSS 0.54243f $ **FLOATING
C1547 ota_lv_gmid_comparator_0.ota_slow_gmid_mirror_0.vout1.t14 VSS 0.18303f $ **FLOATING
C1548 ota_lv_gmid_comparator_0.ota_slow_gmid_mirror_0.vout1.t15 VSS 1.37769f $ **FLOATING
C1549 ota_lv_gmid_comparator_0.ota_slow_gmid_mirror_0.vout1.n0 VSS 0.69304f $ **FLOATING
C1550 ota_lv_gmid_comparator_0.ota_slow_gmid_mirror_0.vout1.t16 VSS 0.11369f $ **FLOATING
C1551 ota_lv_gmid_comparator_0.ota_slow_gmid_mirror_0.vout1.n1 VSS 0.45631f $ **FLOATING
C1552 ota_lv_gmid_comparator_0.ota_slow_gmid_mirror_0.vout1.t4 VSS 0.16464f $ **FLOATING
C1553 ota_lv_gmid_comparator_0.ota_slow_gmid_mirror_0.vout1.t5 VSS 0.12874f $ **FLOATING
C1554 ota_lv_gmid_comparator_0.ota_slow_gmid_mirror_0.vout1.n2 VSS 0.24922f $ **FLOATING
C1555 ota_lv_gmid_comparator_0.ota_slow_gmid_mirror_0.vout1.t13 VSS 0.23843f $ **FLOATING
C1556 ota_lv_gmid_comparator_0.ota_slow_gmid_mirror_0.vout1.t10 VSS 0.23044f $ **FLOATING
C1557 ota_lv_gmid_comparator_0.ota_slow_gmid_mirror_0.vout1.t7 VSS 0.26f $ **FLOATING
C1558 ota_lv_gmid_comparator_0.ota_slow_gmid_mirror_0.vout1.t12 VSS 0.25201f $ **FLOATING
C1559 ota_lv_gmid_comparator_0.ota_slow_gmid_mirror_0.vout1.t6 VSS 0.26f $ **FLOATING
C1560 ota_lv_gmid_comparator_0.ota_slow_gmid_mirror_0.vout1.t11 VSS 0.25201f $ **FLOATING
C1561 ota_lv_gmid_comparator_0.ota_slow_gmid_mirror_0.vout1.t9 VSS 0.26f $ **FLOATING
C1562 ota_lv_gmid_comparator_0.ota_slow_gmid_mirror_0.vout1.t8 VSS 0.25201f $ **FLOATING
C1563 ota_lv_gmid_comparator_0.ota_slow_gmid_mirror_0.vout1.n3 VSS 0.31209f $ **FLOATING
C1564 ota_lv_gmid_comparator_0.ota_slow_gmid_mirror_0.vout1.n4 VSS 0.34856f $ **FLOATING
C1565 ota_lv_gmid_comparator_0.ota_slow_gmid_mirror_0.vout1.n5 VSS 0.34856f $ **FLOATING
C1566 ota_lv_gmid_comparator_0.ota_slow_gmid_mirror_0.vout1.n6 VSS 0.35434f $ **FLOATING
C1567 ota_lv_gmid_comparator_0.ota_slow_gmid_mirror_0.vout1.n7 VSS 0.04557f $ **FLOATING
C1568 ota_lv_gmid_comparator_0.ota_slow_gmid_mirror_0.vout1.n8 VSS 1.95721f $ **FLOATING
C1569 ota_lv_gmid_comparator_0.ota_slow_gmid_mirror_0.vout1.n9 VSS 2.55368f $ **FLOATING
C1570 ota_lv_gmid_comparator_0.ota_slow_gmid_mirror_0.vout1.t3 VSS 0.06434f $ **FLOATING
C1571 ota_lv_gmid_comparator_0.ota_slow_gmid_mirror_0.vout1.t2 VSS 0.06497f $ **FLOATING
C1572 ota_lv_gmid_comparator_0.ota_slow_gmid_mirror_0.vout1.t0 VSS 0.06497f $ **FLOATING
C1573 ota_lv_gmid_comparator_0.ota_slow_gmid_mirror_0.vout1.t1 VSS 0.36788f $ **FLOATING
C1574 ota_lv_gmid_comparator_0.ota_slow_gmid_mirror_0.vout1.n10 VSS 1.2662f $ **FLOATING
C1575 ota_lv_gmid_comparator_0.ota_slow_gmid_mirror_0.vout1.n11 VSS 0.90847f $ **FLOATING
C1576 ota_lv_gmid_comparator_0.ota_slow_gmid_mirror_0.vout1.n12 VSS 0.65318f $ **FLOATING
C1577 SENSOR.t1 VSS 0.02821f $ **FLOATING
C1578 SENSOR.t0 VSS 0.0262f $ **FLOATING
C1579 SENSOR.n0 VSS 0.06184f $ **FLOATING
C1580 SENSOR.n1 VSS 0.04699f $ **FLOATING
C1581 two_stage_instrumentation_amplifier_0.VP.t2 VSS 8.76296f $ **FLOATING
C1582 two_stage_instrumentation_amplifier_0.VP.t3 VSS 8.25217f $ **FLOATING
C1583 two_stage_instrumentation_amplifier_0.VP.n0 VSS 1.51789f $ **FLOATING
C1584 two_stage_instrumentation_amplifier_0.VP.n1 VSS 24.2773f $ **FLOATING
C1585 two_stage_instrumentation_amplifier_0.VP.t0 VSS 1.076f $ **FLOATING
C1586 two_stage_instrumentation_amplifier_0.VP.t1 VSS 2.03924f $ **FLOATING
C1587 two_stage_instrumentation_amplifier_0.VP.n2 VSS 2.8145f $ **FLOATING
C1588 SEL_SENSOR.n0 VSS 16.525f $ **FLOATING
C1589 SEL_SENSOR.t0 VSS 2.32157f $ **FLOATING
C1590 non_inverting_amplifier_hv_0.ota_hv_slow_gmid_0.vamp.t13 VSS 0.07179f $ **FLOATING
C1591 non_inverting_amplifier_hv_0.ota_hv_slow_gmid_0.vamp.t10 VSS 0.07179f $ **FLOATING
C1592 non_inverting_amplifier_hv_0.ota_hv_slow_gmid_0.vamp.t0 VSS 0.07179f $ **FLOATING
C1593 non_inverting_amplifier_hv_0.ota_hv_slow_gmid_0.vamp.t4 VSS 0.07179f $ **FLOATING
C1594 non_inverting_amplifier_hv_0.ota_hv_slow_gmid_0.vamp.t1 VSS 0.06087f $ **FLOATING
C1595 non_inverting_amplifier_hv_0.ota_hv_slow_gmid_0.vamp.t11 VSS 0.01817f $ **FLOATING
C1596 non_inverting_amplifier_hv_0.ota_hv_slow_gmid_0.vamp.t3 VSS 0.01759f $ **FLOATING
C1597 non_inverting_amplifier_hv_0.ota_hv_slow_gmid_0.vamp.n0 VSS 0.05366f $ **FLOATING
C1598 non_inverting_amplifier_hv_0.ota_hv_slow_gmid_0.vamp.t15 VSS 0.01614f $ **FLOATING
C1599 non_inverting_amplifier_hv_0.ota_hv_slow_gmid_0.vamp.n1 VSS 0.05488f $ **FLOATING
C1600 non_inverting_amplifier_hv_0.ota_hv_slow_gmid_0.vamp.n2 VSS 0.08403f $ **FLOATING
C1601 non_inverting_amplifier_hv_0.ota_hv_slow_gmid_0.vamp.n3 VSS 0.05141f $ **FLOATING
C1602 non_inverting_amplifier_hv_0.ota_hv_slow_gmid_0.vamp.n4 VSS 0.04636f $ **FLOATING
C1603 non_inverting_amplifier_hv_0.ota_hv_slow_gmid_0.vamp.n5 VSS 0.04636f $ **FLOATING
C1604 non_inverting_amplifier_hv_0.ota_hv_slow_gmid_0.vamp.n6 VSS 0.06556f $ **FLOATING
C1605 non_inverting_amplifier_hv_0.ota_hv_slow_gmid_0.vamp.t18 VSS 0.11882f $ **FLOATING
C1606 non_inverting_amplifier_hv_0.ota_hv_slow_gmid_0.vamp.t17 VSS 0.2984f $ **FLOATING
C1607 non_inverting_amplifier_hv_0.ota_hv_slow_gmid_0.vamp.t20 VSS 0.34094f $ **FLOATING
C1608 non_inverting_amplifier_hv_0.ota_hv_slow_gmid_0.vamp.t19 VSS 0.13063f $ **FLOATING
C1609 non_inverting_amplifier_hv_0.ota_hv_slow_gmid_0.vamp.n7 VSS 0.43241f $ **FLOATING
C1610 non_inverting_amplifier_hv_0.ota_hv_slow_gmid_0.vamp.n8 VSS 0.31474f $ **FLOATING
C1611 non_inverting_amplifier_hv_0.ota_hv_slow_gmid_0.vamp.n9 VSS 0.07865f $ **FLOATING
C1612 non_inverting_amplifier_hv_0.ota_hv_slow_gmid_0.ota_hv_slow_gmid_mirror_0.vamp VSS 0.09026f $ **FLOATING
C1613 non_inverting_amplifier_hv_0.ota_hv_slow_gmid_0.vamp.t16 VSS 35.5328f $ **FLOATING
C1614 non_inverting_amplifier_hv_0.ota_hv_slow_gmid_0.vamp.n10 VSS 0.13991f $ **FLOATING
C1615 non_inverting_amplifier_hv_0.ota_hv_slow_gmid_0.vamp.t23 VSS 0.5754f $ **FLOATING
C1616 non_inverting_amplifier_hv_0.ota_hv_slow_gmid_0.vamp.t21 VSS 0.04472f $ **FLOATING
C1617 non_inverting_amplifier_hv_0.ota_hv_slow_gmid_0.vamp.t22 VSS 0.03418f $ **FLOATING
C1618 non_inverting_amplifier_hv_0.ota_hv_slow_gmid_0.vamp.n11 VSS 0.12635f $ **FLOATING
C1619 non_inverting_amplifier_hv_0.ota_hv_slow_gmid_0.ota_hv_slow_gmid_tail_0.vamp VSS 0.07007f $ **FLOATING
C1620 non_inverting_amplifier_hv_0.ota_hv_slow_gmid_0.vamp.n12 VSS 0.1262f $ **FLOATING
C1621 non_inverting_amplifier_hv_0.ota_hv_slow_gmid_0.vamp.t6 VSS 0.07179f $ **FLOATING
C1622 non_inverting_amplifier_hv_0.ota_hv_slow_gmid_0.vamp.t2 VSS 0.07179f $ **FLOATING
C1623 non_inverting_amplifier_hv_0.ota_hv_slow_gmid_0.vamp.t8 VSS 0.07179f $ **FLOATING
C1624 non_inverting_amplifier_hv_0.ota_hv_slow_gmid_0.vamp.t12 VSS 0.06087f $ **FLOATING
C1625 non_inverting_amplifier_hv_0.ota_hv_slow_gmid_0.vamp.t5 VSS 0.01817f $ **FLOATING
C1626 non_inverting_amplifier_hv_0.ota_hv_slow_gmid_0.vamp.t14 VSS 0.01759f $ **FLOATING
C1627 non_inverting_amplifier_hv_0.ota_hv_slow_gmid_0.vamp.n13 VSS 0.05366f $ **FLOATING
C1628 non_inverting_amplifier_hv_0.ota_hv_slow_gmid_0.vamp.t9 VSS 0.01614f $ **FLOATING
C1629 non_inverting_amplifier_hv_0.ota_hv_slow_gmid_0.vamp.n14 VSS 0.05488f $ **FLOATING
C1630 non_inverting_amplifier_hv_0.ota_hv_slow_gmid_0.vamp.n15 VSS 0.08403f $ **FLOATING
C1631 non_inverting_amplifier_hv_0.ota_hv_slow_gmid_0.vamp.n16 VSS 0.05141f $ **FLOATING
C1632 non_inverting_amplifier_hv_0.ota_hv_slow_gmid_0.vamp.t7 VSS 0.07179f $ **FLOATING
C1633 non_inverting_amplifier_hv_0.ota_hv_slow_gmid_0.vamp.n17 VSS 0.04636f $ **FLOATING
C1634 non_inverting_amplifier_hv_0.ota_hv_slow_gmid_0.vamp.n18 VSS 0.04636f $ **FLOATING
C1635 non_inverting_amplifier_hv_0.ota_hv_slow_gmid_0.vamp.n19 VSS 0.13029f $ **FLOATING
C1636 non_inverting_amplifier_hv_0.ota_hv_slow_gmid_0.vamp.t24 VSS 0.52466f $ **FLOATING
C1637 non_inverting_amplifier_hv_0.ota_hv_slow_gmid_0.vamp.n20 VSS 0.12709f $ **FLOATING
C1638 non_inverting_amplifier_hv_0.ota_hv_slow_gmid_0.vamp.n21 VSS 0.07685f $ **FLOATING
C1639 non_inverting_amplifier_hv_0.ota_hv_slow_gmid_0.vamp.n22 VSS 0.05996f $ **FLOATING
C1640 non_inverting_amplifier_hv_0.ota_hv_slow_gmid_0.ota_hv_slow_gmid_buffer_0.vamp VSS 0.08793f $ **FLOATING
C1641 non_inverting_amplifier_hv_0.ota_hv_slow_gmid_0.en_n.t1 VSS 0.07285f $ **FLOATING
C1642 non_inverting_amplifier_hv_0.ota_hv_slow_gmid_0.en_n.t7 VSS 0.61208f $ **FLOATING
C1643 non_inverting_amplifier_hv_0.ota_hv_slow_gmid_0.en_n.t2 VSS 2.30814f $ **FLOATING
C1644 non_inverting_amplifier_hv_0.ota_hv_slow_gmid_0.en_n.n0 VSS 0.33018f $ **FLOATING
C1645 non_inverting_amplifier_hv_0.ota_hv_slow_gmid_0.en_n.n1 VSS 0.11928f $ **FLOATING
C1646 non_inverting_amplifier_hv_0.ota_hv_slow_gmid_0.ota_hv_slow_gmid_ctrl_inv_1.Y VSS 0.01304f $ **FLOATING
C1647 non_inverting_amplifier_hv_0.ota_hv_slow_gmid_0.en_n.t6 VSS 0.43942f $ **FLOATING
C1648 non_inverting_amplifier_hv_0.ota_hv_slow_gmid_0.ota_hv_slow_gmid_ctrl_inv_0.A VSS 0.06652f $ **FLOATING
C1649 non_inverting_amplifier_hv_0.ota_hv_slow_gmid_0.en_n.t4 VSS 2.10154f $ **FLOATING
C1650 non_inverting_amplifier_hv_0.ota_hv_slow_gmid_0.en_n.t8 VSS 0.26508f $ **FLOATING
C1651 non_inverting_amplifier_hv_0.ota_hv_slow_gmid_0.en_n.n2 VSS 0.09913f $ **FLOATING
C1652 non_inverting_amplifier_hv_0.ota_hv_slow_gmid_0.en_n.t5 VSS 0.09496f $ **FLOATING
C1653 non_inverting_amplifier_hv_0.ota_hv_slow_gmid_0.en_n.t3 VSS 0.40396f $ **FLOATING
C1654 non_inverting_amplifier_hv_0.ota_hv_slow_gmid_0.en_n.n3 VSS 0.05387f $ **FLOATING
C1655 non_inverting_amplifier_hv_0.ota_hv_slow_gmid_0.en_n.n4 VSS 0.37035f $ **FLOATING
C1656 non_inverting_amplifier_hv_0.ota_hv_slow_gmid_0.en_n.n5 VSS 0.31237f $ **FLOATING
C1657 non_inverting_amplifier_hv_0.ota_hv_slow_gmid_0.en_n.t0 VSS 0.14077f $ **FLOATING
C1658 non_inverting_amplifier_hv_0.ota_hv_slow_gmid_0.en_n.n6 VSS 0.29646f $ **FLOATING
C1659 two_stage_instrumentation_amplifier_0.ota_slow_gmid_0.en.t1 VSS 0.23339f $ **FLOATING
C1660 two_stage_instrumentation_amplifier_0.ota_slow_gmid_0.en.t0 VSS 0.23122f $ **FLOATING
C1661 two_stage_instrumentation_amplifier_0.ota_slow_gmid_0.en.n0 VSS 0.23792f $ **FLOATING
C1662 two_stage_instrumentation_amplifier_0.ota_slow_gmid_0.en.t3 VSS 0.89302f $ **FLOATING
C1663 two_stage_instrumentation_amplifier_0.ota_slow_gmid_0.en.t2 VSS 0.843f $ **FLOATING
C1664 two_stage_instrumentation_amplifier_0.ota_slow_gmid_0.en.n1 VSS 0.84014f $ **FLOATING
C1665 two_stage_instrumentation_amplifier_0.ota_slow_gmid_0.ota_slow_gmid_ctrl_buff_0.ota_slow_gmid_ctrl_inv_0.y VSS 0.22132f $ **FLOATING
C1666 ref_selector_0.I1MA.t13 VSS 0.20337f $ **FLOATING
C1667 ref_selector_0.I1MA.n0 VSS 0.30516f $ **FLOATING
C1668 ref_selector_0.I1MA.n1 VSS 0.09641f $ **FLOATING
C1669 ref_selector_0.I1MA.n2 VSS 0.11537f $ **FLOATING
C1670 ref_selector_0.I1MA.n3 VSS 0.09641f $ **FLOATING
C1671 ref_selector_0.I1MA.t0 VSS 0.20505f $ **FLOATING
C1672 ref_selector_0.I1MA.n4 VSS 0.26372f $ **FLOATING
C1673 ref_selector_0.I1MA.t1 VSS 0.047f $ **FLOATING
C1674 ref_selector_0.I1MA.n5 VSS 0.03943f $ **FLOATING
C1675 ref_selector_0.I1MA.t11 VSS 0.04692f $ **FLOATING
C1676 ref_selector_0.I1MA.t7 VSS 0.04692f $ **FLOATING
C1677 ref_selector_0.I1MA.t9 VSS 0.04714f $ **FLOATING
C1678 ref_selector_0.I1MA.t4 VSS 0.05084f $ **FLOATING
C1679 ref_selector_0.I1MA.t12 VSS 0.05089f $ **FLOATING
C1680 ref_selector_0.I1MA.n6 VSS 0.11017f $ **FLOATING
C1681 ref_selector_0.I1MA.t8 VSS 0.047f $ **FLOATING
C1682 ref_selector_0.I1MA.t10 VSS 0.04692f $ **FLOATING
C1683 ref_selector_0.I1MA.n7 VSS 0.02586f $ **FLOATING
C1684 ref_selector_0.I1MA.t6 VSS 0.04692f $ **FLOATING
C1685 ref_selector_0.I1MA.n8 VSS 0.02605f $ **FLOATING
C1686 ref_selector_0.I1MA.n9 VSS 0.03467f $ **FLOATING
C1687 ref_selector_0.I1MA.n10 VSS 0.40579f $ **FLOATING
C1688 ref_selector_0.I1MA.n11 VSS 0.03768f $ **FLOATING
C1689 ref_selector_0.I1MA.n12 VSS 0.02532f $ **FLOATING
C1690 ref_selector_0.I1MA.n13 VSS 0.02586f $ **FLOATING
C1691 ref_selector_0.I1MA.t2 VSS 0.047f $ **FLOATING
C1692 ref_selector_0.I1MA.n14 VSS 0.04052f $ **FLOATING
C1693 ref_selector_0.I1MA.t5 VSS 0.0424f $ **FLOATING
C1694 ref_selector_0.I1MA.t3 VSS 0.04239f $ **FLOATING
C1695 ref_selector_0.I1MA.n15 VSS 0.16101f $ **FLOATING
C1696 ref_selector_0.I1MA.n16 VSS 0.39195f $ **FLOATING
C1697 ref_selector_0.I1MA.n17 VSS 1.80236f $ **FLOATING
C1698 ref_selector_0.I1MA.n18 VSS 1.50654f $ **FLOATING
C1699 ref_selector_0.I1MA.n19 VSS 0.57964f $ **FLOATING
C1700 ref_selector_0.I1MA.n20 VSS 0.11477f $ **FLOATING
C1701 ref_selector_0.I1MA.n21 VSS 0.09641f $ **FLOATING
C1702 ref_selector_0.I1MA.n22 VSS 0.09641f $ **FLOATING
C1703 ref_selector_0.I1MA.n23 VSS 0.05829f $ **FLOATING
C1704 ref_selector_0.I1MA.n24 VSS 0.11537f $ **FLOATING
C1705 ref_selector_0.I1MA.n25 VSS 0.11537f $ **FLOATING
C1706 ref_selector_0.I1MA.n26 VSS 0.09641f $ **FLOATING
C1707 ref_selector_0.I1MA.n27 VSS 0.09641f $ **FLOATING
C1708 ref_selector_0.I1MA.n28 VSS 0.09641f $ **FLOATING
C1709 ref_selector_0.I1MA.n29 VSS 0.11537f $ **FLOATING
C1710 ref_selector_0.I1MA.n30 VSS 0.11537f $ **FLOATING
C1711 ref_selector_0.I1MA.n31 VSS 0.07631f $ **FLOATING
C1712 ref_selector_0.I1MA.n32 VSS 0.26252f $ **FLOATING
C1713 ref_selector_0.I1MA.n33 VSS 0.08797f $ **FLOATING
C1714 ref_selector_0.ref_selector_r_96_0.vcal.t9 VSS 0.02682f $ **FLOATING
C1715 ref_selector_0.ref_selector_r_96_0.vcal.t8 VSS 0.02851f $ **FLOATING
C1716 ref_selector_0.ref_selector_r_96_0.vcal.n0 VSS 0.05028f $ **FLOATING
C1717 ref_selector_0.ref_selector_r_96_0.vcal.n5 VSS 0.01081f $ **FLOATING
C1718 ref_selector_0.ref_selector_r_96_0.vcal.n6 VSS 0.01166f $ **FLOATING
C1719 ref_selector_0.ref_selector_r_96_0.vcal.n8 VSS 0.01442f $ **FLOATING
C1720 ref_selector_0.ref_selector_r_96_0.vcal.n9 VSS 0.01202f $ **FLOATING
C1721 ref_selector_0.ref_selector_r_96_0.vcal.n10 VSS 0.01068f $ **FLOATING
C1722 ref_selector_0.ref_selector_r_96_0.vcal.n12 VSS 0.051f $ **FLOATING
C1723 ref_selector_0.ref_selector_r_96_0.vcal.n13 VSS 0.01571f $ **FLOATING
C1724 ref_selector_0.ref_selector_r_96_0.vcal.n14 VSS 0.01043f $ **FLOATING
C1725 ref_selector_0.ref_selector_r_96_0.vcal.t10 VSS 2.68585f $ **FLOATING
C1726 ref_selector_0.ref_selector_r_96_0.vcal.n15 VSS 0.0988f $ **FLOATING
C1727 SEL_CAL.n0 VSS 21.5749f $ **FLOATING
C1728 SEL_CAL.t0 VSS 3.91488f $ **FLOATING
C1729 VBIAS.t33 VSS 3.88605f $ **FLOATING
C1730 VBIAS.n0 VSS 1.04947f $ **FLOATING
C1731 VBIAS.t31 VSS 0.474f $ **FLOATING
C1732 VBIAS.t29 VSS 0.45812f $ **FLOATING
C1733 VBIAS.t28 VSS 0.51689f $ **FLOATING
C1734 VBIAS.t24 VSS 0.50101f $ **FLOATING
C1735 VBIAS.t30 VSS 0.51689f $ **FLOATING
C1736 VBIAS.t27 VSS 0.50101f $ **FLOATING
C1737 VBIAS.t26 VSS 0.51689f $ **FLOATING
C1738 VBIAS.t25 VSS 0.50101f $ **FLOATING
C1739 VBIAS.n1 VSS 0.62045f $ **FLOATING
C1740 VBIAS.n2 VSS 0.69295f $ **FLOATING
C1741 VBIAS.n3 VSS 0.69295f $ **FLOATING
C1742 VBIAS.n4 VSS 0.72832f $ **FLOATING
C1743 VBIAS.n5 VSS 1.75139f $ **FLOATING
C1744 VBIAS.t34 VSS 3.87275f $ **FLOATING
C1745 VBIAS.t7 VSS 0.29319f $ **FLOATING
C1746 VBIAS.t6 VSS 0.29319f $ **FLOATING
C1747 VBIAS.t9 VSS 0.29319f $ **FLOATING
C1748 VBIAS.t8 VSS 0.29319f $ **FLOATING
C1749 VBIAS.t11 VSS 0.28455f $ **FLOATING
C1750 VBIAS.n6 VSS 0.44199f $ **FLOATING
C1751 VBIAS.n7 VSS 0.25761f $ **FLOATING
C1752 VBIAS.n8 VSS 0.25761f $ **FLOATING
C1753 VBIAS.n9 VSS 0.25251f $ **FLOATING
C1754 VBIAS.t10 VSS 0.26405f $ **FLOATING
C1755 VBIAS.n10 VSS 0.83117f $ **FLOATING
C1756 VBIAS.t2 VSS 0.26405f $ **FLOATING
C1757 VBIAS.t0 VSS 0.29319f $ **FLOATING
C1758 VBIAS.t3 VSS 0.29319f $ **FLOATING
C1759 VBIAS.t1 VSS 0.29319f $ **FLOATING
C1760 VBIAS.t4 VSS 0.29319f $ **FLOATING
C1761 VBIAS.t5 VSS 0.28455f $ **FLOATING
C1762 VBIAS.n11 VSS 0.44199f $ **FLOATING
C1763 VBIAS.n12 VSS 0.25761f $ **FLOATING
C1764 VBIAS.n13 VSS 0.25761f $ **FLOATING
C1765 VBIAS.n14 VSS 0.25251f $ **FLOATING
C1766 VBIAS.n15 VSS 0.2616f $ **FLOATING
C1767 VBIAS.n16 VSS 2.89369f $ **FLOATING
C1768 VBIAS.t32 VSS 3.88605f $ **FLOATING
C1769 VBIAS.n17 VSS 0.85462f $ **FLOATING
C1770 VBIAS.n18 VSS 9.13423f $ **FLOATING
C1771 VBIAS.n19 VSS 17.8494f $ **FLOATING
C1772 VBIAS.t14 VSS 0.26405f $ **FLOATING
C1773 VBIAS.t12 VSS 0.29319f $ **FLOATING
C1774 VBIAS.t15 VSS 0.29319f $ **FLOATING
C1775 VBIAS.t13 VSS 0.29319f $ **FLOATING
C1776 VBIAS.t17 VSS 0.29319f $ **FLOATING
C1777 VBIAS.t16 VSS 0.28455f $ **FLOATING
C1778 VBIAS.n20 VSS 0.44199f $ **FLOATING
C1779 VBIAS.n21 VSS 0.25761f $ **FLOATING
C1780 VBIAS.n22 VSS 0.25761f $ **FLOATING
C1781 VBIAS.n23 VSS 0.25251f $ **FLOATING
C1782 VBIAS.n24 VSS 0.83117f $ **FLOATING
C1783 VBIAS.t23 VSS 0.29319f $ **FLOATING
C1784 VBIAS.t19 VSS 0.29319f $ **FLOATING
C1785 VBIAS.t18 VSS 0.29319f $ **FLOATING
C1786 VBIAS.t21 VSS 0.29319f $ **FLOATING
C1787 VBIAS.t20 VSS 0.28455f $ **FLOATING
C1788 VBIAS.n25 VSS 0.44199f $ **FLOATING
C1789 VBIAS.n26 VSS 0.25761f $ **FLOATING
C1790 VBIAS.n27 VSS 0.25761f $ **FLOATING
C1791 VBIAS.n28 VSS 0.25251f $ **FLOATING
C1792 VBIAS.t22 VSS 0.26405f $ **FLOATING
C1793 VBIAS.n29 VSS 0.2616f $ **FLOATING
C1794 VBIAS.n30 VSS 2.89369f $ **FLOATING
C1795 VBIAS.n31 VSS 2.58947f $ **FLOATING
C1796 VBIAS.n32 VSS 0.85499f $ **FLOATING
C1797 non_inverting_amplifier_hv_0.ota_hv_slow_gmid_0.vref.t1 VSS 0.17544f $ **FLOATING
C1798 non_inverting_amplifier_hv_0.ota_hv_slow_gmid_0.vref.t0 VSS 0.05515f $ **FLOATING
C1799 non_inverting_amplifier_hv_0.ota_hv_slow_gmid_0.vref.n0 VSS 0.13299f $ **FLOATING
C1800 non_inverting_amplifier_hv_0.ota_hv_slow_gmid_0.vref.t4 VSS 0.10497f $ **FLOATING
C1801 non_inverting_amplifier_hv_0.ota_hv_slow_gmid_0.vref.t2 VSS 12.7937f $ **FLOATING
C1802 non_inverting_amplifier_hv_0.ota_hv_slow_gmid_0.vref.t3 VSS 0.15991f $ **FLOATING
C1803 non_inverting_amplifier_hv_0.ota_hv_slow_gmid_0.vref.n1 VSS 0.65923f $ **FLOATING
C1804 non_inverting_amplifier_hv_0.ota_hv_slow_gmid_0.vref.n2 VSS 0.16973f $ **FLOATING
C1805 non_inverting_amplifier_hv_0.ota_hv_slow_gmid_0.ota_hv_slow_gmid_mirror_0.vref VSS 0.38056f $ **FLOATING
C1806 non_inverting_amplifier_hv_0.ota_hv_slow_gmid_0.ota_hv_slow_gmid_pairs_0.vref VSS 0.26829f $ **FLOATING
C1807 two_stage_instrumentation_amplifier_0.ota_slow_gmid_1.vout1.t13 VSS 0.08898f $ **FLOATING
C1808 two_stage_instrumentation_amplifier_0.ota_slow_gmid_1.vout1.t12 VSS 0.06958f $ **FLOATING
C1809 two_stage_instrumentation_amplifier_0.ota_slow_gmid_1.vout1.n0 VSS 0.1347f $ **FLOATING
C1810 two_stage_instrumentation_amplifier_0.ota_slow_gmid_1.vout1.t11 VSS 0.08625f $ **FLOATING
C1811 two_stage_instrumentation_amplifier_0.ota_slow_gmid_1.vout1.t7 VSS 0.09588f $ **FLOATING
C1812 two_stage_instrumentation_amplifier_0.ota_slow_gmid_1.vout1.t2 VSS 0.09588f $ **FLOATING
C1813 two_stage_instrumentation_amplifier_0.ota_slow_gmid_1.vout1.t8 VSS 0.09588f $ **FLOATING
C1814 two_stage_instrumentation_amplifier_0.ota_slow_gmid_1.vout1.t5 VSS 0.09248f $ **FLOATING
C1815 two_stage_instrumentation_amplifier_0.ota_slow_gmid_1.vout1.t3 VSS 0.09589f $ **FLOATING
C1816 two_stage_instrumentation_amplifier_0.ota_slow_gmid_1.vout1.n1 VSS 0.13142f $ **FLOATING
C1817 two_stage_instrumentation_amplifier_0.ota_slow_gmid_1.vout1.n2 VSS 0.07596f $ **FLOATING
C1818 two_stage_instrumentation_amplifier_0.ota_slow_gmid_1.vout1.n3 VSS 0.07596f $ **FLOATING
C1819 two_stage_instrumentation_amplifier_0.ota_slow_gmid_1.vout1.n4 VSS 0.07451f $ **FLOATING
C1820 two_stage_instrumentation_amplifier_0.ota_slow_gmid_1.vout1.n5 VSS 0.07129f $ **FLOATING
C1821 two_stage_instrumentation_amplifier_0.ota_slow_gmid_1.vout1.t17 VSS 0.03478f $ **FLOATING
C1822 two_stage_instrumentation_amplifier_0.ota_slow_gmid_1.vout1.t16 VSS 0.03512f $ **FLOATING
C1823 two_stage_instrumentation_amplifier_0.ota_slow_gmid_1.vout1.t14 VSS 0.19884f $ **FLOATING
C1824 two_stage_instrumentation_amplifier_0.ota_slow_gmid_1.vout1.t15 VSS 0.03512f $ **FLOATING
C1825 two_stage_instrumentation_amplifier_0.ota_slow_gmid_1.vout1.n6 VSS 0.68438f $ **FLOATING
C1826 two_stage_instrumentation_amplifier_0.ota_slow_gmid_1.vout1.n7 VSS 0.49102f $ **FLOATING
C1827 two_stage_instrumentation_amplifier_0.ota_slow_gmid_1.vout1.n8 VSS 0.35304f $ **FLOATING
C1828 two_stage_instrumentation_amplifier_0.ota_slow_gmid_1.vout1.n9 VSS 0.30832f $ **FLOATING
C1829 two_stage_instrumentation_amplifier_0.ota_slow_gmid_1.vout1.n10 VSS 0.43028f $ **FLOATING
C1830 two_stage_instrumentation_amplifier_0.ota_slow_gmid_1.vout1.t9 VSS 0.09588f $ **FLOATING
C1831 two_stage_instrumentation_amplifier_0.ota_slow_gmid_1.vout1.t0 VSS 0.09588f $ **FLOATING
C1832 two_stage_instrumentation_amplifier_0.ota_slow_gmid_1.vout1.t1 VSS 0.09588f $ **FLOATING
C1833 two_stage_instrumentation_amplifier_0.ota_slow_gmid_1.vout1.t10 VSS 0.09588f $ **FLOATING
C1834 two_stage_instrumentation_amplifier_0.ota_slow_gmid_1.vout1.t6 VSS 0.09248f $ **FLOATING
C1835 two_stage_instrumentation_amplifier_0.ota_slow_gmid_1.vout1.n11 VSS 0.13143f $ **FLOATING
C1836 two_stage_instrumentation_amplifier_0.ota_slow_gmid_1.vout1.n12 VSS 0.07596f $ **FLOATING
C1837 two_stage_instrumentation_amplifier_0.ota_slow_gmid_1.vout1.n13 VSS 0.07596f $ **FLOATING
C1838 two_stage_instrumentation_amplifier_0.ota_slow_gmid_1.vout1.n14 VSS 0.07451f $ **FLOATING
C1839 two_stage_instrumentation_amplifier_0.ota_slow_gmid_1.vout1.t4 VSS 0.08625f $ **FLOATING
C1840 two_stage_instrumentation_amplifier_0.ota_slow_gmid_1.vout1.n15 VSS 0.06014f $ **FLOATING
C1841 two_stage_instrumentation_amplifier_0.ota_slow_gmid_1.vout1.n16 VSS 0.57179f $ **FLOATING
C1842 two_stage_instrumentation_amplifier_0.ota_slow_gmid_1.vout1.t19 VSS 0.10614f $ **FLOATING
C1843 two_stage_instrumentation_amplifier_0.ota_slow_gmid_1.vout1.n17 VSS 0.65508f $ **FLOATING
C1844 two_stage_instrumentation_amplifier_0.ota_slow_gmid_1.vout1.t18 VSS 0.2004f $ **FLOATING
C1845 two_stage_instrumentation_amplifier_0.ota_slow_gmid_1.vout1.n18 VSS 0.32017f $ **FLOATING
C1846 current_source_1mA_0.ota_med_hv_gmid_0.ota_med_hv_gmid_mirror_0.Iref.t4 VSS 0.13545f $ **FLOATING
C1847 current_source_1mA_0.ota_med_hv_gmid_0.ota_med_hv_gmid_mirror_0.Iref.t3 VSS 0.29059f $ **FLOATING
C1848 current_source_1mA_0.ota_med_hv_gmid_0.ota_med_hv_gmid_mirror_0.Iref.n0 VSS 0.17056f $ **FLOATING
C1849 current_source_1mA_0.ota_med_hv_gmid_0.ota_med_hv_gmid_mirror_0.Iref.t0 VSS 1.64166f $ **FLOATING
C1850 current_source_1mA_0.ota_med_hv_gmid_0.ota_med_hv_gmid_mirror_0.Iref.t2 VSS 0.07101f $ **FLOATING
C1851 current_source_1mA_0.ota_med_hv_gmid_0.ota_med_hv_gmid_mirror_0.Iref.n1 VSS 0.08591f $ **FLOATING
C1852 current_source_1mA_0.ota_med_hv_gmid_0.ota_med_hv_gmid_mirror_0.Iref.t1 VSS 0.06425f $ **FLOATING
C1853 current_source_1mA_0.ota_med_hv_gmid_0.ota_med_hv_gmid_mirror_0.Iref.n2 VSS 0.04018f $ **FLOATING
C1854 current_source_1mA_0.current_source_1mA_2_stage_0.vcp.t2 VSS 0.04218f $ **FLOATING
C1855 current_source_1mA_0.current_source_1mA_2_stage_0.vcp.t7 VSS 0.48596f $ **FLOATING
C1856 current_source_1mA_0.current_source_1mA_2_stage_0.vcp.t6 VSS 0.48667f $ **FLOATING
C1857 current_source_1mA_0.current_source_1mA_2_stage_0.vcp.n0 VSS 0.19029f $ **FLOATING
C1858 current_source_1mA_0.current_source_1mA_2_stage_0.vcp.n1 VSS 0.112f $ **FLOATING
C1859 current_source_1mA_0.current_source_1mA_2_stage_0.vcp.t5 VSS 0.04332f $ **FLOATING
C1860 current_source_1mA_0.current_source_1mA_2_stage_0.vcp.t4 VSS 0.04332f $ **FLOATING
C1861 current_source_1mA_0.current_source_1mA_2_stage_0.vcp.t3 VSS 0.04332f $ **FLOATING
C1862 current_source_1mA_0.current_source_1mA_2_stage_0.vcp.t1 VSS 0.04813f $ **FLOATING
C1863 current_source_1mA_0.current_source_1mA_2_stage_0.vcp.n2 VSS 0.13018f $ **FLOATING
C1864 current_source_1mA_0.current_source_1mA_2_stage_0.vcp.n3 VSS 0.08098f $ **FLOATING
C1865 current_source_1mA_0.current_source_1mA_2_stage_0.vcp.n4 VSS 0.08714f $ **FLOATING
C1866 current_source_1mA_0.current_source_1mA_2_stage_0.vcp.t0 VSS 0.04282f $ **FLOATING
C1867 current_source_1mA_0.current_source_1mA_2_stage_0.vcp.n5 VSS 0.05679f $ **FLOATING
C1868 current_source_1mA_0.current_source_1mA_2_stage_0.vcp.n6 VSS 0.27411f $ **FLOATING
C1869 VDD.n0 VSS 0.0464f $ **FLOATING
C1870 VDD.t101 VSS 0.01559f $ **FLOATING
C1871 VDD.t98 VSS 0.01918f $ **FLOATING
C1872 VDD.t100 VSS 0.01834f $ **FLOATING
C1873 VDD.n2 VSS 0.03855f $ **FLOATING
C1874 VDD.n3 VSS 0.01087f $ **FLOATING
C1875 VDD.n4 VSS 0.01607f $ **FLOATING
C1876 VDD.n5 VSS 0.01244f $ **FLOATING
C1877 VDD.n6 VSS 0.02801f $ **FLOATING
C1878 VDD.n7 VSS 0.0159f $ **FLOATING
C1879 VDD.n8 VSS 0.0159f $ **FLOATING
C1880 VDD.t144 VSS 0.01392f $ **FLOATING
C1881 VDD.n9 VSS 0.01545f $ **FLOATING
C1882 VDD.n10 VSS 0.03927f $ **FLOATING
C1883 VDD.t145 VSS 0.01392f $ **FLOATING
C1884 VDD.n11 VSS 0.01545f $ **FLOATING
C1885 VDD.n12 VSS 0.02067f $ **FLOATING
C1886 VDD.n13 VSS 0.01457f $ **FLOATING
C1887 VDD.n14 VSS 0.0159f $ **FLOATING
C1888 VDD.n16 VSS 0.02045f $ **FLOATING
C1889 VDD.t129 VSS 0.01392f $ **FLOATING
C1890 VDD.n17 VSS 0.02847f $ **FLOATING
C1891 VDD.t130 VSS 0.01392f $ **FLOATING
C1892 VDD.n18 VSS 0.03302f $ **FLOATING
C1893 VDD.n19 VSS 0.01271f $ **FLOATING
C1894 VDD.n20 VSS 0.02806f $ **FLOATING
C1895 VDD.t115 VSS 0.08268f $ **FLOATING
C1896 VDD.n21 VSS 0.02856f $ **FLOATING
C1897 VDD.n22 VSS 0.02204f $ **FLOATING
C1898 VDD.n23 VSS 0.0159f $ **FLOATING
C1899 VDD.n24 VSS 0.0159f $ **FLOATING
C1900 VDD.t116 VSS 0.01392f $ **FLOATING
C1901 VDD.n25 VSS 0.01545f $ **FLOATING
C1902 VDD.n26 VSS 0.01545f $ **FLOATING
C1903 VDD.t117 VSS 0.01392f $ **FLOATING
C1904 VDD.n27 VSS 0.05853f $ **FLOATING
C1905 VDD.n28 VSS 0.0174f $ **FLOATING
C1906 VDD.n29 VSS 0.0103f $ **FLOATING
C1907 VDD.n30 VSS 0.03597f $ **FLOATING
C1908 VDD.n31 VSS 0.0159f $ **FLOATING
C1909 VDD.n32 VSS 0.0159f $ **FLOATING
C1910 VDD.t126 VSS 0.01392f $ **FLOATING
C1911 VDD.n33 VSS 0.01545f $ **FLOATING
C1912 VDD.n34 VSS 0.03958f $ **FLOATING
C1913 VDD.t127 VSS 0.01392f $ **FLOATING
C1914 VDD.n35 VSS 0.01545f $ **FLOATING
C1915 VDD.n36 VSS 0.02204f $ **FLOATING
C1916 VDD.n37 VSS 0.01271f $ **FLOATING
C1917 VDD.n38 VSS 0.0159f $ **FLOATING
C1918 VDD.t147 VSS 0.01392f $ **FLOATING
C1919 VDD.n39 VSS 0.02045f $ **FLOATING
C1920 VDD.n41 VSS 0.03302f $ **FLOATING
C1921 VDD.t148 VSS 0.01392f $ **FLOATING
C1922 VDD.n42 VSS 0.02847f $ **FLOATING
C1923 VDD.n43 VSS 0.01457f $ **FLOATING
C1924 VDD.n44 VSS 0.02856f $ **FLOATING
C1925 VDD.t125 VSS 0.08268f $ **FLOATING
C1926 VDD.n45 VSS 0.02806f $ **FLOATING
C1927 VDD.n46 VSS 0.02067f $ **FLOATING
C1928 VDD.n47 VSS 0.0159f $ **FLOATING
C1929 VDD.n48 VSS 0.0159f $ **FLOATING
C1930 VDD.t162 VSS 0.01392f $ **FLOATING
C1931 VDD.n49 VSS 0.01545f $ **FLOATING
C1932 VDD.n50 VSS 0.01545f $ **FLOATING
C1933 VDD.t163 VSS 0.01392f $ **FLOATING
C1934 VDD.n51 VSS 0.11215f $ **FLOATING
C1935 VDD.n52 VSS 0.01201f $ **FLOATING
C1936 VDD.t93 VSS 0.01559f $ **FLOATING
C1937 VDD.t92 VSS 0.01918f $ **FLOATING
C1938 VDD.t94 VSS 0.01834f $ **FLOATING
C1939 VDD.n53 VSS 0.03855f $ **FLOATING
C1940 VDD.n54 VSS 0.01087f $ **FLOATING
C1941 VDD.n55 VSS 0.04773f $ **FLOATING
C1942 VDD.t104 VSS 0.01405f $ **FLOATING
C1943 VDD.t82 VSS 0.03853f $ **FLOATING
C1944 VDD.t81 VSS 1.06406f $ **FLOATING
C1945 VDD.n56 VSS 0.08581f $ **FLOATING
C1946 VDD.t83 VSS 0.04797f $ **FLOATING
C1947 VDD.n57 VSS 0.11732f $ **FLOATING
C1948 VDD.n58 VSS 0.02726f $ **FLOATING
C1949 VDD.n59 VSS 0.0242f $ **FLOATING
C1950 VDD.n60 VSS 0.02448f $ **FLOATING
C1951 VDD.n61 VSS 0.03184f $ **FLOATING
C1952 VDD.n62 VSS 0.04547f $ **FLOATING
C1953 VDD.n63 VSS 0.06031f $ **FLOATING
C1954 VDD.n65 VSS 0.04544f $ **FLOATING
C1955 VDD.n66 VSS 0.06644f $ **FLOATING
C1956 VDD.n68 VSS 0.05397f $ **FLOATING
C1957 VDD.n70 VSS 0.02801f $ **FLOATING
C1958 VDD.n71 VSS 0.0159f $ **FLOATING
C1959 VDD.n72 VSS 0.0159f $ **FLOATING
C1960 VDD.t111 VSS 0.01392f $ **FLOATING
C1961 VDD.n73 VSS 0.01545f $ **FLOATING
C1962 VDD.n74 VSS 0.03927f $ **FLOATING
C1963 VDD.t112 VSS 0.01392f $ **FLOATING
C1964 VDD.n75 VSS 0.01545f $ **FLOATING
C1965 VDD.n76 VSS 0.02067f $ **FLOATING
C1966 VDD.n77 VSS 0.01457f $ **FLOATING
C1967 VDD.n78 VSS 0.0159f $ **FLOATING
C1968 VDD.n80 VSS 0.02045f $ **FLOATING
C1969 VDD.t210 VSS 0.01392f $ **FLOATING
C1970 VDD.n81 VSS 0.02847f $ **FLOATING
C1971 VDD.t211 VSS 0.01392f $ **FLOATING
C1972 VDD.n82 VSS 0.03302f $ **FLOATING
C1973 VDD.n83 VSS 0.01271f $ **FLOATING
C1974 VDD.n84 VSS 0.02806f $ **FLOATING
C1975 VDD.t110 VSS 0.08268f $ **FLOATING
C1976 VDD.n85 VSS 0.02856f $ **FLOATING
C1977 VDD.n86 VSS 0.01227f $ **FLOATING
C1978 VDD.n87 VSS 0.0159f $ **FLOATING
C1979 VDD.n88 VSS 0.0159f $ **FLOATING
C1980 VDD.t198 VSS 0.01392f $ **FLOATING
C1981 VDD.n89 VSS 0.01545f $ **FLOATING
C1982 VDD.n90 VSS 0.06367f $ **FLOATING
C1983 VDD.n91 VSS 0.04558f $ **FLOATING
C1984 VDD.n92 VSS 0.01477f $ **FLOATING
C1985 VDD.t199 VSS 0.01392f $ **FLOATING
C1986 VDD.n93 VSS 0.05853f $ **FLOATING
C1987 VDD.n94 VSS 0.0174f $ **FLOATING
C1988 VDD.n95 VSS 0.01027f $ **FLOATING
C1989 VDD.n96 VSS 0.03597f $ **FLOATING
C1990 VDD.n97 VSS 0.0159f $ **FLOATING
C1991 VDD.n98 VSS 0.0159f $ **FLOATING
C1992 VDD.t180 VSS 0.01392f $ **FLOATING
C1993 VDD.n99 VSS 0.01545f $ **FLOATING
C1994 VDD.n100 VSS 0.03958f $ **FLOATING
C1995 VDD.t181 VSS 0.01392f $ **FLOATING
C1996 VDD.n101 VSS 0.01545f $ **FLOATING
C1997 VDD.n102 VSS 0.02204f $ **FLOATING
C1998 VDD.n104 VSS 0.03225f $ **FLOATING
C1999 VDD.n105 VSS 0.02809f $ **FLOATING
C2000 VDD.n106 VSS 0.01431f $ **FLOATING
C2001 VDD.n107 VSS 0.0159f $ **FLOATING
C2002 VDD.t192 VSS 0.01392f $ **FLOATING
C2003 VDD.n108 VSS 0.02045f $ **FLOATING
C2004 VDD.n110 VSS 0.01999f $ **FLOATING
C2005 VDD.t193 VSS 0.01392f $ **FLOATING
C2006 VDD.n111 VSS 0.02847f $ **FLOATING
C2007 VDD.n112 VSS 0.01457f $ **FLOATING
C2008 VDD.n113 VSS 0.01545f $ **FLOATING
C2009 VDD.t179 VSS 0.08268f $ **FLOATING
C2010 VDD.n114 VSS 0.02806f $ **FLOATING
C2011 VDD.n115 VSS 0.02067f $ **FLOATING
C2012 VDD.n116 VSS 0.0159f $ **FLOATING
C2013 VDD.n117 VSS 0.0159f $ **FLOATING
C2014 VDD.t213 VSS 0.01392f $ **FLOATING
C2015 VDD.n118 VSS 0.01545f $ **FLOATING
C2016 VDD.n119 VSS 0.01545f $ **FLOATING
C2017 VDD.t214 VSS 0.01392f $ **FLOATING
C2018 VDD.n120 VSS 0.03927f $ **FLOATING
C2019 VDD.n121 VSS 0.02801f $ **FLOATING
C2020 VDD.n122 VSS 0.0464f $ **FLOATING
C2021 VDD.t51 VSS 0.01405f $ **FLOATING
C2022 VDD.t226 VSS 0.06099f $ **FLOATING
C2023 VDD.t225 VSS 0.0678f $ **FLOATING
C2024 VDD.t224 VSS 1.10035f $ **FLOATING
C2025 VDD.n123 VSS 0.19051f $ **FLOATING
C2026 VDD.n124 VSS 0.06044f $ **FLOATING
C2027 VDD.n125 VSS 0.13679f $ **FLOATING
C2028 VDD.n126 VSS 0.12453f $ **FLOATING
C2029 VDD.n127 VSS 0.06031f $ **FLOATING
C2030 VDD.n129 VSS 0.16271f $ **FLOATING
C2031 VDD.n130 VSS 0.11675f $ **FLOATING
C2032 VDD.n132 VSS 0.15102f $ **FLOATING
C2033 VDD.n133 VSS 0.11022f $ **FLOATING
C2034 VDD.n138 VSS 0.02038f $ **FLOATING
C2035 VDD.n139 VSS 0.12893f $ **FLOATING
C2036 VDD.t48 VSS 0.33316f $ **FLOATING
C2037 VDD.n141 VSS 0.0467f $ **FLOATING
C2038 VDD.n142 VSS 0.02167f $ **FLOATING
C2039 VDD.n143 VSS 0.06247f $ **FLOATING
C2040 VDD.n144 VSS 0.02262f $ **FLOATING
C2041 VDD.n152 VSS 0.01985f $ **FLOATING
C2042 VDD.n172 VSS 0.01093f $ **FLOATING
C2043 VDD.n173 VSS 0.04295f $ **FLOATING
C2044 VDD.n175 VSS 0.03102f $ **FLOATING
C2045 VDD.n176 VSS 0.06958f $ **FLOATING
C2046 VDD.n177 VSS 0.01462f $ **FLOATING
C2047 VDD.t28 VSS 0.03164f $ **FLOATING
C2048 VDD.t231 VSS 0.02306f $ **FLOATING
C2049 VDD.n178 VSS 0.01658f $ **FLOATING
C2050 VDD.n179 VSS 0.03629f $ **FLOATING
C2051 VDD.n180 VSS 0.01173f $ **FLOATING
C2052 VDD.t232 VSS 0.02306f $ **FLOATING
C2053 VDD.n182 VSS 0.0333f $ **FLOATING
C2054 VDD.n183 VSS 0.03759f $ **FLOATING
C2055 VDD.n184 VSS 0.01017f $ **FLOATING
C2056 VDD.t236 VSS 0.02306f $ **FLOATING
C2057 VDD.n185 VSS 0.0262f $ **FLOATING
C2058 VDD.n187 VSS 0.01504f $ **FLOATING
C2059 VDD.n188 VSS 0.04196f $ **FLOATING
C2060 VDD.t229 VSS 0.02073f $ **FLOATING
C2061 VDD.n190 VSS 0.02198f $ **FLOATING
C2062 VDD.n191 VSS 0.06266f $ **FLOATING
C2063 VDD.t27 VSS 5.53829f $ **FLOATING
C2064 VDD.n195 VSS 0.03034f $ **FLOATING
C2065 VDD.n196 VSS 0.01869f $ **FLOATING
C2066 VDD.t50 VSS 0.03164f $ **FLOATING
C2067 VDD.n198 VSS 0.02209f $ **FLOATING
C2068 VDD.n199 VSS 0.02225f $ **FLOATING
C2069 VDD.n200 VSS 0.02425f $ **FLOATING
C2070 VDD.n204 VSS 0.30867f $ **FLOATING
C2071 VDD.n206 VSS 0.02883f $ **FLOATING
C2072 VDD.t208 VSS 0.03479f $ **FLOATING
C2073 VDD.n210 VSS 2.59705f $ **FLOATING
C2074 VDD.t142 VSS 0.03479f $ **FLOATING
C2075 VDD.n211 VSS 0.07996f $ **FLOATING
C2076 VDD.n212 VSS 0.06664f $ **FLOATING
C2077 VDD.n213 VSS 0.05469f $ **FLOATING
C2078 VDD.n214 VSS 0.05469f $ **FLOATING
C2079 VDD.n215 VSS 0.02493f $ **FLOATING
C2080 VDD.n216 VSS 0.05469f $ **FLOATING
C2081 VDD.n217 VSS 0.05067f $ **FLOATING
C2082 VDD.n218 VSS 0.05469f $ **FLOATING
C2083 VDD.n219 VSS 0.03374f $ **FLOATING
C2084 VDD.n220 VSS 0.01037f $ **FLOATING
C2085 VDD.n221 VSS 0.05469f $ **FLOATING
C2086 VDD.n222 VSS 0.01367f $ **FLOATING
C2087 VDD.n223 VSS 0.05469f $ **FLOATING
C2088 VDD.n224 VSS 0.05469f $ **FLOATING
C2089 VDD.n225 VSS 0.14145f $ **FLOATING
C2090 VDD.t156 VSS 0.07368f $ **FLOATING
C2091 VDD.n226 VSS 0.05469f $ **FLOATING
C2092 VDD.n227 VSS 0.05469f $ **FLOATING
C2093 VDD.n228 VSS 0.05308f $ **FLOATING
C2094 VDD.n229 VSS 0.04021f $ **FLOATING
C2095 VDD.n230 VSS 0.05469f $ **FLOATING
C2096 VDD.n231 VSS 0.10354f $ **FLOATING
C2097 VDD.n232 VSS 0.05469f $ **FLOATING
C2098 VDD.n233 VSS 0.05469f $ **FLOATING
C2099 VDD.n234 VSS 0.05469f $ **FLOATING
C2100 VDD.t228 VSS 0.02306f $ **FLOATING
C2101 VDD.t235 VSS 0.02395f $ **FLOATING
C2102 VDD.n235 VSS 0.05522f $ **FLOATING
C2103 VDD.t227 VSS 0.02306f $ **FLOATING
C2104 VDD.t233 VSS 0.02162f $ **FLOATING
C2105 VDD.n236 VSS 0.05522f $ **FLOATING
C2106 VDD.n237 VSS 0.02761f $ **FLOATING
C2107 VDD.n238 VSS 0.07989f $ **FLOATING
C2108 VDD.n239 VSS 0.05147f $ **FLOATING
C2109 VDD.t140 VSS 0.91699f $ **FLOATING
C2110 VDD.n240 VSS 0.01448f $ **FLOATING
C2111 VDD.n241 VSS 0.04424f $ **FLOATING
C2112 VDD.t141 VSS 0.07368f $ **FLOATING
C2113 VDD.n242 VSS 0.48792f $ **FLOATING
C2114 VDD.n243 VSS 0.02418f $ **FLOATING
C2115 VDD.n244 VSS 0.33316f $ **FLOATING
C2116 VDD.n245 VSS 0.33316f $ **FLOATING
C2117 VDD.t41 VSS 0.55976f $ **FLOATING
C2118 VDD.n247 VSS 0.09407f $ **FLOATING
C2119 VDD.n251 VSS 0.07194f $ **FLOATING
C2120 VDD.n252 VSS 0.04557f $ **FLOATING
C2121 VDD.n254 VSS 0.04619f $ **FLOATING
C2122 VDD.n255 VSS 0.04557f $ **FLOATING
C2123 VDD.n256 VSS 0.04557f $ **FLOATING
C2124 VDD.n257 VSS 0.04619f $ **FLOATING
C2125 VDD.t136 VSS 0.03479f $ **FLOATING
C2126 VDD.n258 VSS 0.04245f $ **FLOATING
C2127 VDD.n259 VSS 0.04245f $ **FLOATING
C2128 VDD.n260 VSS 0.08404f $ **FLOATING
C2129 VDD.n262 VSS 0.10408f $ **FLOATING
C2130 VDD.n263 VSS 0.01482f $ **FLOATING
C2131 VDD.n264 VSS 0.08364f $ **FLOATING
C2132 VDD.n265 VSS 0.04245f $ **FLOATING
C2133 VDD.t124 VSS 0.05885f $ **FLOATING
C2134 VDD.n266 VSS 0.04245f $ **FLOATING
C2135 VDD.n267 VSS 0.05306f $ **FLOATING
C2136 VDD.n268 VSS 0.04245f $ **FLOATING
C2137 VDD.t123 VSS 0.43012f $ **FLOATING
C2138 VDD.n269 VSS 0.02109f $ **FLOATING
C2139 VDD.n270 VSS 0.02497f $ **FLOATING
C2140 VDD.n271 VSS 0.02146f $ **FLOATING
C2141 VDD.n275 VSS 0.05243f $ **FLOATING
C2142 VDD.t134 VSS 0.41935f $ **FLOATING
C2143 VDD.n277 VSS 0.04245f $ **FLOATING
C2144 VDD.n278 VSS 0.05431f $ **FLOATING
C2145 VDD.n279 VSS 0.04557f $ **FLOATING
C2146 VDD.n280 VSS 0.04557f $ **FLOATING
C2147 VDD.n281 VSS 0.04619f $ **FLOATING
C2148 VDD.n282 VSS 0.04557f $ **FLOATING
C2149 VDD.n284 VSS 0.04619f $ **FLOATING
C2150 VDD.t196 VSS 0.03479f $ **FLOATING
C2151 VDD.n285 VSS 0.08404f $ **FLOATING
C2152 VDD.n286 VSS 0.04245f $ **FLOATING
C2153 VDD.n287 VSS 0.04245f $ **FLOATING
C2154 VDD.n289 VSS 0.04245f $ **FLOATING
C2155 VDD.n290 VSS 0.01482f $ **FLOATING
C2156 VDD.n291 VSS 0.04245f $ **FLOATING
C2157 VDD.n292 VSS 0.08364f $ **FLOATING
C2158 VDD.t178 VSS 0.05885f $ **FLOATING
C2159 VDD.n293 VSS 0.07418f $ **FLOATING
C2160 VDD.n294 VSS 0.08059f $ **FLOATING
C2161 VDD.n297 VSS 0.0128f $ **FLOATING
C2162 VDD.n298 VSS 0.01781f $ **FLOATING
C2163 VDD.n299 VSS 0.01781f $ **FLOATING
C2164 VDD.n303 VSS 0.01781f $ **FLOATING
C2165 VDD.n304 VSS 0.02174f $ **FLOATING
C2166 VDD.n307 VSS 0.01781f $ **FLOATING
C2167 VDD.n308 VSS 0.01781f $ **FLOATING
C2168 VDD.n315 VSS 0.03992f $ **FLOATING
C2169 VDD.n318 VSS 0.01682f $ **FLOATING
C2170 VDD.n320 VSS 0.01343f $ **FLOATING
C2171 VDD.t42 VSS 0.49974f $ **FLOATING
C2172 VDD.n322 VSS 0.33316f $ **FLOATING
C2173 VDD.t49 VSS 0.36256f $ **FLOATING
C2174 VDD.n328 VSS 0.01617f $ **FLOATING
C2175 VDD.n329 VSS 0.01223f $ **FLOATING
C2176 VDD.n330 VSS 0.0142f $ **FLOATING
C2177 VDD.n332 VSS 0.01252f $ **FLOATING
C2178 VDD.t52 VSS 0.33316f $ **FLOATING
C2179 VDD.n338 VSS 0.33316f $ **FLOATING
C2180 VDD.n342 VSS 0.33316f $ **FLOATING
C2181 VDD.t247 VSS 0.02306f $ **FLOATING
C2182 VDD.t243 VSS 0.02162f $ **FLOATING
C2183 VDD.n345 VSS 0.05522f $ **FLOATING
C2184 VDD.t246 VSS 0.02306f $ **FLOATING
C2185 VDD.t250 VSS 0.02395f $ **FLOATING
C2186 VDD.n346 VSS 0.05522f $ **FLOATING
C2187 VDD.n352 VSS 0.09757f $ **FLOATING
C2188 VDD.n356 VSS 0.02433f $ **FLOATING
C2189 VDD.n357 VSS 0.01815f $ **FLOATING
C2190 VDD.n360 VSS 0.01072f $ **FLOATING
C2191 VDD.n363 VSS 0.31171f $ **FLOATING
C2192 VDD.n364 VSS 0.04861f $ **FLOATING
C2193 VDD.t109 VSS 0.03164f $ **FLOATING
C2194 VDD.t253 VSS 0.02073f $ **FLOATING
C2195 VDD.t242 VSS 0.02306f $ **FLOATING
C2196 VDD.t241 VSS 0.02306f $ **FLOATING
C2197 VDD.t244 VSS 0.02306f $ **FLOATING
C2198 VDD.t255 VSS 0.03164f $ **FLOATING
C2199 VDD.n367 VSS 0.01831f $ **FLOATING
C2200 VDD.n368 VSS 0.01307f $ **FLOATING
C2201 VDD.n369 VSS 0.04809f $ **FLOATING
C2202 VDD.n370 VSS 0.01073f $ **FLOATING
C2203 VDD.n371 VSS 0.02578f $ **FLOATING
C2204 VDD.n372 VSS 0.04387f $ **FLOATING
C2205 VDD.n374 VSS 0.03168f $ **FLOATING
C2206 VDD.n375 VSS 0.01856f $ **FLOATING
C2207 VDD.n376 VSS 0.03308f $ **FLOATING
C2208 VDD.n377 VSS 0.04773f $ **FLOATING
C2209 VDD.n379 VSS 0.02844f $ **FLOATING
C2210 VDD.n381 VSS 0.04189f $ **FLOATING
C2211 VDD.n382 VSS 0.01531f $ **FLOATING
C2212 VDD.n383 VSS 0.02179f $ **FLOATING
C2213 VDD.n384 VSS 0.01745f $ **FLOATING
C2214 VDD.n386 VSS 0.01928f $ **FLOATING
C2215 VDD.n388 VSS 0.01632f $ **FLOATING
C2216 VDD.n389 VSS 0.01577f $ **FLOATING
C2217 VDD.n390 VSS 0.0179f $ **FLOATING
C2218 VDD.n393 VSS 0.01155f $ **FLOATING
C2219 VDD.n394 VSS 0.0556f $ **FLOATING
C2220 VDD.t108 VSS 5.71467f $ **FLOATING
C2221 VDD.n401 VSS 0.18576f $ **FLOATING
C2222 VDD.n403 VSS 0.10959f $ **FLOATING
C2223 VDD.n404 VSS 0.01093f $ **FLOATING
C2224 VDD.n405 VSS 0.13282f $ **FLOATING
C2225 VDD.n406 VSS 0.01006f $ **FLOATING
C2226 VDD.n407 VSS 0.06064f $ **FLOATING
C2227 VDD.n408 VSS 0.02863f $ **FLOATING
C2228 VDD.n409 VSS 0.01456f $ **FLOATING
C2229 VDD.n410 VSS 0.07439f $ **FLOATING
C2230 VDD.n411 VSS 0.01761f $ **FLOATING
C2231 VDD.n412 VSS 0.26247f $ **FLOATING
C2232 VDD.n413 VSS 0.01444f $ **FLOATING
C2233 VDD.n414 VSS 0.05817f $ **FLOATING
C2234 VDD.n415 VSS 0.02385f $ **FLOATING
C2235 VDD.n416 VSS 0.01304f $ **FLOATING
C2236 VDD.n417 VSS 0.01251f $ **FLOATING
C2237 VDD.t47 VSS 0.33316f $ **FLOATING
C2238 VDD.n418 VSS 0.79333f $ **FLOATING
C2239 VDD.n420 VSS 0.02805f $ **FLOATING
C2240 VDD.n421 VSS 0.02442f $ **FLOATING
C2241 VDD.n422 VSS 0.01536f $ **FLOATING
C2242 VDD.n423 VSS 0.01536f $ **FLOATING
C2243 VDD.n424 VSS 0.01654f $ **FLOATING
C2244 VDD.n425 VSS 0.01037f $ **FLOATING
C2245 VDD.n427 VSS 0.02454f $ **FLOATING
C2246 VDD.n428 VSS 0.01543f $ **FLOATING
C2247 VDD.n429 VSS 0.0108f $ **FLOATING
C2248 VDD.n430 VSS 0.05051f $ **FLOATING
C2249 VDD.n431 VSS 0.06202f $ **FLOATING
C2250 VDD.n432 VSS 0.01802f $ **FLOATING
C2251 VDD.n433 VSS 0.35254f $ **FLOATING
C2252 VDD.t54 VSS 3.66398f $ **FLOATING
C2253 VDD.n435 VSS 0.34186f $ **FLOATING
C2254 VDD.n436 VSS 0.01119f $ **FLOATING
C2255 VDD.n437 VSS 0.01596f $ **FLOATING
C2256 VDD.n438 VSS 6.75625f $ **FLOATING
C2257 VDD.n439 VSS 7.05272f $ **FLOATING
C2258 VDD.n440 VSS 4.63375f $ **FLOATING
C2259 VDD.n442 VSS 0.34221f $ **FLOATING
C2260 VDD.t183 VSS 0.01392f $ **FLOATING
C2261 VDD.n443 VSS 0.0159f $ **FLOATING
C2262 VDD.n444 VSS 0.01545f $ **FLOATING
C2263 VDD.n445 VSS 0.0159f $ **FLOATING
C2264 VDD.n446 VSS 0.01457f $ **FLOATING
C2265 VDD.n448 VSS 0.02045f $ **FLOATING
C2266 VDD.t170 VSS 0.01392f $ **FLOATING
C2267 VDD.n449 VSS 0.0159f $ **FLOATING
C2268 VDD.n450 VSS 0.02847f $ **FLOATING
C2269 VDD.t171 VSS 0.01392f $ **FLOATING
C2270 VDD.n451 VSS 0.03302f $ **FLOATING
C2271 VDD.n452 VSS 0.01271f $ **FLOATING
C2272 VDD.t150 VSS 0.01392f $ **FLOATING
C2273 VDD.n453 VSS 0.0159f $ **FLOATING
C2274 VDD.n454 VSS 0.01545f $ **FLOATING
C2275 VDD.n455 VSS 0.0159f $ **FLOATING
C2276 VDD.n456 VSS 0.02863f $ **FLOATING
C2277 VDD.n457 VSS 0.0159f $ **FLOATING
C2278 VDD.t165 VSS 0.01392f $ **FLOATING
C2279 VDD.n458 VSS 0.01545f $ **FLOATING
C2280 VDD.n459 VSS 0.01271f $ **FLOATING
C2281 VDD.n460 VSS 0.0159f $ **FLOATING
C2282 VDD.t204 VSS 0.01392f $ **FLOATING
C2283 VDD.n461 VSS 0.01545f $ **FLOATING
C2284 VDD.t87 VSS 0.01559f $ **FLOATING
C2285 VDD.t88 VSS 0.01918f $ **FLOATING
C2286 VDD.t86 VSS 0.01834f $ **FLOATING
C2287 VDD.n462 VSS 0.03855f $ **FLOATING
C2288 VDD.n463 VSS 0.01087f $ **FLOATING
C2289 VDD.n464 VSS 0.01933f $ **FLOATING
C2290 VDD.n465 VSS 0.0194f $ **FLOATING
C2291 VDD.n466 VSS 0.0159f $ **FLOATING
C2292 VDD.n467 VSS 0.11215f $ **FLOATING
C2293 VDD.t205 VSS 0.01392f $ **FLOATING
C2294 VDD.n468 VSS 0.01545f $ **FLOATING
C2295 VDD.n469 VSS 0.02067f $ **FLOATING
C2296 VDD.t186 VSS 0.01392f $ **FLOATING
C2297 VDD.n470 VSS 0.0159f $ **FLOATING
C2298 VDD.n471 VSS 0.02045f $ **FLOATING
C2299 VDD.n473 VSS 0.03302f $ **FLOATING
C2300 VDD.t187 VSS 0.01392f $ **FLOATING
C2301 VDD.n474 VSS 0.02847f $ **FLOATING
C2302 VDD.n475 VSS 0.01457f $ **FLOATING
C2303 VDD.n476 VSS 0.02806f $ **FLOATING
C2304 VDD.t164 VSS 0.08268f $ **FLOATING
C2305 VDD.n477 VSS 0.02856f $ **FLOATING
C2306 VDD.n478 VSS 0.02204f $ **FLOATING
C2307 VDD.n479 VSS 0.0159f $ **FLOATING
C2308 VDD.n480 VSS 0.01545f $ **FLOATING
C2309 VDD.t166 VSS 0.01392f $ **FLOATING
C2310 VDD.n481 VSS 0.03958f $ **FLOATING
C2311 VDD.n482 VSS 0.03597f $ **FLOATING
C2312 VDD.n483 VSS 0.01017f $ **FLOATING
C2313 VDD.n484 VSS 0.26247f $ **FLOATING
C2314 VDD.n485 VSS 0.01761f $ **FLOATING
C2315 VDD.n486 VSS 0.01093f $ **FLOATING
C2316 VDD.n488 VSS 0.13282f $ **FLOATING
C2317 VDD.n489 VSS 0.01006f $ **FLOATING
C2318 VDD.n490 VSS 0.07439f $ **FLOATING
C2319 VDD.n491 VSS 0.01456f $ **FLOATING
C2320 VDD.n492 VSS 0.10473f $ **FLOATING
C2321 VDD.n493 VSS 0.01093f $ **FLOATING
C2322 VDD.n494 VSS 0.069f $ **FLOATING
C2323 VDD.n495 VSS 0.02441f $ **FLOATING
C2324 VDD.n496 VSS 0.02441f $ **FLOATING
C2325 VDD.n497 VSS 0.02441f $ **FLOATING
C2326 VDD.n498 VSS 0.02441f $ **FLOATING
C2327 VDD.n499 VSS 0.02037f $ **FLOATING
C2328 VDD.n500 VSS 0.05898f $ **FLOATING
C2329 VDD.n501 VSS 0.10361f $ **FLOATING
C2330 VDD.t84 VSS 0.03961f $ **FLOATING
C2331 VDD.n502 VSS 0.26487f $ **FLOATING
C2332 VDD.n503 VSS 0.01039f $ **FLOATING
C2333 VDD.n504 VSS 0.05741f $ **FLOATING
C2334 VDD.n505 VSS 0.05741f $ **FLOATING
C2335 VDD.n506 VSS 0.05741f $ **FLOATING
C2336 VDD.n507 VSS 0.05741f $ **FLOATING
C2337 VDD.n508 VSS 0.05741f $ **FLOATING
C2338 VDD.t119 VSS 0.07368f $ **FLOATING
C2339 VDD.n509 VSS 0.20885f $ **FLOATING
C2340 VDD.t121 VSS 0.07368f $ **FLOATING
C2341 VDD.n510 VSS 0.0467f $ **FLOATING
C2342 VDD.n511 VSS 0.05741f $ **FLOATING
C2343 VDD.n512 VSS 0.05741f $ **FLOATING
C2344 VDD.n513 VSS 0.0904f $ **FLOATING
C2345 VDD.n514 VSS 0.0904f $ **FLOATING
C2346 VDD.n515 VSS 0.12882f $ **FLOATING
C2347 VDD.n516 VSS 0.0904f $ **FLOATING
C2348 VDD.n517 VSS 0.0904f $ **FLOATING
C2349 VDD.n518 VSS 0.05741f $ **FLOATING
C2350 VDD.n519 VSS 0.11251f $ **FLOATING
C2351 VDD.t118 VSS 0.91699f $ **FLOATING
C2352 VDD.n520 VSS 0.0152f $ **FLOATING
C2353 VDD.n521 VSS 0.05741f $ **FLOATING
C2354 VDD.t176 VSS 0.03479f $ **FLOATING
C2355 VDD.t122 VSS 0.03479f $ **FLOATING
C2356 VDD.n522 VSS 0.08883f $ **FLOATING
C2357 VDD.n523 VSS 0.01351f $ **FLOATING
C2358 VDD.n524 VSS 2.72479f $ **FLOATING
C2359 VDD.n525 VSS 0.01015f $ **FLOATING
C2360 VDD.n526 VSS 0.01302f $ **FLOATING
C2361 VDD.n527 VSS 0.01013f $ **FLOATING
C2362 VDD.n529 VSS 0.02919f $ **FLOATING
C2363 VDD.n530 VSS 0.01607f $ **FLOATING
C2364 VDD.n532 VSS 0.04014f $ **FLOATING
C2365 VDD.t257 VSS 0.03164f $ **FLOATING
C2366 VDD.n534 VSS 0.04233f $ **FLOATING
C2367 VDD.n535 VSS 0.01671f $ **FLOATING
C2368 VDD.n538 VSS 0.05071f $ **FLOATING
C2369 VDD.n541 VSS 0.03797f $ **FLOATING
C2370 VDD.n542 VSS 0.0121f $ **FLOATING
C2371 VDD.t1 VSS 0.03164f $ **FLOATING
C2372 VDD.n543 VSS 0.04005f $ **FLOATING
C2373 VDD.n544 VSS 0.01678f $ **FLOATING
C2374 VDD.n546 VSS 0.05438f $ **FLOATING
C2375 VDD.n548 VSS 0.03641f $ **FLOATING
C2376 VDD.n549 VSS 0.01604f $ **FLOATING
C2377 VDD.t18 VSS 0.01595f $ **FLOATING
C2378 VDD.n550 VSS 0.03515f $ **FLOATING
C2379 VDD.n551 VSS 0.01043f $ **FLOATING
C2380 VDD.t20 VSS 0.01595f $ **FLOATING
C2381 VDD.n552 VSS 0.02737f $ **FLOATING
C2382 VDD.n553 VSS 0.0104f $ **FLOATING
C2383 VDD.t17 VSS 0.01595f $ **FLOATING
C2384 VDD.n554 VSS 0.02555f $ **FLOATING
C2385 VDD.n555 VSS 0.01344f $ **FLOATING
C2386 VDD.t19 VSS 0.01595f $ **FLOATING
C2387 VDD.n556 VSS 0.02396f $ **FLOATING
C2388 VDD.t21 VSS 0.01595f $ **FLOATING
C2389 VDD.n557 VSS 0.04101f $ **FLOATING
C2390 VDD.n558 VSS 0.0104f $ **FLOATING
C2391 VDD.t4 VSS 0.01595f $ **FLOATING
C2392 VDD.n559 VSS 0.03512f $ **FLOATING
C2393 VDD.n560 VSS 0.0104f $ **FLOATING
C2394 VDD.t11 VSS 0.31925f $ **FLOATING
C2395 VDD.t12 VSS 0.01595f $ **FLOATING
C2396 VDD.n561 VSS 0.02742f $ **FLOATING
C2397 VDD.n562 VSS 0.01043f $ **FLOATING
C2398 VDD.t8 VSS 0.31925f $ **FLOATING
C2399 VDD.t5 VSS 0.2676f $ **FLOATING
C2400 VDD.t6 VSS 0.01595f $ **FLOATING
C2401 VDD.n563 VSS 0.02551f $ **FLOATING
C2402 VDD.n564 VSS 0.01344f $ **FLOATING
C2403 VDD.t16 VSS 0.25821f $ **FLOATING
C2404 VDD.t13 VSS 0.01595f $ **FLOATING
C2405 VDD.n565 VSS 0.02392f $ **FLOATING
C2406 VDD.t10 VSS 0.01595f $ **FLOATING
C2407 VDD.n566 VSS 0.03836f $ **FLOATING
C2408 VDD.n567 VSS 0.01043f $ **FLOATING
C2409 VDD.t9 VSS 0.38615f $ **FLOATING
C2410 VDD.t14 VSS 0.31338f $ **FLOATING
C2411 VDD.n568 VSS 0.6338f $ **FLOATING
C2412 VDD.n571 VSS 0.07194f $ **FLOATING
C2413 VDD.n572 VSS 0.04557f $ **FLOATING
C2414 VDD.n574 VSS 0.04619f $ **FLOATING
C2415 VDD.n575 VSS 0.04557f $ **FLOATING
C2416 VDD.n576 VSS 0.04557f $ **FLOATING
C2417 VDD.n577 VSS 0.04619f $ **FLOATING
C2418 VDD.t114 VSS 0.05882f $ **FLOATING
C2419 VDD.n578 VSS 0.08404f $ **FLOATING
C2420 VDD.n579 VSS 0.10408f $ **FLOATING
C2421 VDD.n580 VSS 0.08364f $ **FLOATING
C2422 VDD.n581 VSS 0.04245f $ **FLOATING
C2423 VDD.t217 VSS 0.03479f $ **FLOATING
C2424 VDD.n582 VSS 0.04245f $ **FLOATING
C2425 VDD.n584 VSS 0.04245f $ **FLOATING
C2426 VDD.n585 VSS 0.01486f $ **FLOATING
C2427 VDD.n586 VSS 0.04245f $ **FLOATING
C2428 VDD.n587 VSS 0.05306f $ **FLOATING
C2429 VDD.n588 VSS 0.04245f $ **FLOATING
C2430 VDD.t152 VSS 0.42828f $ **FLOATING
C2431 VDD.n592 VSS 0.02201f $ **FLOATING
C2432 VDD.n593 VSS 0.02404f $ **FLOATING
C2433 VDD.n594 VSS 0.05244f $ **FLOATING
C2434 VDD.t113 VSS 0.40848f $ **FLOATING
C2435 VDD.n595 VSS 0.03416f $ **FLOATING
C2436 VDD.n596 VSS 0.04245f $ **FLOATING
C2437 VDD.n597 VSS 0.05431f $ **FLOATING
C2438 VDD.n598 VSS 0.04557f $ **FLOATING
C2439 VDD.n599 VSS 0.04557f $ **FLOATING
C2440 VDD.n600 VSS 0.04619f $ **FLOATING
C2441 VDD.n601 VSS 0.04557f $ **FLOATING
C2442 VDD.n603 VSS 0.04619f $ **FLOATING
C2443 VDD.t153 VSS 0.05882f $ **FLOATING
C2444 VDD.n604 VSS 0.04245f $ **FLOATING
C2445 VDD.n605 VSS 0.04245f $ **FLOATING
C2446 VDD.n606 VSS 0.04245f $ **FLOATING
C2447 VDD.n607 VSS 0.04245f $ **FLOATING
C2448 VDD.t154 VSS 0.03479f $ **FLOATING
C2449 VDD.n608 VSS 0.08364f $ **FLOATING
C2450 VDD.n610 VSS 0.08404f $ **FLOATING
C2451 VDD.n611 VSS 0.01486f $ **FLOATING
C2452 VDD.n612 VSS 0.07418f $ **FLOATING
C2453 VDD.n613 VSS 0.08059f $ **FLOATING
C2454 VDD.n616 VSS 0.05736f $ **FLOATING
C2455 VDD.n618 VSS 0.0192f $ **FLOATING
C2456 VDD.n620 VSS 0.0192f $ **FLOATING
C2457 VDD.n622 VSS 0.0192f $ **FLOATING
C2458 VDD.n624 VSS 0.0192f $ **FLOATING
C2459 VDD.n626 VSS 0.0209f $ **FLOATING
C2460 VDD.n631 VSS 0.098f $ **FLOATING
C2461 VDD.n634 VSS 0.0192f $ **FLOATING
C2462 VDD.n635 VSS 0.07689f $ **FLOATING
C2463 VDD.n636 VSS 0.0192f $ **FLOATING
C2464 VDD.t0 VSS 12.1976f $ **FLOATING
C2465 VDD.n652 VSS 0.08479f $ **FLOATING
C2466 VDD.n654 VSS 1.30748f $ **FLOATING
C2467 VDD.n655 VSS 0.01444f $ **FLOATING
C2468 VDD.n656 VSS 0.02857f $ **FLOATING
C2469 VDD.n657 VSS 0.05817f $ **FLOATING
C2470 VDD.n658 VSS 0.01027f $ **FLOATING
C2471 VDD.n659 VSS 0.06064f $ **FLOATING
C2472 VDD.n660 VSS 0.0174f $ **FLOATING
C2473 VDD.n661 VSS 0.05853f $ **FLOATING
C2474 VDD.t151 VSS 0.01392f $ **FLOATING
C2475 VDD.n662 VSS 0.01545f $ **FLOATING
C2476 VDD.n663 VSS 0.02204f $ **FLOATING
C2477 VDD.n664 VSS 0.02856f $ **FLOATING
C2478 VDD.t149 VSS 0.08268f $ **FLOATING
C2479 VDD.n665 VSS 0.02806f $ **FLOATING
C2480 VDD.n666 VSS 0.02067f $ **FLOATING
C2481 VDD.n667 VSS 0.01545f $ **FLOATING
C2482 VDD.t184 VSS 0.01392f $ **FLOATING
C2483 VDD.n668 VSS 0.03927f $ **FLOATING
C2484 VDD.n669 VSS 0.02801f $ **FLOATING
C2485 VDD.n671 VSS 0.0464f $ **FLOATING
C2486 VDD.n672 VSS 0.01114f $ **FLOATING
C2487 VDD.n673 VSS 0.24719f $ **FLOATING
C2488 VDD.n674 VSS 1.6435f $ **FLOATING
C2489 VDD.n675 VSS 0.5725f $ **FLOATING
C2490 VDD.n676 VSS 2.25029f $ **FLOATING
C2491 VDD.n677 VSS 0.25035f $ **FLOATING
C2492 VDD.n678 VSS 0.01849f $ **FLOATING
C2493 VDD.n684 VSS 1.30748f $ **FLOATING
C2494 VDD.n685 VSS 0.01001f $ **FLOATING
C2495 VDD.n686 VSS 0.01604f $ **FLOATING
C2496 VDD.n687 VSS 0.02441f $ **FLOATING
C2497 VDD.n688 VSS 0.05741f $ **FLOATING
C2498 VDD.n689 VSS 0.05741f $ **FLOATING
C2499 VDD.n690 VSS 0.0152f $ **FLOATING
C2500 VDD.n691 VSS 0.0904f $ **FLOATING
C2501 VDD.n692 VSS 0.0904f $ **FLOATING
C2502 VDD.n693 VSS 0.02441f $ **FLOATING
C2503 VDD.n694 VSS 0.02441f $ **FLOATING
C2504 VDD.n695 VSS 0.0904f $ **FLOATING
C2505 VDD.n696 VSS 0.02441f $ **FLOATING
C2506 VDD.n697 VSS 0.0904f $ **FLOATING
C2507 VDD.n698 VSS 0.05741f $ **FLOATING
C2508 VDD.n699 VSS 0.05741f $ **FLOATING
C2509 VDD.n700 VSS 0.05741f $ **FLOATING
C2510 VDD.n701 VSS 0.05741f $ **FLOATING
C2511 VDD.n702 VSS 0.05741f $ **FLOATING
C2512 VDD.n703 VSS 0.05741f $ **FLOATING
C2513 VDD.t73 VSS 0.01595f $ **FLOATING
C2514 VDD.t71 VSS 0.01595f $ **FLOATING
C2515 VDD.t77 VSS 0.01595f $ **FLOATING
C2516 VDD.t72 VSS 0.01595f $ **FLOATING
C2517 VDD.t75 VSS 0.01595f $ **FLOATING
C2518 VDD.n704 VSS 0.03515f $ **FLOATING
C2519 VDD.n705 VSS 0.01043f $ **FLOATING
C2520 VDD.n706 VSS 0.02737f $ **FLOATING
C2521 VDD.n707 VSS 0.0104f $ **FLOATING
C2522 VDD.n708 VSS 0.02555f $ **FLOATING
C2523 VDD.n709 VSS 0.01344f $ **FLOATING
C2524 VDD.n710 VSS 0.02396f $ **FLOATING
C2525 VDD.n711 VSS 0.0104f $ **FLOATING
C2526 VDD.n712 VSS 0.0424f $ **FLOATING
C2527 VDD.n713 VSS 0.04612f $ **FLOATING
C2528 VDD.t138 VSS 0.07368f $ **FLOATING
C2529 VDD.n714 VSS 0.02037f $ **FLOATING
C2530 VDD.n715 VSS 0.0467f $ **FLOATING
C2531 VDD.t201 VSS 0.07368f $ **FLOATING
C2532 VDD.n716 VSS 0.49953f $ **FLOATING
C2533 VDD.n717 VSS 0.05898f $ **FLOATING
C2534 VDD.n718 VSS 0.05741f $ **FLOATING
C2535 VDD.n719 VSS 0.11251f $ **FLOATING
C2536 VDD.t137 VSS 0.91699f $ **FLOATING
C2537 VDD.n720 VSS 0.12882f $ **FLOATING
C2538 VDD.n721 VSS 0.069f $ **FLOATING
C2539 VDD.t139 VSS 0.03479f $ **FLOATING
C2540 VDD.t202 VSS 0.03479f $ **FLOATING
C2541 VDD.n722 VSS 0.08883f $ **FLOATING
C2542 VDD.n723 VSS 0.01351f $ **FLOATING
C2543 VDD.n733 VSS 0.04619f $ **FLOATING
C2544 VDD.t160 VSS 0.07368f $ **FLOATING
C2545 VDD.n734 VSS 0.04245f $ **FLOATING
C2546 VDD.n735 VSS 0.04245f $ **FLOATING
C2547 VDD.n736 VSS 0.04245f $ **FLOATING
C2548 VDD.n737 VSS 0.04557f $ **FLOATING
C2549 VDD.n741 VSS 0.04245f $ **FLOATING
C2550 VDD.n742 VSS 0.04619f $ **FLOATING
C2551 VDD.t132 VSS 0.07368f $ **FLOATING
C2552 VDD.n743 VSS 0.04245f $ **FLOATING
C2553 VDD.n744 VSS 0.04245f $ **FLOATING
C2554 VDD.n745 VSS 0.08364f $ **FLOATING
C2555 VDD.n746 VSS 0.04557f $ **FLOATING
C2556 VDD.n755 VSS 0.01013f $ **FLOATING
C2557 VDD.t65 VSS 0.01595f $ **FLOATING
C2558 VDD.t59 VSS 0.01595f $ **FLOATING
C2559 VDD.t62 VSS 0.01595f $ **FLOATING
C2560 VDD.t67 VSS 0.01595f $ **FLOATING
C2561 VDD.t57 VSS 0.01595f $ **FLOATING
C2562 VDD.t56 VSS 0.03164f $ **FLOATING
C2563 VDD.t256 VSS 0.03164f $ **FLOATING
C2564 VDD.n756 VSS 0.04021f $ **FLOATING
C2565 VDD.n757 VSS 0.01873f $ **FLOATING
C2566 VDD.n758 VSS 0.04134f $ **FLOATING
C2567 VDD.n761 VSS 0.04286f $ **FLOATING
C2568 VDD.n763 VSS 0.04229f $ **FLOATING
C2569 VDD.n764 VSS 0.01677f $ **FLOATING
C2570 VDD.n765 VSS 0.04353f $ **FLOATING
C2571 VDD.n767 VSS 0.03524f $ **FLOATING
C2572 VDD.n768 VSS 0.01607f $ **FLOATING
C2573 VDD.n769 VSS 0.03512f $ **FLOATING
C2574 VDD.n770 VSS 0.0104f $ **FLOATING
C2575 VDD.n771 VSS 0.02742f $ **FLOATING
C2576 VDD.n772 VSS 0.01043f $ **FLOATING
C2577 VDD.n773 VSS 0.02551f $ **FLOATING
C2578 VDD.n774 VSS 0.01344f $ **FLOATING
C2579 VDD.n775 VSS 0.02392f $ **FLOATING
C2580 VDD.n776 VSS 0.01043f $ **FLOATING
C2581 VDD.n777 VSS 0.03836f $ **FLOATING
C2582 VDD.n778 VSS 0.01302f $ **FLOATING
C2583 VDD.n779 VSS 0.0192f $ **FLOATING
C2584 VDD.n780 VSS 0.0192f $ **FLOATING
C2585 VDD.n781 VSS 0.0192f $ **FLOATING
C2586 VDD.n782 VSS 0.0192f $ **FLOATING
C2587 VDD.n783 VSS 0.0209f $ **FLOATING
C2588 VDD.n785 VSS 0.6338f $ **FLOATING
C2589 VDD.t64 VSS 0.31338f $ **FLOATING
C2590 VDD.t68 VSS 0.38615f $ **FLOATING
C2591 VDD.t58 VSS 0.25821f $ **FLOATING
C2592 VDD.t63 VSS 0.2676f $ **FLOATING
C2593 VDD.t61 VSS 0.31925f $ **FLOATING
C2594 VDD.t66 VSS 0.31925f $ **FLOATING
C2595 VDD.n798 VSS 0.0192f $ **FLOATING
C2596 VDD.n799 VSS 0.0192f $ **FLOATING
C2597 VDD.n800 VSS 0.07689f $ **FLOATING
C2598 VDD.n801 VSS 0.05736f $ **FLOATING
C2599 VDD.n802 VSS 0.098f $ **FLOATING
C2600 VDD.n803 VSS 0.07194f $ **FLOATING
C2601 VDD.n804 VSS 0.10408f $ **FLOATING
C2602 VDD.n805 VSS 0.04619f $ **FLOATING
C2603 VDD.n807 VSS 0.08404f $ **FLOATING
C2604 VDD.n808 VSS 0.04557f $ **FLOATING
C2605 VDD.n809 VSS 0.04557f $ **FLOATING
C2606 VDD.n810 VSS 0.04245f $ **FLOATING
C2607 VDD.t133 VSS 0.03479f $ **FLOATING
C2608 VDD.n811 VSS 0.04245f $ **FLOATING
C2609 VDD.n812 VSS 0.05306f $ **FLOATING
C2610 VDD.t131 VSS 0.42828f $ **FLOATING
C2611 VDD.n813 VSS 0.02201f $ **FLOATING
C2612 VDD.n814 VSS 0.02404f $ **FLOATING
C2613 VDD.n815 VSS 0.05244f $ **FLOATING
C2614 VDD.t159 VSS 0.40848f $ **FLOATING
C2615 VDD.n816 VSS 0.03416f $ **FLOATING
C2616 VDD.n817 VSS 0.04245f $ **FLOATING
C2617 VDD.n818 VSS 0.05431f $ **FLOATING
C2618 VDD.n819 VSS 0.04245f $ **FLOATING
C2619 VDD.n820 VSS 0.04619f $ **FLOATING
C2620 VDD.n821 VSS 0.04557f $ **FLOATING
C2621 VDD.n822 VSS 0.04245f $ **FLOATING
C2622 VDD.n823 VSS 0.03745f $ **FLOATING
C2623 VDD.t85 VSS 0.03961f $ **FLOATING
C2624 VDD.n824 VSS 0.08313f $ **FLOATING
C2625 VDD.n826 VSS 0.04557f $ **FLOATING
C2626 VDD.n827 VSS 0.04245f $ **FLOATING
C2627 VDD.t190 VSS 0.03479f $ **FLOATING
C2628 VDD.n828 VSS 0.07418f $ **FLOATING
C2629 VDD.n829 VSS 0.08059f $ **FLOATING
C2630 VDD.n830 VSS 0.08479f $ **FLOATING
C2631 VDD.n831 VSS 0.01093f $ **FLOATING
C2632 VDD.n832 VSS 0.13282f $ **FLOATING
C2633 VDD.n833 VSS 0.01006f $ **FLOATING
C2634 VDD.n834 VSS 0.06066f $ **FLOATING
C2635 VDD.n835 VSS 0.02863f $ **FLOATING
C2636 VDD.n836 VSS 0.01456f $ **FLOATING
C2637 VDD.n837 VSS 0.07429f $ **FLOATING
C2638 VDD.n838 VSS 0.01761f $ **FLOATING
C2639 VDD.n839 VSS 0.26257f $ **FLOATING
C2640 VDD.n840 VSS 0.01444f $ **FLOATING
C2641 VDD.n841 VSS 0.05812f $ **FLOATING
C2642 VDD.n842 VSS 0.02857f $ **FLOATING
C2643 VDD.n843 VSS 0.01017f $ **FLOATING
C2644 VDD.n844 VSS 0.10473f $ **FLOATING
C2645 VDD.n845 VSS 0.01093f $ **FLOATING
C2646 VDD.n846 VSS 2.72479f $ **FLOATING
C2647 VDD.n847 VSS 0.01015f $ **FLOATING
C2648 VDD.n848 VSS 0.0295f $ **FLOATING
C2649 VDD.n850 VSS 0.05656f $ **FLOATING
C2650 VDD.t55 VSS 12.1976f $ **FLOATING
C2651 VDD.n852 VSS 0.34221f $ **FLOATING
C2652 dw_n7292_5488.n0 VSS 0.18223f $ **FLOATING
C2653 dw_n7292_5488.t1 VSS 0.13689f $ **FLOATING
C2654 dw_n7292_5488.n1 VSS 0.31742f $ **FLOATING
C2655 dw_n7292_5488.t7 VSS 0.15915f $ **FLOATING
C2656 dw_n7292_5488.n2 VSS 0.32539f $ **FLOATING
C2657 dw_n7292_5488.n3 VSS 0.04454f $ **FLOATING
C2658 dw_n7292_5488.t5 VSS 0.13048f $ **FLOATING
C2659 dw_n7292_5488.n4 VSS 0.02737f $ **FLOATING
C2660 dw_n7292_5488.n5 VSS 0.02701f $ **FLOATING
C2661 dw_n7292_5488.n6 VSS 0.02701f $ **FLOATING
C2662 dw_n7292_5488.n7 VSS 0.02701f $ **FLOATING
C2663 dw_n7292_5488.n8 VSS 0.03508f $ **FLOATING
C2664 dw_n7292_5488.n9 VSS 0.08054f $ **FLOATING
C2665 dw_n7292_5488.n10 VSS 0.02386f $ **FLOATING
C2666 dw_n7292_5488.n11 VSS 0.02386f $ **FLOATING
C2667 dw_n7292_5488.n12 VSS 0.02386f $ **FLOATING
C2668 dw_n7292_5488.t4 VSS 0.10682f $ **FLOATING
C2669 dw_n7292_5488.t8 VSS 0.08128f $ **FLOATING
C2670 dw_n7292_5488.n13 VSS 0.22687f $ **FLOATING
C2671 dw_n7292_5488.n14 VSS 0.05218f $ **FLOATING
C2672 dw_n7292_5488.t3 VSS 2.7226f $ **FLOATING
C2673 dw_n7292_5488.n15 VSS 0.21836f $ **FLOATING
C2674 dw_n7292_5488.n16 VSS 0.09262f $ **FLOATING
C2675 dw_n7292_5488.n17 VSS 0.27959f $ **FLOATING
C2676 dw_n7292_5488.n18 VSS 0.41798f $ **FLOATING
C2677 dw_n7292_5488.n19 VSS 0.08835f $ **FLOATING
C2678 dw_n7292_5488.t6 VSS 0.13362f $ **FLOATING
C2679 dw_n7292_5488.n20 VSS 0.09875f $ **FLOATING
C2680 dw_n7292_5488.n21 VSS 0.21955f $ **FLOATING
C2681 dw_n7292_5488.t0 VSS 6.69792f $ **FLOATING
C2682 dw_n7292_5488.n22 VSS 0.21955f $ **FLOATING
C2683 dw_n7292_5488.n23 VSS 0.11168f $ **FLOATING
C2684 dw_n7292_5488.t2 VSS 0.14059f $ **FLOATING
C2685 IOVDD.n0 VSS 0.06402f $ **FLOATING
C2686 IOVDD.n2 VSS 0.09248f $ **FLOATING
C2687 IOVDD.n5 VSS 0.14127f $ **FLOATING
C2688 IOVDD.n6 VSS 0.08768f $ **FLOATING
C2689 IOVDD.n19 VSS 0.04386f $ **FLOATING
C2690 IOVDD.n20 VSS 0.08448f $ **FLOATING
C2691 IOVDD.n21 VSS 0.08463f $ **FLOATING
C2692 IOVDD.n22 VSS 0.10173f $ **FLOATING
C2693 IOVDD.n23 VSS 0.09275f $ **FLOATING
C2694 IOVDD.n24 VSS 0.0359f $ **FLOATING
C2695 IOVDD.t97 VSS 0.02216f $ **FLOATING
C2696 IOVDD.t69 VSS 0.02216f $ **FLOATING
C2697 IOVDD.n34 VSS 0.27259f $ **FLOATING
C2698 IOVDD.n35 VSS 0.02294f $ **FLOATING
C2699 IOVDD.n37 VSS 0.02002f $ **FLOATING
C2700 IOVDD.n38 VSS 0.01235f $ **FLOATING
C2701 IOVDD.n39 VSS 0.01235f $ **FLOATING
C2702 IOVDD.n40 VSS 0.01148f $ **FLOATING
C2703 IOVDD.n41 VSS 0.01726f $ **FLOATING
C2704 IOVDD.n45 VSS 0.04092f $ **FLOATING
C2705 IOVDD.n46 VSS 0.01222f $ **FLOATING
C2706 IOVDD.t29 VSS 0.02895f $ **FLOATING
C2707 IOVDD.n47 VSS 0.04153f $ **FLOATING
C2708 IOVDD.n48 VSS 0.02109f $ **FLOATING
C2709 IOVDD.n49 VSS 0.05258f $ **FLOATING
C2710 IOVDD.n52 VSS 0.08277f $ **FLOATING
C2711 IOVDD.n53 VSS 0.08207f $ **FLOATING
C2712 IOVDD.t3 VSS 11.5621f $ **FLOATING
C2713 IOVDD.n56 VSS 0.05192f $ **FLOATING
C2714 IOVDD.n57 VSS 0.59971f $ **FLOATING
C2715 IOVDD.n58 VSS 0.02533f $ **FLOATING
C2716 IOVDD.n61 VSS 0.04286f $ **FLOATING
C2717 IOVDD.n63 VSS 0.04795f $ **FLOATING
C2718 IOVDD.n66 VSS 0.01125f $ **FLOATING
C2719 IOVDD.n68 VSS 0.01143f $ **FLOATING
C2720 IOVDD.n70 VSS 0.06199f $ **FLOATING
C2721 IOVDD.t212 VSS 0.01815f $ **FLOATING
C2722 IOVDD.n71 VSS 0.04201f $ **FLOATING
C2723 IOVDD.n72 VSS 0.02213f $ **FLOATING
C2724 IOVDD.n74 VSS 0.02026f $ **FLOATING
C2725 IOVDD.n75 VSS 0.02702f $ **FLOATING
C2726 IOVDD.n76 VSS 0.05741f $ **FLOATING
C2727 IOVDD.t96 VSS 0.07169f $ **FLOATING
C2728 IOVDD.n77 VSS 0.09717f $ **FLOATING
C2729 IOVDD.n78 VSS 0.03168f $ **FLOATING
C2730 IOVDD.t140 VSS 0.02629f $ **FLOATING
C2731 IOVDD.n81 VSS 1.08104f $ **FLOATING
C2732 IOVDD.n82 VSS 0.03272f $ **FLOATING
C2733 IOVDD.n83 VSS 0.04672f $ **FLOATING
C2734 IOVDD.n85 VSS 0.05984f $ **FLOATING
C2735 IOVDD.t83 VSS 0.02216f $ **FLOATING
C2736 IOVDD.t105 VSS 0.02216f $ **FLOATING
C2737 IOVDD.n86 VSS 0.05087f $ **FLOATING
C2738 IOVDD.n87 VSS 3.07476f $ **FLOATING
C2739 IOVDD.n88 VSS 0.02421f $ **FLOATING
C2740 IOVDD.n89 VSS 0.05758f $ **FLOATING
C2741 IOVDD.n90 VSS 0.01128f $ **FLOATING
C2742 IOVDD.n91 VSS 0.02602f $ **FLOATING
C2743 IOVDD.n92 VSS 0.02163f $ **FLOATING
C2744 IOVDD.n93 VSS 0.02421f $ **FLOATING
C2745 IOVDD.n94 VSS 0.02848f $ **FLOATING
C2746 IOVDD.n95 VSS 0.02163f $ **FLOATING
C2747 IOVDD.n96 VSS 0.04863f $ **FLOATING
C2748 IOVDD.n97 VSS 0.02112f $ **FLOATING
C2749 IOVDD.t28 VSS 7.06153f $ **FLOATING
C2750 IOVDD.n99 VSS 0.01639f $ **FLOATING
C2751 IOVDD.n101 VSS 0.01639f $ **FLOATING
C2752 IOVDD.t99 VSS 0.02629f $ **FLOATING
C2753 IOVDD.t116 VSS 0.02629f $ **FLOATING
C2754 IOVDD.n103 VSS 0.05217f $ **FLOATING
C2755 IOVDD.n104 VSS 0.0466f $ **FLOATING
C2756 IOVDD.t93 VSS 0.02629f $ **FLOATING
C2757 IOVDD.n105 VSS 0.01566f $ **FLOATING
C2758 IOVDD.n106 VSS 0.02848f $ **FLOATING
C2759 IOVDD.n107 VSS 0.03275f $ **FLOATING
C2760 IOVDD.n108 VSS 0.02848f $ **FLOATING
C2761 IOVDD.n109 VSS 0.04672f $ **FLOATING
C2762 IOVDD.t92 VSS 0.16702f $ **FLOATING
C2763 IOVDD.n110 VSS 0.04672f $ **FLOATING
C2764 IOVDD.n111 VSS 0.02421f $ **FLOATING
C2765 IOVDD.n112 VSS 0.07623f $ **FLOATING
C2766 IOVDD.n113 VSS 0.07623f $ **FLOATING
C2767 IOVDD.n114 VSS 0.07623f $ **FLOATING
C2768 IOVDD.n115 VSS 0.07623f $ **FLOATING
C2769 IOVDD.n116 VSS 0.07623f $ **FLOATING
C2770 IOVDD.n117 VSS 0.07623f $ **FLOATING
C2771 IOVDD.n118 VSS 0.07623f $ **FLOATING
C2772 IOVDD.n119 VSS 0.07623f $ **FLOATING
C2773 IOVDD.n120 VSS 0.07623f $ **FLOATING
C2774 IOVDD.n121 VSS 0.07623f $ **FLOATING
C2775 IOVDD.n122 VSS 0.07623f $ **FLOATING
C2776 IOVDD.n123 VSS 0.0623f $ **FLOATING
C2777 IOVDD.n124 VSS 2.4431f $ **FLOATING
C2778 IOVDD.n125 VSS 0.04869f $ **FLOATING
C2779 IOVDD.n126 VSS 0.0203f $ **FLOATING
C2780 IOVDD.n127 VSS 0.0904f $ **FLOATING
C2781 IOVDD.n128 VSS 0.04706f $ **FLOATING
C2782 IOVDD.n129 VSS 2.62108f $ **FLOATING
C2783 IOVDD.n130 VSS 0.02195f $ **FLOATING
C2784 IOVDD.n131 VSS 0.0386f $ **FLOATING
C2785 IOVDD.n132 VSS 0.0386f $ **FLOATING
C2786 IOVDD.n133 VSS 0.07623f $ **FLOATING
C2787 IOVDD.n134 VSS 0.0386f $ **FLOATING
C2788 IOVDD.n135 VSS 0.0386f $ **FLOATING
C2789 IOVDD.n136 VSS 0.07623f $ **FLOATING
C2790 IOVDD.n137 VSS 0.0386f $ **FLOATING
C2791 IOVDD.n138 VSS 0.04542f $ **FLOATING
C2792 IOVDD.n139 VSS 0.0386f $ **FLOATING
C2793 IOVDD.n140 VSS 0.0386f $ **FLOATING
C2794 IOVDD.n141 VSS 0.07623f $ **FLOATING
C2795 IOVDD.n142 VSS 0.0386f $ **FLOATING
C2796 IOVDD.n143 VSS 0.0386f $ **FLOATING
C2797 IOVDD.n144 VSS 0.07623f $ **FLOATING
C2798 IOVDD.n145 VSS 0.0386f $ **FLOATING
C2799 IOVDD.n146 VSS 0.0386f $ **FLOATING
C2800 IOVDD.n147 VSS 0.07623f $ **FLOATING
C2801 IOVDD.n148 VSS 0.0386f $ **FLOATING
C2802 IOVDD.n149 VSS 0.0386f $ **FLOATING
C2803 IOVDD.n150 VSS 0.07623f $ **FLOATING
C2804 IOVDD.n151 VSS 0.0386f $ **FLOATING
C2805 IOVDD.n152 VSS 0.04879f $ **FLOATING
C2806 IOVDD.n153 VSS 0.0386f $ **FLOATING
C2807 IOVDD.n154 VSS 0.0386f $ **FLOATING
C2808 IOVDD.n155 VSS 0.07623f $ **FLOATING
C2809 IOVDD.n156 VSS 0.0386f $ **FLOATING
C2810 IOVDD.n157 VSS 0.0386f $ **FLOATING
C2811 IOVDD.n158 VSS 0.07623f $ **FLOATING
C2812 IOVDD.n159 VSS 0.0386f $ **FLOATING
C2813 IOVDD.n160 VSS 0.0386f $ **FLOATING
C2814 IOVDD.n161 VSS 0.07623f $ **FLOATING
C2815 IOVDD.n164 VSS 0.01125f $ **FLOATING
C2816 IOVDD.n167 VSS 0.01143f $ **FLOATING
C2817 IOVDD.t214 VSS 0.01815f $ **FLOATING
C2818 IOVDD.n169 VSS 0.04308f $ **FLOATING
C2819 IOVDD.n170 VSS 0.02104f $ **FLOATING
C2820 IOVDD.t30 VSS 0.02895f $ **FLOATING
C2821 IOVDD.n173 VSS 0.02002f $ **FLOATING
C2822 IOVDD.n174 VSS 0.01235f $ **FLOATING
C2823 IOVDD.n175 VSS 0.01235f $ **FLOATING
C2824 IOVDD.n176 VSS 0.01148f $ **FLOATING
C2825 IOVDD.n177 VSS 0.01689f $ **FLOATING
C2826 IOVDD.n178 VSS 0.05046f $ **FLOATING
C2827 IOVDD.n180 VSS 0.01624f $ **FLOATING
C2828 IOVDD.n183 VSS 0.04062f $ **FLOATING
C2829 IOVDD.n184 VSS 0.01219f $ **FLOATING
C2830 IOVDD.n185 VSS 0.04301f $ **FLOATING
C2831 IOVDD.n186 VSS 0.01975f $ **FLOATING
C2832 IOVDD.n187 VSS 0.05113f $ **FLOATING
C2833 IOVDD.n189 VSS 0.06351f $ **FLOATING
C2834 IOVDD.n190 VSS 0.04397f $ **FLOATING
C2835 IOVDD.n192 VSS 0.04652f $ **FLOATING
C2836 IOVDD.n196 VSS 0.04626f $ **FLOATING
C2837 IOVDD.n197 VSS 0.14297f $ **FLOATING
C2838 IOVDD.n198 VSS 0.08636f $ **FLOATING
C2839 IOVDD.t80 VSS 0.07169f $ **FLOATING
C2840 IOVDD.n199 VSS 0.01568f $ **FLOATING
C2841 IOVDD.n200 VSS 0.05036f $ **FLOATING
C2842 IOVDD.n201 VSS 0.0182f $ **FLOATING
C2843 IOVDD.n202 VSS 0.05121f $ **FLOATING
C2844 IOVDD.t102 VSS 0.07169f $ **FLOATING
C2845 IOVDD.n203 VSS 0.27951f $ **FLOATING
C2846 IOVDD.n204 VSS 0.03557f $ **FLOATING
C2847 IOVDD.n205 VSS 0.0386f $ **FLOATING
C2848 IOVDD.n206 VSS 0.12088f $ **FLOATING
C2849 IOVDD.t79 VSS 1.48669f $ **FLOATING
C2850 IOVDD.n207 VSS 0.03291f $ **FLOATING
C2851 IOVDD.n208 VSS 0.07779f $ **FLOATING
C2852 IOVDD.n210 VSS 0.18844f $ **FLOATING
C2853 IOVDD.n211 VSS 0.02163f $ **FLOATING
C2854 IOVDD.n212 VSS 0.01994f $ **FLOATING
C2855 IOVDD.t222 VSS 0.02728f $ **FLOATING
C2856 IOVDD.n213 VSS 0.03807f $ **FLOATING
C2857 IOVDD.t100 VSS 0.01241f $ **FLOATING
C2858 IOVDD.t117 VSS 0.01241f $ **FLOATING
C2859 IOVDD.t94 VSS 0.01241f $ **FLOATING
C2860 IOVDD.n214 VSS 0.02421f $ **FLOATING
C2861 IOVDD.n215 VSS 1.11797f $ **FLOATING
C2862 IOVDD.t225 VSS 0.02405f $ **FLOATING
C2863 IOVDD.n217 VSS 0.03031f $ **FLOATING
C2864 IOVDD.n219 VSS 0.03338f $ **FLOATING
C2865 IOVDD.t6 VSS 0.01423f $ **FLOATING
C2866 IOVDD.t5 VSS 0.01777f $ **FLOATING
C2867 IOVDD.n220 VSS 0.03528f $ **FLOATING
C2868 IOVDD.t7 VSS 0.01241f $ **FLOATING
C2869 IOVDD.t9 VSS 0.01423f $ **FLOATING
C2870 IOVDD.t10 VSS 0.01777f $ **FLOATING
C2871 IOVDD.n221 VSS 0.03715f $ **FLOATING
C2872 IOVDD.t8 VSS 0.01257f $ **FLOATING
C2873 IOVDD.n222 VSS 0.03677f $ **FLOATING
C2874 IOVDD.n223 VSS 0.02552f $ **FLOATING
C2875 IOVDD.n224 VSS 0.01028f $ **FLOATING
C2876 IOVDD.n225 VSS 0.0627f $ **FLOATING
C2877 IOVDD.n226 VSS 0.07699f $ **FLOATING
C2878 IOVDD.t60 VSS 0.02629f $ **FLOATING
C2879 IOVDD.n228 VSS 0.0308f $ **FLOATING
C2880 IOVDD.t172 VSS 0.01241f $ **FLOATING
C2881 IOVDD.n229 VSS 0.0396f $ **FLOATING
C2882 IOVDD.n230 VSS 0.01465f $ **FLOATING
C2883 IOVDD.t221 VSS 0.01659f $ **FLOATING
C2884 IOVDD.n231 VSS 0.08059f $ **FLOATING
C2885 IOVDD.t128 VSS 0.02629f $ **FLOATING
C2886 IOVDD.n232 VSS 0.03388f $ **FLOATING
C2887 IOVDD.n233 VSS 0.01615f $ **FLOATING
C2888 IOVDD.t129 VSS 0.01241f $ **FLOATING
C2889 IOVDD.n234 VSS 0.0396f $ **FLOATING
C2890 IOVDD.n235 VSS 0.0484f $ **FLOATING
C2891 IOVDD.t59 VSS 0.16702f $ **FLOATING
C2892 IOVDD.n236 VSS 0.0484f $ **FLOATING
C2893 IOVDD.n237 VSS 0.0396f $ **FLOATING
C2894 IOVDD.t141 VSS 0.01241f $ **FLOATING
C2895 IOVDD.n238 VSS 0.02332f $ **FLOATING
C2896 IOVDD.n239 VSS 0.2566f $ **FLOATING
C2897 IOVDD.n240 VSS 0.1501f $ **FLOATING
C2898 IOVDD.n241 VSS 0.11136f $ **FLOATING
C2899 IOVDD.n242 VSS 0.11136f $ **FLOATING
C2900 IOVDD.n243 VSS 0.11136f $ **FLOATING
C2901 IOVDD.n244 VSS 0.11397f $ **FLOATING
C2902 IOVDD.n245 VSS 0.11136f $ **FLOATING
C2903 IOVDD.n246 VSS 0.11397f $ **FLOATING
C2904 IOVDD.n247 VSS 0.05741f $ **FLOATING
C2905 IOVDD.n248 VSS 0.11397f $ **FLOATING
C2906 IOVDD.n249 VSS 0.05741f $ **FLOATING
C2907 IOVDD.n250 VSS 0.11136f $ **FLOATING
C2908 IOVDD.n251 VSS 0.06396f $ **FLOATING
C2909 IOVDD.n252 VSS 0.11094f $ **FLOATING
C2910 IOVDD.n253 VSS 0.08921f $ **FLOATING
C2911 IOVDD.n254 VSS 0.19726f $ **FLOATING
C2912 IOVDD.n255 VSS 0.11379f $ **FLOATING
C2913 IOVDD.n256 VSS 0.11136f $ **FLOATING
C2914 IOVDD.n257 VSS 0.11136f $ **FLOATING
C2915 IOVDD.n258 VSS 0.08704f $ **FLOATING
C2916 IOVDD.n259 VSS 0.11136f $ **FLOATING
C2917 IOVDD.n260 VSS 0.11136f $ **FLOATING
C2918 IOVDD.n261 VSS 0.11136f $ **FLOATING
C2919 IOVDD.n262 VSS 0.11136f $ **FLOATING
C2920 IOVDD.n263 VSS 0.11136f $ **FLOATING
C2921 IOVDD.n264 VSS 0.11337f $ **FLOATING
C2922 IOVDD.t67 VSS 1.48669f $ **FLOATING
C2923 IOVDD.n265 VSS 0.0938f $ **FLOATING
C2924 IOVDD.n266 VSS 0.05404f $ **FLOATING
C2925 IOVDD.t68 VSS 0.07169f $ **FLOATING
C2926 IOVDD.n267 VSS 0.05404f $ **FLOATING
C2927 IOVDD.n268 VSS 0.01689f $ **FLOATING
C2928 IOVDD.n269 VSS 1.17842f $ **FLOATING
C2929 IOVDD.n270 VSS 0.02364f $ **FLOATING
C2930 IOVDD.n271 VSS 5.07399f $ **FLOATING
C2931 IOVDD.n272 VSS 0.45153f $ **FLOATING
C2932 IOVDD.n273 VSS 0.0726f $ **FLOATING
C2933 IOVDD.n274 VSS 0.06542f $ **FLOATING
C2934 IOVDD.t2 VSS 0.02883f $ **FLOATING
C2935 IOVDD.n275 VSS 0.09709f $ **FLOATING
C2936 IOVDD.n276 VSS 0.03531f $ **FLOATING
C2937 IOVDD.n277 VSS 0.08116f $ **FLOATING
C2938 IOVDD.t1 VSS 1.26687f $ **FLOATING
C2939 IOVDD.n282 VSS 0.09836f $ **FLOATING
C2940 IOVDD.n283 VSS 0.10853f $ **FLOATING
C2941 IOVDD.n287 VSS 0.30898f $ **FLOATING
C2942 IOVDD.n291 VSS 0.05051f $ **FLOATING
C2943 IOVDD.n292 VSS 0.08233f $ **FLOATING
C2944 IOVDD.n296 VSS 0.17979f $ **FLOATING
C2945 IOVDD.n302 VSS 0.01921f $ **FLOATING
C2946 IOVDD.n304 VSS 0.05051f $ **FLOATING
C2947 IOVDD.n305 VSS 0.01847f $ **FLOATING
C2948 IOVDD.n306 VSS 0.01847f $ **FLOATING
C2949 IOVDD.n307 VSS 0.01547f $ **FLOATING
C2950 IOVDD.n308 VSS 0.01946f $ **FLOATING
C2951 IOVDD.n309 VSS 0.0207f $ **FLOATING
C2952 IOVDD.n311 VSS 0.78091f $ **FLOATING
C2953 IOVDD.n319 VSS 0.04363f $ **FLOATING
C2954 IOVDD.n320 VSS 0.01637f $ **FLOATING
C2955 IOVDD.t217 VSS 0.01387f $ **FLOATING
C2956 IOVDD.t218 VSS 0.01536f $ **FLOATING
C2957 IOVDD.n322 VSS 0.01655f $ **FLOATING
C2958 IOVDD.n324 VSS 0.02082f $ **FLOATING
C2959 IOVDD.n325 VSS 0.01609f $ **FLOATING
C2960 IOVDD.n327 VSS 0.03755f $ **FLOATING
C2961 IOVDD.n328 VSS 0.03811f $ **FLOATING
C2962 IOVDD.t85 VSS 0.02629f $ **FLOATING
C2963 IOVDD.n330 VSS 0.04035f $ **FLOATING
C2964 IOVDD.n331 VSS 0.05773f $ **FLOATING
C2965 IOVDD.n332 VSS 0.03811f $ **FLOATING
C2966 IOVDD.n333 VSS 0.05661f $ **FLOATING
C2967 IOVDD.n334 VSS 0.03811f $ **FLOATING
C2968 IOVDD.t73 VSS 0.09519f $ **FLOATING
C2969 IOVDD.n335 VSS 0.02018f $ **FLOATING
C2970 IOVDD.n336 VSS 0.01849f $ **FLOATING
C2971 IOVDD.t74 VSS 0.02629f $ **FLOATING
C2972 IOVDD.n337 VSS 0.03811f $ **FLOATING
C2973 IOVDD.n338 VSS 0.07398f $ **FLOATING
C2974 IOVDD.t58 VSS 0.01241f $ **FLOATING
C2975 IOVDD.n340 VSS 0.04708f $ **FLOATING
C2976 IOVDD.t188 VSS 0.01241f $ **FLOATING
C2977 IOVDD.n341 VSS 0.02746f $ **FLOATING
C2978 IOVDD.n342 VSS 0.08659f $ **FLOATING
C2979 IOVDD.n343 VSS 0.04259f $ **FLOATING
C2980 IOVDD.n344 VSS 0.02578f $ **FLOATING
C2981 IOVDD.n345 VSS 0.03811f $ **FLOATING
C2982 IOVDD.t15 VSS 0.02972f $ **FLOATING
C2983 IOVDD.n348 VSS 0.14096f $ **FLOATING
C2984 IOVDD.n349 VSS 0.02156f $ **FLOATING
C2985 IOVDD.t25 VSS 0.66212f $ **FLOATING
C2986 IOVDD.t0 VSS 2.42258f $ **FLOATING
C2987 IOVDD.n351 VSS 0.02648f $ **FLOATING
C2988 IOVDD.t87 VSS 0.26485f $ **FLOATING
C2989 IOVDD.t12 VSS 0.02972f $ **FLOATING
C2990 IOVDD.n352 VSS 0.05725f $ **FLOATING
C2991 IOVDD.n353 VSS 0.02142f $ **FLOATING
C2992 IOVDD.n354 VSS 0.26485f $ **FLOATING
C2993 IOVDD.t20 VSS 0.66212f $ **FLOATING
C2994 IOVDD.t154 VSS 0.39727f $ **FLOATING
C2995 IOVDD.n356 VSS 0.03201f $ **FLOATING
C2996 IOVDD.t21 VSS 0.02972f $ **FLOATING
C2997 IOVDD.n357 VSS 0.05667f $ **FLOATING
C2998 IOVDD.n358 VSS 0.03046f $ **FLOATING
C2999 IOVDD.t26 VSS 0.26485f $ **FLOATING
C3000 IOVDD.t11 VSS 0.26485f $ **FLOATING
C3001 IOVDD.n364 VSS 0.04259f $ **FLOATING
C3002 IOVDD.t86 VSS 0.01241f $ **FLOATING
C3003 IOVDD.t75 VSS 0.01241f $ **FLOATING
C3004 IOVDD.n365 VSS 0.01345f $ **FLOATING
C3005 IOVDD.n366 VSS 0.7949f $ **FLOATING
C3006 IOVDD.n367 VSS 0.0304f $ **FLOATING
C3007 IOVDD.n368 VSS 0.16082f $ **FLOATING
C3008 IOVDD.n369 VSS 0.03267f $ **FLOATING
C3009 IOVDD.t71 VSS 0.07729f $ **FLOATING
C3010 IOVDD.n370 VSS 0.02923f $ **FLOATING
C3011 IOVDD.n371 VSS 0.03224f $ **FLOATING
C3012 IOVDD.n372 VSS 0.02923f $ **FLOATING
C3013 IOVDD.n373 VSS 0.03267f $ **FLOATING
C3014 IOVDD.n374 VSS 0.02923f $ **FLOATING
C3015 IOVDD.n375 VSS 0.03224f $ **FLOATING
C3016 IOVDD.n376 VSS 0.02923f $ **FLOATING
C3017 IOVDD.n377 VSS 0.03267f $ **FLOATING
C3018 IOVDD.n378 VSS 0.02923f $ **FLOATING
C3019 IOVDD.n379 VSS 0.03267f $ **FLOATING
C3020 IOVDD.t133 VSS 0.07729f $ **FLOATING
C3021 IOVDD.n380 VSS 0.02923f $ **FLOATING
C3022 IOVDD.n381 VSS 0.03224f $ **FLOATING
C3023 IOVDD.n382 VSS 0.02923f $ **FLOATING
C3024 IOVDD.n383 VSS 0.03267f $ **FLOATING
C3025 IOVDD.n384 VSS 0.02923f $ **FLOATING
C3026 IOVDD.n385 VSS 0.03224f $ **FLOATING
C3027 IOVDD.n386 VSS 0.02923f $ **FLOATING
C3028 IOVDD.n387 VSS 0.03267f $ **FLOATING
C3029 IOVDD.n388 VSS 0.02923f $ **FLOATING
C3030 IOVDD.n389 VSS 0.03224f $ **FLOATING
C3031 IOVDD.t91 VSS 0.0365f $ **FLOATING
C3032 IOVDD.n390 VSS 0.02923f $ **FLOATING
C3033 IOVDD.n391 VSS 0.02923f $ **FLOATING
C3034 IOVDD.n393 VSS 0.03224f $ **FLOATING
C3035 IOVDD.t126 VSS 0.0365f $ **FLOATING
C3036 IOVDD.n394 VSS 0.02923f $ **FLOATING
C3037 IOVDD.n395 VSS 0.02923f $ **FLOATING
C3038 IOVDD.n397 VSS 0.04428f $ **FLOATING
C3039 IOVDD.n398 VSS 0.03811f $ **FLOATING
C3040 IOVDD.n399 VSS 0.03811f $ **FLOATING
C3041 IOVDD.t56 VSS 0.09519f $ **FLOATING
C3042 IOVDD.t57 VSS 0.02629f $ **FLOATING
C3043 IOVDD.n401 VSS 0.0538f $ **FLOATING
C3044 IOVDD.n402 VSS 0.31681f $ **FLOATING
C3045 IOVDD.t165 VSS 0.02629f $ **FLOATING
C3046 IOVDD.n403 VSS 0.01233f $ **FLOATING
C3047 IOVDD.n404 VSS 0.111f $ **FLOATING
C3048 IOVDD.n405 VSS 0.06489f $ **FLOATING
C3049 IOVDD.n406 VSS 0.09797f $ **FLOATING
C3050 IOVDD.n407 VSS 0.03224f $ **FLOATING
C3051 IOVDD.n408 VSS 0.02923f $ **FLOATING
C3052 IOVDD.n409 VSS 0.03267f $ **FLOATING
C3053 IOVDD.n410 VSS 0.02923f $ **FLOATING
C3054 IOVDD.n411 VSS 0.03267f $ **FLOATING
C3055 IOVDD.n412 VSS 0.03224f $ **FLOATING
C3056 IOVDD.n413 VSS 0.0171f $ **FLOATING
C3057 IOVDD.n414 VSS 0.02923f $ **FLOATING
C3058 IOVDD.n415 VSS 0.03267f $ **FLOATING
C3059 IOVDD.n416 VSS 0.03224f $ **FLOATING
C3060 IOVDD.n417 VSS 0.02923f $ **FLOATING
C3061 IOVDD.t114 VSS 0.06019f $ **FLOATING
C3062 IOVDD.n418 VSS 0.05726f $ **FLOATING
C3063 IOVDD.n419 VSS 0.04631f $ **FLOATING
C3064 IOVDD.t89 VSS 0.4902f $ **FLOATING
C3065 IOVDD.n420 VSS 0.07804f $ **FLOATING
C3066 IOVDD.n421 VSS 0.05004f $ **FLOATING
C3067 IOVDD.n422 VSS 0.05726f $ **FLOATING
C3068 IOVDD.n423 VSS 0.03224f $ **FLOATING
C3069 IOVDD.n424 VSS 0.02923f $ **FLOATING
C3070 IOVDD.n425 VSS 0.03267f $ **FLOATING
C3071 IOVDD.n426 VSS 0.02923f $ **FLOATING
C3072 IOVDD.n427 VSS 0.03267f $ **FLOATING
C3073 IOVDD.n428 VSS 0.03224f $ **FLOATING
C3074 IOVDD.n429 VSS 0.0171f $ **FLOATING
C3075 IOVDD.n430 VSS 0.02923f $ **FLOATING
C3076 IOVDD.n431 VSS 0.03267f $ **FLOATING
C3077 IOVDD.n432 VSS 0.03224f $ **FLOATING
C3078 IOVDD.n433 VSS 0.02923f $ **FLOATING
C3079 IOVDD.t90 VSS 0.06019f $ **FLOATING
C3080 IOVDD.n434 VSS 0.30483f $ **FLOATING
C3081 IOVDD.n435 VSS 0.03418f $ **FLOATING
C3082 IOVDD.n436 VSS 0.30476f $ **FLOATING
C3083 IOVDD.n437 VSS 0.03224f $ **FLOATING
C3084 IOVDD.n438 VSS 0.03224f $ **FLOATING
C3085 IOVDD.n439 VSS 0.02923f $ **FLOATING
C3086 IOVDD.t134 VSS 0.0365f $ **FLOATING
C3087 IOVDD.n440 VSS 0.05726f $ **FLOATING
C3088 IOVDD.n441 VSS 0.05098f $ **FLOATING
C3089 IOVDD.t70 VSS 0.4902f $ **FLOATING
C3090 IOVDD.n442 VSS 0.07525f $ **FLOATING
C3091 IOVDD.n443 VSS 0.04815f $ **FLOATING
C3092 IOVDD.n444 VSS 0.05726f $ **FLOATING
C3093 IOVDD.n445 VSS 0.03224f $ **FLOATING
C3094 IOVDD.n446 VSS 0.03224f $ **FLOATING
C3095 IOVDD.n447 VSS 0.02923f $ **FLOATING
C3096 IOVDD.t72 VSS 0.0365f $ **FLOATING
C3097 IOVDD.n448 VSS 0.09565f $ **FLOATING
C3098 IOVDD.n449 VSS 0.06698f $ **FLOATING
C3099 IOVDD.n450 VSS 0.5297f $ **FLOATING
C3100 IOVDD.n452 VSS 0.01986f $ **FLOATING
C3101 IOVDD.n454 VSS 0.01986f $ **FLOATING
C3102 IOVDD.n456 VSS 0.01986f $ **FLOATING
C3103 IOVDD.n458 VSS 0.01986f $ **FLOATING
C3104 IOVDD.n462 VSS 0.03648f $ **FLOATING
C3105 IOVDD.t65 VSS 0.02629f $ **FLOATING
C3106 IOVDD.t66 VSS 0.01241f $ **FLOATING
C3107 IOVDD.t143 VSS 0.02629f $ **FLOATING
C3108 IOVDD.n463 VSS 0.03648f $ **FLOATING
C3109 IOVDD.t136 VSS 0.02629f $ **FLOATING
C3110 IOVDD.t156 VSS 0.01241f $ **FLOATING
C3111 IOVDD.t193 VSS 0.01241f $ **FLOATING
C3112 IOVDD.n464 VSS 0.08056f $ **FLOATING
C3113 IOVDD.n465 VSS 0.11614f $ **FLOATING
C3114 IOVDD.n466 VSS 0.03648f $ **FLOATING
C3115 IOVDD.n467 VSS 0.03544f $ **FLOATING
C3116 IOVDD.t167 VSS 0.02629f $ **FLOATING
C3117 IOVDD.n468 VSS 0.03544f $ **FLOATING
C3118 IOVDD.n469 VSS 0.05733f $ **FLOATING
C3119 IOVDD.t135 VSS 0.09519f $ **FLOATING
C3120 IOVDD.t64 VSS 0.09519f $ **FLOATING
C3121 IOVDD.n470 VSS 0.06046f $ **FLOATING
C3122 IOVDD.n471 VSS 0.05733f $ **FLOATING
C3123 IOVDD.n472 VSS 0.03544f $ **FLOATING
C3124 IOVDD.n473 VSS 0.03648f $ **FLOATING
C3125 IOVDD.n474 VSS 0.03544f $ **FLOATING
C3126 IOVDD.t163 VSS 0.01241f $ **FLOATING
C3127 IOVDD.n475 VSS 0.14116f $ **FLOATING
C3128 IOVDD.n476 VSS 0.07647f $ **FLOATING
C3129 IOVDD.n478 VSS 0.13366f $ **FLOATING
C3130 IOVDD.n480 VSS 0.01986f $ **FLOATING
C3131 IOVDD.n481 VSS 0.0417f $ **FLOATING
C3132 IOVDD.n482 VSS 0.01986f $ **FLOATING
C3133 IOVDD.t16 VSS 1.32424f $ **FLOATING
C3134 IOVDD.t4 VSS 0.65433f $ **FLOATING
C3135 IOVDD.t22 VSS 0.02972f $ **FLOATING
C3136 IOVDD.n485 VSS 0.05669f $ **FLOATING
C3137 IOVDD.n486 VSS 0.02159f $ **FLOATING
C3138 IOVDD.t13 VSS 0.02972f $ **FLOATING
C3139 IOVDD.n487 VSS 0.05991f $ **FLOATING
C3140 IOVDD.n488 VSS 0.02617f $ **FLOATING
C3141 IOVDD.t17 VSS 0.02972f $ **FLOATING
C3142 IOVDD.n489 VSS 0.05158f $ **FLOATING
C3143 IOVDD.t19 VSS 0.02972f $ **FLOATING
C3144 IOVDD.n490 VSS 0.05698f $ **FLOATING
C3145 IOVDD.n491 VSS 0.02651f $ **FLOATING
C3146 IOVDD.t14 VSS 0.79454f $ **FLOATING
C3147 IOVDD.t18 VSS 1.26577f $ **FLOATING
C3148 IOVDD.n494 VSS 0.88727f $ **FLOATING
C3149 IOVDD.n495 VSS 0.47345f $ **FLOATING
C3150 IOVDD.n497 VSS 0.18051f $ **FLOATING
C3151 IOVDD.n498 VSS 0.02121f $ **FLOATING
C3152 IOVDD.n499 VSS 0.03092f $ **FLOATING
C3153 IOVDD.n500 VSS 0.40978f $ **FLOATING
C3154 IOVDD.n501 VSS 0.10033f $ **FLOATING
C3155 IOVDD.n502 VSS 0.03664f $ **FLOATING
C3156 IOVDD.n503 VSS 0.03133f $ **FLOATING
C3157 IOVDD.t42 VSS 0.03943f $ **FLOATING
C3158 IOVDD.n504 VSS 0.03255f $ **FLOATING
C3159 IOVDD.n505 VSS 0.04763f $ **FLOATING
C3160 IOVDD.t49 VSS 0.03943f $ **FLOATING
C3161 IOVDD.n506 VSS 0.03189f $ **FLOATING
C3162 IOVDD.n507 VSS 0.0157f $ **FLOATING
C3163 IOVDD.n508 VSS 0.04984f $ **FLOATING
C3164 IOVDD.t33 VSS 0.03136f $ **FLOATING
C3165 IOVDD.n509 VSS 0.0157f $ **FLOATING
C3166 IOVDD.n511 VSS 0.03143f $ **FLOATING
C3167 IOVDD.n512 VSS 0.01006f $ **FLOATING
C3168 IOVDD.n513 VSS 0.0324f $ **FLOATING
C3169 IOVDD.t120 VSS 0.13582f $ **FLOATING
C3170 IOVDD.n514 VSS 0.0301f $ **FLOATING
C3171 IOVDD.n515 VSS 0.03009f $ **FLOATING
C3172 IOVDD.n516 VSS 0.03133f $ **FLOATING
C3173 IOVDD.n517 VSS 0.11375f $ **FLOATING
C3174 IOVDD.t45 VSS 0.03943f $ **FLOATING
C3175 IOVDD.n518 VSS 0.02421f $ **FLOATING
C3176 IOVDD.n519 VSS 0.63952f $ **FLOATING
C3177 IOVDD.n520 VSS 0.04466f $ **FLOATING
C3178 IOVDD.t36 VSS 0.02353f $ **FLOATING
C3179 IOVDD.t39 VSS 0.02081f $ **FLOATING
C3180 IOVDD.n521 VSS 0.02006f $ **FLOATING
C3181 IOVDD.t37 VSS 0.02081f $ **FLOATING
C3182 IOVDD.n522 VSS 0.01227f $ **FLOATING
C3183 IOVDD.t38 VSS 0.02081f $ **FLOATING
C3184 IOVDD.n524 VSS 0.12771f $ **FLOATING
C3185 IOVDD.n525 VSS 0.05263f $ **FLOATING
C3186 IOVDD.t32 VSS 0.02353f $ **FLOATING
C3187 IOVDD.t47 VSS 0.02081f $ **FLOATING
C3188 IOVDD.n526 VSS 0.02006f $ **FLOATING
C3189 IOVDD.t41 VSS 0.02081f $ **FLOATING
C3190 IOVDD.n527 VSS 0.01227f $ **FLOATING
C3191 IOVDD.t43 VSS 0.02081f $ **FLOATING
C3192 IOVDD.n529 VSS 0.1285f $ **FLOATING
C3193 IOVDD.n530 VSS 0.04466f $ **FLOATING
C3194 IOVDD.n531 VSS 0.03698f $ **FLOATING
C3195 IOVDD.n532 VSS 0.15137f $ **FLOATING
C3196 IOVDD.n533 VSS 0.01661f $ **FLOATING
C3197 IOVDD.t179 VSS 0.01862f $ **FLOATING
C3198 IOVDD.n536 VSS 0.01519f $ **FLOATING
C3199 IOVDD.t46 VSS 0.02081f $ **FLOATING
C3200 IOVDD.n537 VSS 0.01604f $ **FLOATING
C3201 IOVDD.n538 VSS 0.01709f $ **FLOATING
C3202 IOVDD.n540 VSS 0.01623f $ **FLOATING
C3203 IOVDD.t78 VSS 0.01862f $ **FLOATING
C3204 IOVDD.n542 VSS 0.01519f $ **FLOATING
C3205 IOVDD.t54 VSS 0.02081f $ **FLOATING
C3206 IOVDD.n543 VSS 0.01585f $ **FLOATING
C3207 IOVDD.t35 VSS 0.02081f $ **FLOATING
C3208 IOVDD.n544 VSS 0.02657f $ **FLOATING
C3209 IOVDD.n545 VSS 0.03227f $ **FLOATING
C3210 IOVDD.n546 VSS 0.04984f $ **FLOATING
C3211 IOVDD.n547 VSS 0.01847f $ **FLOATING
C3212 IOVDD.n548 VSS 0.0157f $ **FLOATING
C3213 IOVDD.n549 VSS 0.01547f $ **FLOATING
C3214 IOVDD.n550 VSS 0.01847f $ **FLOATING
C3215 IOVDD.n551 VSS 0.0157f $ **FLOATING
C3216 IOVDD.t108 VSS 0.01862f $ **FLOATING
C3217 IOVDD.n552 VSS 0.01006f $ **FLOATING
C3218 IOVDD.n553 VSS 0.01709f $ **FLOATING
C3219 IOVDD.t61 VSS 0.13582f $ **FLOATING
C3220 IOVDD.n554 VSS 0.0149f $ **FLOATING
C3221 IOVDD.t63 VSS 0.01862f $ **FLOATING
C3222 IOVDD.n556 VSS 0.01801f $ **FLOATING
C3223 IOVDD.t51 VSS 0.02084f $ **FLOATING
C3224 IOVDD.n557 VSS 0.03715f $ **FLOATING
C3225 IOVDD.n558 VSS 0.04553f $ **FLOATING
C3226 IOVDD.n559 VSS 0.21753f $ **FLOATING
C3227 IOVDD.t31 VSS 6.92025f $ **FLOATING
C3228 IOVDD.n560 VSS 0.07076f $ **FLOATING
C3229 IOVDD.n561 VSS 0.02317f $ **FLOATING
C3230 IOVDD.n562 VSS 0.08134f $ **FLOATING
C3231 IOVDD.n566 VSS 0.61341f $ **FLOATING
C3232 IOVDD.n568 VSS 0.01862f $ **FLOATING
C3233 IOVDD.n569 VSS 0.03201f $ **FLOATING
C3234 IOVDD.n570 VSS 0.05802f $ **FLOATING
C3235 IOVDD.n571 VSS 0.06359f $ **FLOATING
C3236 IOVDD.n572 VSS 0.03576f $ **FLOATING
C3237 IOVDD.n573 VSS 0.07459f $ **FLOATING
C3238 IOVDD.n574 VSS 0.06559f $ **FLOATING
C3239 IOVDD.n575 VSS 0.09757f $ **FLOATING
C3240 non_inverting_amplifier_hv_0.ota_hv_slow_gmid_0.ota_hv_slow_gmid_pairs_0.vota VSS 0.16865f $ **FLOATING
C3241 non_inverting_amplifier_hv_0.ota_hv_slow_gmid_0.vota.t1 VSS 0.04018f $ **FLOATING
C3242 non_inverting_amplifier_hv_0.ota_hv_slow_gmid_0.vota.t0 VSS 0.04809f $ **FLOATING
C3243 non_inverting_amplifier_hv_0.ota_hv_slow_gmid_0.vota.n0 VSS 0.10144f $ **FLOATING
C3244 non_inverting_amplifier_hv_0.ota_hv_slow_gmid_0.vota.n1 VSS 0.01483f $ **FLOATING
C3245 non_inverting_amplifier_hv_0.ota_hv_slow_gmid_0.ota_hv_slow_gmid_mirror_0.vota VSS 0.06047f $ **FLOATING
C3246 non_inverting_amplifier_hv_0.ota_hv_slow_gmid_0.vota.t6 VSS 3.70592f $ **FLOATING
C3247 non_inverting_amplifier_hv_0.ota_hv_slow_gmid_0.vota.t3 VSS 0.06314f $ **FLOATING
C3248 non_inverting_amplifier_hv_0.ota_hv_slow_gmid_0.vota.t4 VSS 3.81066f $ **FLOATING
C3249 non_inverting_amplifier_hv_0.ota_hv_slow_gmid_0.vota.n2 VSS 0.12301f $ **FLOATING
C3250 non_inverting_amplifier_hv_0.ota_hv_slow_gmid_0.vota.t2 VSS 0.16527f $ **FLOATING
C3251 non_inverting_amplifier_hv_0.ota_hv_slow_gmid_0.vota.n3 VSS 0.19045f $ **FLOATING
C3252 non_inverting_amplifier_hv_0.ota_hv_slow_gmid_0.vota.n4 VSS 0.08739f $ **FLOATING
C3253 non_inverting_amplifier_hv_0.ota_hv_slow_gmid_0.vota.n5 VSS 0.05226f $ **FLOATING
C3254 non_inverting_amplifier_hv_0.ota_hv_slow_gmid_0.vota.t5 VSS 31.1134f $ **FLOATING
C3255 non_inverting_amplifier_hv_0.ota_hv_slow_gmid_0.vota.n6 VSS 0.35487f $ **FLOATING
C3256 VAMP.t0 VSS 0.645f $ **FLOATING
C3257 VAMP.t10 VSS 0.06079f $ **FLOATING
C3258 VAMP.t53 VSS 0.06079f $ **FLOATING
C3259 VAMP.n0 VSS 1.12554f $ **FLOATING
C3260 VAMP.t23 VSS 0.06079f $ **FLOATING
C3261 VAMP.t13 VSS 0.06079f $ **FLOATING
C3262 VAMP.n1 VSS 0.40716f $ **FLOATING
C3263 VAMP.t6 VSS 0.06079f $ **FLOATING
C3264 VAMP.t49 VSS 0.06079f $ **FLOATING
C3265 VAMP.n2 VSS 0.29376f $ **FLOATING
C3266 VAMP.t59 VSS 0.06079f $ **FLOATING
C3267 VAMP.n3 VSS 0.08295f $ **FLOATING
C3268 VAMP.t45 VSS 0.06079f $ **FLOATING
C3269 VAMP.t29 VSS 0.06079f $ **FLOATING
C3270 VAMP.n4 VSS 0.29376f $ **FLOATING
C3271 VAMP.t11 VSS 0.06079f $ **FLOATING
C3272 VAMP.t55 VSS 0.06079f $ **FLOATING
C3273 VAMP.n5 VSS 0.31046f $ **FLOATING
C3274 VAMP.t25 VSS 0.06079f $ **FLOATING
C3275 VAMP.t2 VSS 0.06079f $ **FLOATING
C3276 VAMP.t12 VSS 0.06079f $ **FLOATING
C3277 VAMP.t60 VSS 0.06079f $ **FLOATING
C3278 VAMP.t47 VSS 0.06079f $ **FLOATING
C3279 VAMP.t28 VSS 0.06079f $ **FLOATING
C3280 VAMP.t24 VSS 0.06079f $ **FLOATING
C3281 VAMP.t51 VSS 0.06079f $ **FLOATING
C3282 VAMP.t58 VSS 0.06079f $ **FLOATING
C3283 VAMP.t31 VSS 0.06152f $ **FLOATING
C3284 VAMP.n6 VSS 0.14449f $ **FLOATING
C3285 VAMP.t19 VSS 0.06079f $ **FLOATING
C3286 VAMP.n7 VSS 0.08083f $ **FLOATING
C3287 VAMP.t54 VSS 0.06079f $ **FLOATING
C3288 VAMP.t14 VSS 0.06079f $ **FLOATING
C3289 VAMP.n8 VSS 0.29376f $ **FLOATING
C3290 VAMP.t16 VSS 0.06079f $ **FLOATING
C3291 VAMP.t33 VSS 0.06079f $ **FLOATING
C3292 VAMP.n9 VSS 0.40716f $ **FLOATING
C3293 VAMP.t35 VSS 0.06079f $ **FLOATING
C3294 VAMP.t7 VSS 0.06079f $ **FLOATING
C3295 VAMP.n10 VSS 0.40716f $ **FLOATING
C3296 VAMP.t4 VSS 0.06079f $ **FLOATING
C3297 VAMP.t21 VSS 0.06079f $ **FLOATING
C3298 VAMP.n11 VSS 0.40716f $ **FLOATING
C3299 VAMP.t44 VSS 0.06079f $ **FLOATING
C3300 VAMP.t40 VSS 0.06079f $ **FLOATING
C3301 VAMP.n12 VSS 0.40716f $ **FLOATING
C3302 VAMP.t56 VSS 0.06079f $ **FLOATING
C3303 VAMP.t18 VSS 0.06079f $ **FLOATING
C3304 VAMP.n13 VSS 0.40716f $ **FLOATING
C3305 VAMP.t8 VSS 0.06079f $ **FLOATING
C3306 VAMP.t36 VSS 0.06079f $ **FLOATING
C3307 VAMP.n14 VSS 0.40716f $ **FLOATING
C3308 VAMP.t37 VSS 0.06079f $ **FLOATING
C3309 VAMP.t5 VSS 0.06079f $ **FLOATING
C3310 VAMP.n15 VSS 0.40716f $ **FLOATING
C3311 VAMP.t1 VSS 0.06079f $ **FLOATING
C3312 VAMP.t46 VSS 0.06079f $ **FLOATING
C3313 VAMP.n16 VSS 0.40716f $ **FLOATING
C3314 VAMP.t22 VSS 0.06079f $ **FLOATING
C3315 VAMP.t43 VSS 0.06079f $ **FLOATING
C3316 VAMP.n17 VSS 0.29376f $ **FLOATING
C3317 VAMP.t26 VSS 0.06079f $ **FLOATING
C3318 VAMP.n18 VSS 0.08295f $ **FLOATING
C3319 VAMP.t52 VSS 0.06079f $ **FLOATING
C3320 VAMP.t3 VSS 0.06079f $ **FLOATING
C3321 VAMP.n19 VSS 0.29376f $ **FLOATING
C3322 VAMP.t15 VSS 0.06079f $ **FLOATING
C3323 VAMP.t41 VSS 0.06079f $ **FLOATING
C3324 VAMP.n20 VSS 0.40716f $ **FLOATING
C3325 VAMP.t34 VSS 0.06079f $ **FLOATING
C3326 VAMP.t42 VSS 0.06079f $ **FLOATING
C3327 VAMP.n21 VSS 0.49512f $ **FLOATING
C3328 VAMP.t50 VSS 0.06079f $ **FLOATING
C3329 VAMP.n22 VSS 0.23438f $ **FLOATING
C3330 VAMP.t38 VSS 0.06079f $ **FLOATING
C3331 VAMP.n23 VSS 0.16354f $ **FLOATING
C3332 VAMP.t9 VSS 0.06079f $ **FLOATING
C3333 VAMP.n24 VSS 0.08083f $ **FLOATING
C3334 VAMP.t39 VSS 0.06079f $ **FLOATING
C3335 VAMP.n25 VSS 0.29376f $ **FLOATING
C3336 VAMP.t20 VSS 0.06079f $ **FLOATING
C3337 VAMP.n26 VSS 0.40716f $ **FLOATING
C3338 VAMP.t48 VSS 0.06079f $ **FLOATING
C3339 VAMP.n27 VSS 0.40716f $ **FLOATING
C3340 VAMP.t57 VSS 0.06079f $ **FLOATING
C3341 VAMP.n28 VSS 0.40716f $ **FLOATING
C3342 VAMP.t30 VSS 0.06079f $ **FLOATING
C3343 VAMP.n29 VSS 0.40716f $ **FLOATING
C3344 VAMP.t27 VSS 0.06079f $ **FLOATING
C3345 VAMP.n30 VSS 0.40716f $ **FLOATING
C3346 VAMP.t32 VSS 0.06079f $ **FLOATING
C3347 VAMP.n31 VSS 0.40716f $ **FLOATING
C3348 VAMP.t17 VSS 0.06079f $ **FLOATING
C3349 VAMP.n32 VSS 0.30028f $ **FLOATING
C3350 VAMP.n33 VSS 0.3529f $ **FLOATING
C3351 two_stage_instrumentation_amplifier_0.ota_slow_gmid_0.VOUT VSS 1.27706f $ **FLOATING
C3352 VAMP.t62 VSS 3.58918f $ **FLOATING
C3353 VAMP.t63 VSS 3.60304f $ **FLOATING
C3354 VAMP.n34 VSS 1.28288f $ **FLOATING
C3355 non_inverting_amplifier_hv_0.ota_hv_slow_gmid_0.ota_hv_slow_gmid_pairs_0.vp VSS 10.0286f $ **FLOATING
C3356 VAMP.t65 VSS 7.82945f $ **FLOATING
C3357 VAMP.t64 VSS 7.37294f $ **FLOATING
C3358 VAMP.n35 VSS 1.36875f $ **FLOATING
C3359 ota_lv_gmid_comparator_0.ota_slow_gmid_common_0/ota_slow_gmid_pairs_0.vp VSS 0.59689f $ **FLOATING
C3360 VAMP.n36 VSS 0.12054f $ **FLOATING
C3361 VAMP.n37 VSS 1.2639f $ **FLOATING
C3362 VAMP.n38 VSS 16.2445f $ **FLOATING
C3363 two_stage_instrumentation_amplifier_0.VOUT VSS 3.35985f $ **FLOATING
C3364 VAMP.n39 VSS 7.73612f $ **FLOATING
C3365 VAMP.t61 VSS 0.15645f $ **FLOATING
C3366 two_stage_instrumentation_amplifier_0.top_conditionning_gain_s2_0.vamp VSS 0.64008f $ **FLOATING
C3367 VAMP.n40 VSS 1.64599f $ **FLOATING
C3368 two_stage_instrumentation_amplifier_0.ota_slow_gmid_0.ota_slow_gmid_buffer_0.vout VSS 0.35116f $ **FLOATING
.ends
