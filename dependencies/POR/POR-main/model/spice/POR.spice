* NGSPICE file created from POR.ext - technology: ihp-sg13g2

.subckt POR RESET VSS VDD VBIAS
X0 a_n506_1214.t3 VCAP.t10 ring_inv_0.A.t4 VDD.t12 sg13_lv_pmos ad=0.2375p pd=1.63u as=0.2375p ps=1.63u w=1.25u l=0.13u
X1 VCAP.t1 POR_ref_voltage_0/POR_nmos_ref_0.vref.t1 VDD.t5 VDD.t2 sg13_lv_pmos ad=0.17p pd=1.68u as=0.17p ps=1.68u w=0.5u l=0.5u
X2 a_n706_n638.t12 VCAP.t10 ring_inv_0.A.t1 VSS.t28 sg13_lv_nmos ad=0.38p pd=2.38u as=0.38p ps=2.38u w=2u l=0.13u
X3 VSS.t14 ring_inv_0.A.t6 a_n506_1214.t2 VDD.t12 sg13_lv_pmos ad=95f pd=0.88u as=95f ps=0.88u w=0.5u l=1u
X4 VDD.t7 ring_inv_0.A.t7 a_n706_n638.t9 VSS.t8 sg13_lv_nmos ad=55.85f pd=0.74u as=55.85f ps=0.74u w=0.155u l=0.5u
X5 VDD.t4 POR_ref_voltage_0/POR_nmos_ref_0.vref.t1 VCAP.t0 VDD.t0 sg13_lv_pmos ad=0.17p pd=1.68u as=0.17p ps=1.68u w=0.5u l=0.5u
X6 a_n706_n638.t7 ring_inv_0.A.t7 VDD.t10 VSS.t12 sg13_lv_nmos ad=55.85f pd=0.74u as=55.85f ps=0.74u w=0.155u l=0.5u
X7 VSS.t18 VDD.t19 VCAP.t5 VDD.t21 sg13_lv_pmos ad=0.1577p pd=1.21u as=0.1577p ps=1.21u w=0.83u l=0.13u
X8 VCAP.t3 VDD.t19 VSS.t20 VDD.t23 sg13_lv_pmos ad=0.2822p pd=2.34u as=0.1577p ps=1.21u w=0.83u l=0.13u
X9 a_n706_n638.t6 ring_inv_0.A.t7 VDD.t16 VSS.t6 sg13_lv_nmos ad=55.85f pd=0.74u as=55.85f ps=0.74u w=0.155u l=0.5u
X10 VDD.t18 ring_inv_0.A.t7 a_n706_n638.t4 VSS.t11 sg13_lv_nmos ad=55.85f pd=0.74u as=55.85f ps=0.74u w=0.155u l=0.5u
X11 VDD.t17 ring_inv_0.A.t7 a_n706_n638.t1 VSS.t4 sg13_lv_nmos ad=55.85f pd=0.74u as=55.85f ps=0.74u w=0.155u l=0.5u
X12 VCAP.t7 VDD.t19 VSS.t19 VDD.t20 sg13_lv_pmos ad=0.1577p pd=1.21u as=0.1577p ps=1.21u w=0.83u l=0.13u
X13 VCAP.t4 VDD.t19 VSS.t22 VDD.t33 sg13_lv_pmos ad=0.1577p pd=1.21u as=0.1577p ps=1.21u w=0.83u l=0.13u
X14 a_n506_1214.t2 VCAP.t11 VDD.t46 VDD.t12 sg13_lv_pmos ad=95f pd=0.88u as=0.2p ps=1.8u w=0.5u l=0.5u
X15 ring_inv_0.A.t4 VCAP.t10 a_n506_1214.t5 VDD.t12 sg13_lv_pmos ad=0.2375p pd=1.63u as=0.425p ps=3.18u w=1.25u l=0.13u
X16 VDD.t41 VDD.t26 VDD.t40 VDD.t27 sg13_lv_pmos ad=0.17p pd=1.68u as=0 ps=0 w=0.5u l=0.5u
X17 ring_inv_0.A.t0 VCAP.t10 a_n706_n638.t12 VSS.t27 sg13_lv_nmos ad=0.68p pd=4.68u as=0.38p ps=2.38u w=2u l=0.13u
X18 VDD.t9 ring_inv_0.A.t7 a_n706_n638.t8 VSS.t10 sg13_lv_nmos ad=55.85f pd=0.74u as=55.85f ps=0.74u w=0.155u l=0.5u
X19 VDD.t38 VDD.t22 VDD.t37 VDD.t23 sg13_lv_pmos ad=0.17p pd=1.68u as=0 ps=0 w=0.5u l=0.5u
X20 a_n506_1214.t4 VCAP.t10 ring_inv_0.A.t3 VDD.t12 sg13_lv_pmos ad=0.2375p pd=1.63u as=0.2375p ps=1.63u w=1.25u l=0.13u
X21 a_n706_n638.t8 ring_inv_0.A.t7 VDD.t14 VSS.t7 sg13_lv_nmos ad=55.85f pd=0.74u as=55.85f ps=0.74u w=0.155u l=0.5u
X22 VCAP.t5 VDD.t19 VSS.t21 VDD.t0 sg13_lv_pmos ad=0.1577p pd=1.21u as=0.1577p ps=1.21u w=0.83u l=0.13u
X23 a_n706_n638.t9 VCAP.t12 VSS.t26 VSS.t2 sg13_lv_nmos ad=55.85f pd=0.74u as=0.10085p ps=1.34u w=0.155u l=0.5u
X24 ring_inv_0.A.t5 VCAP.t10 a_n506_1214.t4 VDD.t12 sg13_lv_pmos ad=0.425p pd=3.18u as=0.2375p ps=1.63u w=1.25u l=0.13u
X25 ring_inv_0.A.t2 VCAP.t10 a_n706_n638.t11 VSS.t25 sg13_lv_nmos ad=0.38p pd=2.38u as=0.68p ps=4.68u w=2u l=0.13u
X26 RESET.t1 ring_inv_0.A.t8 VSS.t16 VSS.t15 sg13_lv_nmos ad=0.238p pd=2.08u as=0.238p ps=2.08u w=0.7u l=0.13u
X27 a_n506_1214.t1 ring_inv_0.A.t6 VSS.t14 VDD.t12 sg13_lv_pmos ad=95f pd=0.88u as=95f ps=0.88u w=0.5u l=1u
X28 POR_ref_voltage_0/POR_nmos_ref_0.vref.t3 POR_ref_voltage_0/POR_nmos_ref_0.vref.t1 VDD.t3 VDD.t2 sg13_lv_pmos ad=0.17p pd=1.68u as=0.17p ps=1.68u w=0.5u l=0.5u
X29 ring_inv_0.A.t1 VCAP.t10 a_n706_n638.t10 VSS.t24 sg13_lv_nmos ad=0.38p pd=2.38u as=0.38p ps=2.38u w=2u l=0.13u
X30 POR_ref_voltage_0/POR_nmos_ref_0.vref.t0 VBIAS.t0 VSS.t1 VSS.t0 sg13_hv_nmos ad=0.17p pd=1.68u as=0.17p ps=1.68u w=0.5u l=2u
X31 VDD.t8 ring_inv_0.A.t7 a_n706_n638.t7 VSS.t5 sg13_lv_nmos ad=0.10085p pd=1.34u as=55.85f ps=0.74u w=0.155u l=0.5u
X32 VSS.t22 VDD.t19 VCAP.t6 VDD.t33 sg13_lv_pmos ad=0.1577p pd=1.21u as=0.1577p ps=1.21u w=0.83u l=0.13u
X33 VSS.t13 ring_inv_0.A.t6 a_n506_1214.t0 VDD.t12 sg13_lv_pmos ad=0.17p pd=1.68u as=95f ps=0.88u w=0.5u l=1u
X34 a_n706_n638.t2 ring_inv_0.A.t7 VDD.t18 VSS.t3 sg13_lv_nmos ad=55.85f pd=0.74u as=55.85f ps=0.74u w=0.155u l=0.5u
X35 a_n706_n638.t3 ring_inv_0.A.t7 VDD.t17 VSS.t12 sg13_lv_nmos ad=55.85f pd=0.74u as=55.85f ps=0.74u w=0.155u l=0.5u
X36 VDD.t15 ring_inv_0.A.t7 a_n706_n638.t6 VSS.t11 sg13_lv_nmos ad=55.85f pd=0.74u as=55.85f ps=0.74u w=0.155u l=0.5u
X37 a_n506_1214.t0 ring_inv_0.A.t6 VSS.t9 VDD.t12 sg13_lv_pmos ad=95f pd=0.88u as=95f ps=0.88u w=0.5u l=1u
X38 VSS.t21 VDD.t19 VCAP.t4 VDD.t33 sg13_lv_pmos ad=0.1577p pd=1.21u as=0.1577p ps=1.21u w=0.83u l=0.13u
X39 VSS.t20 VDD.t19 VCAP.t2 VDD.t32 sg13_lv_pmos ad=0.1577p pd=1.21u as=0.1577p ps=1.21u w=0.83u l=0.13u
X40 ring_inv_0.A.t3 VCAP.t10 a_n506_1214.t3 VDD.t12 sg13_lv_pmos ad=0.2375p pd=1.63u as=0.2375p ps=1.63u w=1.25u l=0.13u
X41 VDD.t16 ring_inv_0.A.t7 a_n706_n638.t5 VSS.t10 sg13_lv_nmos ad=55.85f pd=0.74u as=55.85f ps=0.74u w=0.155u l=0.5u
X42 VSS.t9 ring_inv_0.A.t6 a_n506_1214.t1 VDD.t12 sg13_lv_pmos ad=95f pd=0.88u as=95f ps=0.88u w=0.5u l=1u
X43 VDD.t1 POR_ref_voltage_0/POR_nmos_ref_0.vref.t1 POR_ref_voltage_0/POR_nmos_ref_0.vref.t2 VDD.t0 sg13_lv_pmos ad=0.17p pd=1.68u as=0.17p ps=1.68u w=0.5u l=0.5u
X44 VDD.t14 ring_inv_0.A.t7 a_n706_n638.t0 VSS.t8 sg13_lv_nmos ad=55.85f pd=0.74u as=55.85f ps=0.74u w=0.155u l=0.5u
X45 VSS.t19 VDD.t19 VCAP.t8 VDD.t27 sg13_lv_pmos ad=0.1577p pd=1.21u as=0.2822p ps=2.34u w=0.83u l=0.13u
X46 VCAP.t6 VDD.t19 VSS.t17 VDD.t2 sg13_lv_pmos ad=0.1577p pd=1.21u as=0.1577p ps=1.21u w=0.83u l=0.13u
X47 a_n706_n638.t5 ring_inv_0.A.t7 VDD.t7 VSS.t7 sg13_lv_nmos ad=55.85f pd=0.74u as=55.85f ps=0.74u w=0.155u l=0.5u
X48 a_n706_n638.t4 ring_inv_0.A.t7 VDD.t9 VSS.t6 sg13_lv_nmos ad=55.85f pd=0.74u as=55.85f ps=0.74u w=0.155u l=0.5u
X49 VDD.t6 ring_inv_0.A.t7 a_n706_n638.t3 VSS.t5 sg13_lv_nmos ad=0.10085p pd=1.34u as=55.85f ps=0.74u w=0.155u l=0.5u
X50 VDD.t10 ring_inv_0.A.t7 a_n706_n638.t2 VSS.t4 sg13_lv_nmos ad=55.85f pd=0.74u as=55.85f ps=0.74u w=0.155u l=0.5u
X51 VDD.t29 VDD.t26 VDD.t28 VDD.t27 sg13_lv_pmos ad=0.17p pd=1.68u as=0 ps=0 w=0.5u l=0.5u
X52 a_n706_n638.t1 ring_inv_0.A.t7 VDD.t15 VSS.t3 sg13_lv_nmos ad=55.85f pd=0.74u as=55.85f ps=0.74u w=0.155u l=0.5u
X53 RESET.t0 ring_inv_0.A.t8 VDD.t13 VDD.t12 sg13_lv_pmos ad=0.3808p pd=2.92u as=0.3808p ps=2.92u w=1.12u l=0.13u
X54 VDD.t25 VDD.t22 VDD.t24 VDD.t23 sg13_lv_pmos ad=0.17p pd=1.68u as=0 ps=0 w=0.5u l=0.5u
X55 VSS.t29 VCAP.t9 cap_cmim l=20u w=40u
X56 VCAP.t2 VDD.t19 VSS.t18 VDD.t21 sg13_lv_pmos ad=0.1577p pd=1.21u as=0.1577p ps=1.21u w=0.83u l=0.13u
X57 VSS.t17 VDD.t19 VCAP.t7 VDD.t20 sg13_lv_pmos ad=0.1577p pd=1.21u as=0.1577p ps=1.21u w=0.83u l=0.13u
X58 a_n706_n638.t10 VCAP.t10 ring_inv_0.A.t2 VSS.t23 sg13_lv_nmos ad=0.38p pd=2.38u as=0.38p ps=2.38u w=2u l=0.13u
X59 a_n706_n638.t0 ring_inv_0.A.t7 VDD.t11 VSS.t2 sg13_lv_nmos ad=55.85f pd=0.74u as=0.10085p ps=1.34u w=0.155u l=0.5u
C0 VCAP ring_inv_0.A 0.74819f
C1 RESET ring_inv_0.A 0.11106f
C2 POR_ref_voltage_0/POR_nmos_ref_0.vref VCAP 0.58011f
C3 RESET VCAP 0.08692f
C4 VBIAS VCAP 0.36975f
C5 VBIAS POR_ref_voltage_0/POR_nmos_ref_0.vref 0.05586f
C6 ring_inv_0.A VDD 2.79637f
C7 VCAP VDD 3.78908f
C8 POR_ref_voltage_0/POR_nmos_ref_0.vref VDD 1.00556f
C9 RESET VDD 0.25234f
C10 VBIAS VDD 0.02782f
R0 VCAP.n0 VCAP.t11 25.518
R1 VCAP.n2 VCAP.t12 24.4924
R2 VCAP.n14 VCAP.t0 22.3959
R3 VCAP.n14 VCAP.t1 21.5791
R4 VCAP.n4 VCAP.t3 9.36875
R5 VCAP.n7 VCAP.t8 9.36647
R6 VCAP.n4 VCAP.t2 8.85975
R7 VCAP.n7 VCAP.t7 8.85975
R8 VCAP.n8 VCAP.t6 8.85975
R9 VCAP.n6 VCAP.t4 8.85975
R10 VCAP.n5 VCAP.t5 8.85975
R11 VCAP.n0 VCAP.t10 6.61988
R12 VCAP.n13 VCAP.n12 3.37627
R13 VCAP.n12 VCAP.n11 1.3505
R14 VCAP.n3 VCAP.n2 1.3505
R15 VCAP.n10 VCAP 0.958637
R16 VCAP.n10 VCAP.n9 0.9005
R17 VCAP VCAP.n15 0.5593
R18 VCAP.n5 VCAP.n4 0.492783
R19 VCAP.n6 VCAP.n5 0.488326
R20 VCAP.n8 VCAP.n7 0.488326
R21 VCAP.n9 VCAP.n8 0.414196
R22 VCAP.n1 VCAP 0.3665
R23 VCAP.n11 VCAP 0.268107
R24 VCAP.n1 VCAP.n0 0.2645
R25 VCAP.n2 VCAP.n1 0.190926
R26 VCAP.n15 VCAP.n14 0.1281
R27 VCAP.n15 VCAP.n13 0.110139
R28 VCAP.n9 VCAP.n6 0.0746304
R29 VCAP.n13 VCAP 0.0740738
R30 VCAP.n12 VCAP.n3 0.0265264
R31 VCAP.n11 VCAP.n10 0.0199754
R32 VCAP.n3 VCAP.t9 0.00720377
R33 ring_inv_0.A.n5 ring_inv_0.A.t7 25.59
R34 ring_inv_0.A.n5 ring_inv_0.A.t6 25.1081
R35 ring_inv_0.A.n6 ring_inv_0.A.n5 9.0005
R36 ring_inv_0.A.n0 ring_inv_0.A.t4 6.77452
R37 ring_inv_0.A.n1 ring_inv_0.A.t5 6.07327
R38 ring_inv_0.A.n0 ring_inv_0.A.t3 6.07327
R39 ring_inv_0.A.n2 ring_inv_0.A.t2 4.10783
R40 ring_inv_0.A ring_inv_0.A.t8 3.79603
R41 ring_inv_0.A.n2 ring_inv_0.A.t1 3.4078
R42 ring_inv_0.A.n3 ring_inv_0.A.t0 3.40592
R43 ring_inv_0.A.n6 ring_inv_0.A.n4 0.872826
R44 ring_inv_0.A.n1 ring_inv_0.A.n0 0.70175
R45 ring_inv_0.A.n3 ring_inv_0.A.n2 0.70175
R46 ring_inv_0.A.n4 ring_inv_0.A.n1 0.138
R47 ring_inv_0.A.n4 ring_inv_0.A.n3 0.120812
R48 ring_inv_0.A ring_inv_0.A.n6 0.120733
R49 a_n506_1214.t0 a_n506_1214.n3 19.1936
R50 a_n506_1214.n2 a_n506_1214.n1 18.7515
R51 a_n506_1214.n2 a_n506_1214.t2 18.2143
R52 a_n506_1214.n3 a_n506_1214.t1 17.2961
R53 a_n506_1214.n0 a_n506_1214.t4 6.77495
R54 a_n506_1214.n1 a_n506_1214.t5 6.07724
R55 a_n506_1214.n0 a_n506_1214.t3 6.0737
R56 a_n506_1214.n3 a_n506_1214.n2 0.9255
R57 a_n506_1214.n1 a_n506_1214.n0 0.653317
R58 VDD.n90 VDD.n89 20.1019
R59 VDD.n80 VDD.t11 18.5233
R60 VDD.n86 VDD.t7 18.5199
R61 VDD.n77 VDD.t46 17.7293
R62 VDD.n83 VDD.t10 17.2308
R63 VDD.n82 VDD.t18 17.2308
R64 VDD.n81 VDD.t9 17.2308
R65 VDD.n80 VDD.t14 17.2308
R66 VDD.n86 VDD.t16 17.2274
R67 VDD.n87 VDD.t15 17.2274
R68 VDD.n88 VDD.t17 17.2274
R69 VDD.n84 VDD.t8 17.0005
R70 VDD.n85 VDD.t6 17.0005
R71 VDD.n58 VDD.t24 17.0005
R72 VDD.n52 VDD.t25 17.0005
R73 VDD.n42 VDD.t1 17.0005
R74 VDD.n58 VDD.t37 17.0005
R75 VDD.n52 VDD.t38 17.0005
R76 VDD.n42 VDD.t4 17.0005
R77 VDD.n9 VDD.t5 17.0005
R78 VDD.n9 VDD.t28 17.0005
R79 VDD.n9 VDD.t29 17.0005
R80 VDD.n15 VDD.t3 17.0005
R81 VDD.n15 VDD.t40 17.0005
R82 VDD.n15 VDD.t41 17.0005
R83 VDD.n112 VDD.n24 17.0005
R84 VDD.n112 VDD.n26 17.0005
R85 VDD.n112 VDD.n29 17.0005
R86 VDD.n112 VDD.n31 17.0005
R87 VDD.n112 VDD.n34 17.0005
R88 VDD.n112 VDD.n36 17.0005
R89 VDD.n112 VDD.n39 17.0005
R90 VDD.n112 VDD.n46 17.0005
R91 VDD.n112 VDD.n48 17.0005
R92 VDD.n112 VDD.n50 17.0005
R93 VDD.n112 VDD.n56 17.0005
R94 VDD.n112 VDD.n60 17.0005
R95 VDD.n112 VDD.n62 17.0005
R96 VDD.n112 VDD.n10 17.0005
R97 VDD.n112 VDD.n12 17.0005
R98 VDD.n112 VDD.n14 17.0005
R99 VDD.n105 VDD.t21 17.0005
R100 VDD.n105 VDD.n46 17.0005
R101 VDD.n105 VDD.n48 17.0005
R102 VDD.n105 VDD.n50 17.0005
R103 VDD.n105 VDD.n56 17.0005
R104 VDD.n105 VDD.n60 17.0005
R105 VDD.n105 VDD.n62 17.0005
R106 VDD.n105 VDD.t12 17.0005
R107 VDD.n25 VDD.n1 17.0005
R108 VDD.n28 VDD.n1 17.0005
R109 VDD.n33 VDD.n1 17.0005
R110 VDD.n35 VDD.n1 17.0005
R111 VDD.n38 VDD.n1 17.0005
R112 VDD.n43 VDD.n1 17.0005
R113 VDD.n45 VDD.n1 17.0005
R114 VDD.n47 VDD.n1 17.0005
R115 VDD.n53 VDD.n1 17.0005
R116 VDD.n51 VDD.n1 17.0005
R117 VDD.n59 VDD.n1 17.0005
R118 VDD.n61 VDD.n1 17.0005
R119 VDD.n107 VDD.n1 17.0005
R120 VDD.n6 VDD.n1 17.0005
R121 VDD.t22 VDD.n54 15.0005
R122 VDD.n55 VDD.t22 15.0005
R123 VDD.n44 VDD.n8 8.501
R124 VDD.n112 VDD.n40 8.501
R125 VDD.n112 VDD.n49 8.501
R126 VDD.n112 VDD.n57 8.501
R127 VDD.n108 VDD.n106 8.501
R128 VDD.n105 VDD.n70 8.501
R129 VDD.n105 VDD.n68 8.501
R130 VDD.n105 VDD.n66 8.501
R131 VDD.n64 VDD.n1 8.5005
R132 VDD.n65 VDD.n1 8.5005
R133 VDD.n67 VDD.n1 8.5005
R134 VDD.t23 VDD.n1 8.5005
R135 VDD.t32 VDD.n1 8.5005
R136 VDD.n69 VDD.n1 8.5005
R137 VDD.n30 VDD.n1 8.48605
R138 VDD.n103 VDD.n102 8.46995
R139 VDD.n115 VDD.n114 8.46995
R140 VDD.n98 VDD.n91 8.46995
R141 VDD.n21 VDD.t19 7.57017
R142 VDD.n11 VDD.t26 7.5005
R143 VDD.n101 VDD.t13 6.41406
R144 VDD.n114 VDD.t20 5.66717
R145 VDD.t20 VDD.n1 5.66717
R146 VDD.n112 VDD.n16 5.66235
R147 VDD.n112 VDD.n17 4.251
R148 VDD.n112 VDD.n27 4.251
R149 VDD.n112 VDD.n32 4.251
R150 VDD.n112 VDD.n37 4.251
R151 VDD.t27 VDD.n5 4.251
R152 VDD.t21 VDD.n1 4.2505
R153 VDD.t0 VDD.n1 4.2505
R154 VDD.t2 VDD.n1 4.2505
R155 VDD.n98 VDD.n78 4.17416
R156 VDD.n94 VDD.n72 3.62449
R157 VDD.n96 VDD 3.42333
R158 VDD.n98 VDD.n79 3.3033
R159 VDD.n92 VDD.n71 2.99026
R160 VDD.n104 VDD.n100 2.98701
R161 VDD.t12 VDD.n73 2.8374
R162 VDD.t12 VDD.n72 2.83459
R163 VDD.n112 VDD.n18 2.83433
R164 VDD.n112 VDD.n20 2.83433
R165 VDD.n114 VDD.n4 2.29043
R166 VDD.n99 VDD.n98 2.12625
R167 VDD.n98 VDD.n97 2.1255
R168 VDD.t33 VDD.n1 2.1255
R169 VDD.n101 VDD.n73 2.07479
R170 VDD.n98 VDD.n76 1.97072
R171 VDD.n98 VDD.n95 1.97072
R172 VDD.n22 VDD.n3 1.88989
R173 VDD.n112 VDD.n19 1.88939
R174 VDD.t12 VDD.n1 1.88939
R175 VDD.n109 VDD.n1 1.8888
R176 VDD.n13 VDD 1.88425
R177 VDD.n112 VDD.n111 1.54595
R178 VDD.n84 VDD.n83 1.52331
R179 VDD.n114 VDD.n113 1.41785
R180 VDD.t12 VDD.n104 1.41759
R181 VDD.n113 VDD.n112 1.30932
R182 VDD.n112 VDD.n63 1.30864
R183 VDD.n88 VDD.n87 1.293
R184 VDD.n87 VDD.n86 1.293
R185 VDD.n83 VDD.n82 1.293
R186 VDD.n82 VDD.n81 1.293
R187 VDD.n81 VDD.n80 1.293
R188 VDD.n116 VDD.n115 1.21732
R189 VDD.n89 VDD.n85 1.15925
R190 VDD.n117 VDD.n116 1.10828
R191 VDD.n98 VDD.n93 1.06386
R192 VDD VDD.n75 1.04133
R193 VDD.n75 VDD.n74 0.926863
R194 VDD.n93 VDD.n92 0.822735
R195 VDD.n94 VDD.n93 0.774826
R196 VDD.n112 VDD.n7 0.774424
R197 VDD.n98 VDD.n75 0.712184
R198 VDD.n74 VDD 0.7105
R199 VDD.n41 VDD.n7 0.691458
R200 VDD.n85 VDD.n84 0.560813
R201 VDD.n96 VDD.n95 0.488237
R202 VDD.n95 VDD.n94 0.47458
R203 VDD.n77 VDD.n76 0.45707
R204 VDD.n116 VDD.n1 0.449584
R205 VDD.n21 VDD.n4 0.44101
R206 VDD.n4 VDD.n2 0.438468
R207 VDD.n76 VDD 0.437913
R208 VDD.n23 VDD 0.362175
R209 VDD VDD.n117 0.337779
R210 VDD.n90 VDD.n79 0.326147
R211 VDD.n79 VDD.n74 0.31697
R212 VDD.n89 VDD.n88 0.30675
R213 VDD.n78 VDD.n77 0.276562
R214 VDD.n96 VDD.n78 0.252728
R215 VDD.n92 VDD.n91 0.240939
R216 VDD.n111 VDD 0.222973
R217 VDD.t12 VDD.n71 0.218817
R218 VDD.n9 VDD.n7 0.199566
R219 VDD.n41 VDD 0.139009
R220 VDD.n102 VDD.n100 0.138227
R221 VDD.n102 VDD 0.108939
R222 VDD.n91 VDD.n90 0.108939
R223 VDD VDD.n101 0.0756667
R224 VDD.n115 VDD.n2 0.0631056
R225 VDD.n2 VDD 0.0555
R226 VDD.n31 VDD.n30 0.0401096
R227 VDD.n30 VDD.n29 0.0401096
R228 VDD.n100 VDD.n99 0.0328636
R229 VDD.n38 VDD.n36 0.0304476
R230 VDD.n35 VDD.n34 0.0304476
R231 VDD.n33 VDD.n31 0.0304476
R232 VDD.n29 VDD.n28 0.0304476
R233 VDD.n26 VDD.n25 0.0304476
R234 VDD.n97 VDD.n0 0.0282022
R235 VDD.n16 VDD.n15 0.0207101
R236 VDD VDD.n16 0.0203761
R237 VDD.n11 VDD.n10 0.0154183
R238 VDD.n23 VDD.n22 0.0123627
R239 VDD.n23 VDD.n19 0.012183
R240 VDD.n110 VDD.n109 0.0107722
R241 VDD.n39 VDD.n38 0.00971466
R242 VDD.n36 VDD.n35 0.00971466
R243 VDD.n34 VDD.n33 0.00971466
R244 VDD.n28 VDD.n26 0.00971466
R245 VDD.n25 VDD.n24 0.00971466
R246 VDD.n41 VDD.n39 0.00856283
R247 VDD.n24 VDD.n23 0.00856283
R248 VDD.n13 VDD.n12 0.00697059
R249 VDD.n97 VDD.n96 0.00697059
R250 VDD.n110 VDD.n108 0.00686262
R251 VDD.n107 VDD.n62 0.00686262
R252 VDD.n61 VDD.n60 0.00686262
R253 VDD.n51 VDD.n50 0.00686262
R254 VDD.n47 VDD.n46 0.00686262
R255 VDD.n45 VDD.n44 0.00686262
R256 VDD.n58 VDD.n56 0.00661791
R257 VDD.n117 VDD.n0 0.00656618
R258 VDD.n14 VDD.n13 0.00625163
R259 VDD.n99 VDD.n74 0.00595455
R260 VDD.n22 VDD.n21 0.00589216
R261 VDD.n19 VDD 0.00589216
R262 VDD.n15 VDD.n14 0.00589216
R263 VDD.n10 VDD.n9 0.00589216
R264 VDD.n53 VDD.n52 0.00563904
R265 VDD.n43 VDD.n42 0.00319188
R266 VDD.n12 VDD.n11 0.0028366
R267 VDD.n103 VDD.n73 0.00248667
R268 VDD.n111 VDD.n110 0.00245773
R269 VDD.n108 VDD.n107 0.00245773
R270 VDD.n62 VDD.n61 0.00245773
R271 VDD.n60 VDD.n59 0.00245773
R272 VDD.n48 VDD.n47 0.00245773
R273 VDD.n46 VDD.n45 0.00245773
R274 VDD.n44 VDD.n43 0.00245773
R275 VDD.n42 VDD.n41 0.00245773
R276 VDD.n98 VDD.n72 0.00229873
R277 VDD.n109 VDD.n0 0.00222152
R278 VDD.n64 VDD.n63 0.00192306
R279 VDD.n55 VDD.n51 0.00184594
R280 VDD.n54 VDD.n53 0.00184594
R281 VDD.n52 VDD.n48 0.00172358
R282 VDD.n113 VDD.n6 0.00137495
R283 VDD.n98 VDD.n71 0.00115233
R284 VDD.n56 VDD.n55 0.00111179
R285 VDD.n54 VDD.n50 0.00111179
R286 VDD.n104 VDD.n103 0.00109621
R287 VDD.t12 VDD.n63 0.00107692
R288 VDD.n114 VDD.n5 0.001
R289 VDD.n114 VDD.n3 0.001
R290 VDD.n112 VDD.n106 0.001
R291 VDD.n112 VDD.n8 0.001
R292 VDD.n66 VDD.n64 0.001
R293 VDD.n67 VDD.n57 0.001
R294 VDD.n68 VDD.n67 0.001
R295 VDD.t32 VDD.n49 0.001
R296 VDD.n70 VDD.t32 0.001
R297 VDD.t21 VDD.n40 0.001
R298 VDD.n37 VDD.t0 0.001
R299 VDD.n32 VDD.t33 0.001
R300 VDD.n27 VDD.t2 0.001
R301 VDD.n20 VDD.t20 0.001
R302 VDD.n18 VDD.t27 0.001
R303 VDD.n17 VDD.n6 0.001
R304 VDD.t27 VDD.n17 0.001
R305 VDD.n18 VDD.t20 0.001
R306 VDD.t2 VDD.n20 0.001
R307 VDD.t33 VDD.n27 0.001
R308 VDD.t0 VDD.n32 0.001
R309 VDD.t21 VDD.n37 0.001
R310 VDD.n69 VDD.n40 0.001
R311 VDD.t23 VDD.n49 0.001
R312 VDD.n65 VDD.n57 0.001
R313 VDD.n105 VDD.n8 0.001
R314 VDD.n70 VDD.n69 0.001
R315 VDD.n68 VDD.t23 0.001
R316 VDD.n66 VDD.n65 0.001
R317 VDD.n106 VDD.n105 0.001
R318 VDD.n3 VDD.n1 0.001
R319 VDD.n5 VDD.n1 0.001
R320 VDD.n59 VDD.n58 0.000744716
R321 POR_ref_voltage_0/POR_nmos_ref_0.vref POR_ref_voltage_0/POR_nmos_ref_0.vref.t0 19.3034
R322 POR_ref_voltage_0/POR_nmos_ref_0.vref.n0 POR_ref_voltage_0/POR_nmos_ref_0.vref.t3 17.5898
R323 POR_ref_voltage_0/POR_nmos_ref_0.vref.n1 POR_ref_voltage_0/POR_nmos_ref_0.vref.t2 17.0005
R324 POR_ref_voltage_0/POR_nmos_ref_0.vref.n2 POR_ref_voltage_0/POR_nmos_ref_0.vref.n1 5.16867
R325 POR_ref_voltage_0/POR_nmos_ref_0.vref.n0 POR_ref_voltage_0/POR_nmos_ref_0.vref.t1 2.39837
R326 POR_ref_voltage_0/POR_nmos_ref_0.vref.n3 POR_ref_voltage_0/POR_nmos_ref_0.vref.n2 1.0925
R327 POR_ref_voltage_0/POR_nmos_ref_0.vref.n1 POR_ref_voltage_0/POR_nmos_ref_0.vref.n0 0.550952
R328 POR_ref_voltage_0/POR_nmos_ref_0.vref.n2 POR_ref_voltage_0/POR_nmos_ref_0.vref 0.0973
R329 POR_ref_voltage_0/POR_nmos_ref_0.vref.n3 POR_ref_voltage_0/POR_nmos_ref_0.vref 0.0785
R330 POR_ref_voltage_0/POR_nmos_ref_0.vref.n2 POR_ref_voltage_0/POR_nmos_ref_0.vref 0.0405
R331 POR_ref_voltage_0/POR_nmos_ref_0.vref POR_ref_voltage_0/POR_nmos_ref_0.vref.n3 0.0250143
R332 a_n706_n638.n5 a_n706_n638.n4 18.7002
R333 a_n706_n638.n0 a_n706_n638.t3 17.2274
R334 a_n706_n638.n1 a_n706_n638.t1 17.2274
R335 a_n706_n638.n2 a_n706_n638.t6 17.2274
R336 a_n706_n638.n6 a_n706_n638.t5 17.2274
R337 a_n706_n638.t9 a_n706_n638.n7 17.2274
R338 a_n706_n638.n7 a_n706_n638.t0 17.2239
R339 a_n706_n638.n0 a_n706_n638.t7 17.2239
R340 a_n706_n638.n1 a_n706_n638.t2 17.2239
R341 a_n706_n638.n2 a_n706_n638.t4 17.2239
R342 a_n706_n638.n6 a_n706_n638.t8 17.2239
R343 a_n706_n638.n3 a_n706_n638.t12 4.10735
R344 a_n706_n638.n4 a_n706_n638.t11 3.64026
R345 a_n706_n638.n3 a_n706_n638.t10 3.4061
R346 a_n706_n638.n1 a_n706_n638.n0 1.293
R347 a_n706_n638.n2 a_n706_n638.n1 1.293
R348 a_n706_n638.n7 a_n706_n638.n6 1.293
R349 a_n706_n638.n5 a_n706_n638.n2 0.942702
R350 a_n706_n638.n4 a_n706_n638.n3 0.413313
R351 a_n706_n638.n6 a_n706_n638.n5 0.303327
R352 VSS.n96 VSS.n95 22107.5
R353 VSS.n100 VSS.n16 749.75
R354 VSS.n89 VSS.n88 258.81
R355 VSS.n100 VSS.n5 106.862
R356 VSS.n95 VSS.n45 97.3285
R357 VSS.n89 VSS.n51 97.3285
R358 VSS.n67 VSS.n66 84.5609
R359 VSS.n61 VSS.n60 84.5609
R360 VSS.n77 VSS.n58 84.5609
R361 VSS.t10 VSS.n57 82.0367
R362 VSS.t2 VSS.n16 77.6333
R363 VSS.n88 VSS.t5 77.1443
R364 VSS.n64 VSS.t25 76.9883
R365 VSS.n84 VSS.n52 71.9399
R366 VSS.n71 VSS.n53 71.9399
R367 VSS.n73 VSS.n72 71.9399
R368 VSS.n65 VSS.n55 71.9399
R369 VSS.n14 VSS.t0 69.1466
R370 VSS.t0 VSS.n8 69.1466
R371 VSS.t4 VSS.n85 63.1053
R372 VSS.n68 VSS.t27 63.1053
R373 VSS.n80 VSS.t7 61.8432
R374 VSS.n79 VSS.t8 57.1025
R375 VSS.t8 VSS.n78 57.1025
R376 VSS.t12 VSS.n86 56.7669
R377 VSS.n87 VSS.t12 56.7613
R378 VSS.t15 VSS.n45 55.9924
R379 VSS.n51 VSS.t15 55.9924
R380 VSS.n70 VSS.t28 51.7464
R381 VSS.n62 VSS.t23 50.4843
R382 VSS.t7 VSS.n79 36.908
R383 VSS.n78 VSS.t2 36.908
R384 VSS.n86 VSS.t4 36.9072
R385 VSS.t5 VSS.n87 36.7205
R386 VSS.n24 VSS.n6 25.7949
R387 VSS.n25 VSS.n6 25.7949
R388 VSS.n25 VSS.n7 25.7949
R389 VSS.n26 VSS.n7 25.7949
R390 VSS.n27 VSS.n9 25.7949
R391 VSS.n30 VSS.n9 25.7949
R392 VSS.n30 VSS.n10 25.7949
R393 VSS.n39 VSS.n10 25.7949
R394 VSS.n39 VSS.n13 25.7949
R395 VSS.t24 VSS.n65 22.7182
R396 VSS.n76 VSS.n75 19.8135
R397 VSS.n74 VSS.t14 19.1936
R398 VSS.n75 VSS.t13 18.8244
R399 VSS.n28 VSS.t1 17.8736
R400 VSS.t11 VSS.n69 17.6698
R401 VSS.t23 VSS.t6 17.6698
R402 VSS.n74 VSS.t9 17.2961
R403 VSS.n2 VSS.t26 17.2617
R404 VSS.n92 VSS.n46 17.0005
R405 VSS.n83 VSS.n58 17.0005
R406 VSS.n83 VSS.n61 17.0005
R407 VSS.n83 VSS.n57 17.0005
R408 VSS.n83 VSS.n64 17.0005
R409 VSS.n83 VSS.n56 17.0005
R410 VSS.n83 VSS.n67 17.0005
R411 VSS.n83 VSS.n55 17.0005
R412 VSS.n83 VSS.n70 17.0005
R413 VSS.n83 VSS.n54 17.0005
R414 VSS.n83 VSS.n73 17.0005
R415 VSS.n83 VSS.n53 17.0005
R416 VSS.n77 VSS.n1 17.0005
R417 VSS.n60 VSS.n1 17.0005
R418 VSS.n59 VSS.n1 17.0005
R419 VSS.n63 VSS.n1 17.0005
R420 VSS.n62 VSS.n1 17.0005
R421 VSS.n66 VSS.n1 17.0005
R422 VSS.n65 VSS.n1 17.0005
R423 VSS.n69 VSS.n1 17.0005
R424 VSS.n68 VSS.n1 17.0005
R425 VSS.n72 VSS.n1 17.0005
R426 VSS.n71 VSS.n1 17.0005
R427 VSS.n52 VSS.n1 17.0005
R428 VSS.n85 VSS.n1 17.0005
R429 VSS.n102 VSS.n8 17.0005
R430 VSS.n102 VSS.n14 17.0005
R431 VSS.n102 VSS.n5 17.0005
R432 VSS.t6 VSS.n56 16.4077
R433 VSS.n85 VSS.n84 13.8835
R434 VSS.n53 VSS.n52 13.8835
R435 VSS.n72 VSS.n54 13.8835
R436 VSS.n70 VSS.n68 13.8835
R437 VSS.n69 VSS.n55 13.8835
R438 VSS.n26 VSS.n14 12.8977
R439 VSS.n96 VSS.n13 12.8977
R440 VSS.n27 VSS.n8 12.8977
R441 VSS.n24 VSS.n5 12.8977
R442 VSS.n73 VSS.t3 11.3594
R443 VSS.n31 VSS.t20 9.33254
R444 VSS.n33 VSS.t19 9.30722
R445 VSS.n93 VSS.t16 9.00182
R446 VSS.n31 VSS.t18 8.84844
R447 VSS.n32 VSS.t21 8.84844
R448 VSS.n34 VSS.t22 8.84844
R449 VSS.n33 VSS.t17 8.84844
R450 VSS.t27 VSS.n54 8.83517
R451 VSS.n67 VSS.t24 8.83517
R452 VSS.n100 VSS.n17 8.501
R453 VSS.n96 VSS.n44 8.501
R454 VSS.n100 VSS.n18 8.501
R455 VSS.n101 VSS.n100 8.501
R456 VSS.n2 VSS.n1 8.5005
R457 VSS.n15 VSS.n3 8.5005
R458 VSS.n22 VSS.n19 8.46995
R459 VSS.n41 VSS.n40 8.46995
R460 VSS.n98 VSS.n29 8.46995
R461 VSS.n21 VSS.n20 8.46813
R462 VSS.n43 VSS.n42 8.45904
R463 VSS.t25 VSS.n63 7.57307
R464 VSS.n96 VSS.n11 5.66778
R465 VSS.n100 VSS.n99 5.66767
R466 VSS.n97 VSS.n96 5.66767
R467 VSS.n105 VSS.n1 5.66717
R468 VSS.n102 VSS.n12 5.62487
R469 VSS.n98 VSS.n38 5.62486
R470 VSS.n91 VSS.n90 4.33109
R471 VSS.n95 VSS.n94 4.25217
R472 VSS.n90 VSS.n89 4.25119
R473 VSS.n1 VSS.n0 4.24685
R474 VSS.n37 VSS 2.97471
R475 VSS.n47 VSS.t29 2.65305
R476 VSS.t3 VSS.n71 2.52469
R477 VSS.t28 VSS.t11 2.52469
R478 VSS.n59 VSS.t10 2.52469
R479 VSS.n94 VSS.n93 2.48291
R480 VSS.n51 VSS.n46 2.42596
R481 VSS.n46 VSS.n45 2.42596
R482 VSS.n83 VSS.n76 2.28134
R483 VSS.n82 VSS.n80 2.13698
R484 VSS.n84 VSS.n83 2.1255
R485 VSS.n48 VSS.n1 2.117
R486 VSS.n98 VSS.n39 2.05265
R487 VSS.n98 VSS.n30 2.05265
R488 VSS.n98 VSS.n27 2.05265
R489 VSS.n98 VSS.n26 2.05265
R490 VSS.n98 VSS.n25 2.05265
R491 VSS.n98 VSS.n24 2.05265
R492 VSS.n102 VSS.n13 2.05265
R493 VSS.n102 VSS.n10 2.05265
R494 VSS.n102 VSS.n9 2.05265
R495 VSS.n102 VSS.n7 2.05265
R496 VSS.n102 VSS.n6 2.05265
R497 VSS.n82 VSS.n81 1.53172
R498 VSS.n98 VSS.n23 1.3389
R499 VSS.n103 VSS.n102 1.29619
R500 VSS.n66 VSS.n56 1.2626
R501 VSS.n64 VSS.n62 1.2626
R502 VSS.n63 VSS.n57 1.2626
R503 VSS.n61 VSS.n59 1.2626
R504 VSS.n60 VSS.n58 1.2626
R505 VSS.n80 VSS.n77 1.2626
R506 VSS.n36 VSS.n35 1.13666
R507 VSS.n81 VSS.n50 1.06055
R508 VSS.n23 VSS.n22 0.729453
R509 VSS.n28 VSS.n23 0.707931
R510 VSS.n49 VSS.n1 0.646267
R511 VSS.n50 VSS.n49 0.547953
R512 VSS.n32 VSS.n31 0.423896
R513 VSS.n34 VSS.n33 0.423896
R514 VSS.n87 VSS.n1 0.354161
R515 VSS.n86 VSS.n1 0.351793
R516 VSS.n78 VSS.n1 0.350291
R517 VSS.n79 VSS.n1 0.350291
R518 VSS.n81 VSS.n76 0.329349
R519 VSS.n75 VSS.n74 0.318749
R520 VSS.n42 VSS.n12 0.316447
R521 VSS.n35 VSS.n32 0.276538
R522 VSS.n41 VSS.n38 0.276441
R523 VSS.n42 VSS.n41 0.272189
R524 VSS.n22 VSS.n21 0.254017
R525 VSS.n38 VSS.n37 0.224358
R526 VSS.n35 VSS.n34 0.147858
R527 VSS VSS.n106 0.141077
R528 VSS.n104 VSS.n2 0.135448
R529 VSS.n104 VSS.n3 0.134881
R530 VSS.n49 VSS 0.133988
R531 VSS.n36 VSS 0.121724
R532 VSS.n12 VSS.n4 0.0888312
R533 VSS.n29 VSS.n28 0.0814389
R534 VSS.n37 VSS.n29 0.0704389
R535 VSS.n21 VSS.n3 0.0667448
R536 VSS.n104 VSS.n103 0.0619735
R537 VSS.n103 VSS.n4 0.0521703
R538 VSS.n91 VSS.n50 0.0432429
R539 VSS VSS.n36 0.0324407
R540 VSS.n48 VSS.n47 0.0294184
R541 VSS VSS.n48 0.0290547
R542 VSS.n105 VSS.n104 0.0216984
R543 VSS.n47 VSS.n0 0.016744
R544 VSS.n106 VSS.n0 0.0156694
R545 VSS.n92 VSS.n91 0.0147476
R546 VSS.n88 VSS.n1 0.0126567
R547 VSS.n16 VSS.n1 0.0119485
R548 VSS VSS.n92 0.00804286
R549 VSS.n83 VSS.n82 0.00480891
R550 VSS.n93 VSS 0.00385238
R551 VSS.n106 VSS.n105 0.00317206
R552 VSS.n4 VSS 0.00317206
R553 VSS.n94 VSS.n46 0.00170589
R554 VSS.n43 VSS.n11 0.00166667
R555 VSS.n90 VSS.n46 0.00162495
R556 VSS.n102 VSS.n11 0.00133332
R557 VSS.n99 VSS.n19 0.001
R558 VSS.n19 VSS.n17 0.001
R559 VSS.n20 VSS.n18 0.001
R560 VSS.n101 VSS.n15 0.001
R561 VSS.n97 VSS.n40 0.001
R562 VSS.n44 VSS.n40 0.001
R563 VSS.n98 VSS.n97 0.001
R564 VSS.n99 VSS.n98 0.001
R565 VSS.n20 VSS.n17 0.001
R566 VSS.n44 VSS.n43 0.001
R567 VSS.n18 VSS.n15 0.001
R568 VSS.n102 VSS.n101 0.001
R569 RESET RESET.t1 8.93995
R570 RESET RESET.t0 6.2524
R571 VBIAS.n0 VBIAS.t0 3.13298
R572 VBIAS VBIAS.n0 0.6785
R573 VBIAS.n0 VBIAS 0.245025
C11 VBIAS VSS 1.93027f
C12 RESET VSS 0.60803f
C13 VDD VSS 6.36541f
C14 POR_ref_voltage_0/POR_nmos_ref_0.vref VSS 0.63877f $ **FLOATING
C15 ring_inv_0.A VSS 4.6594f $ **FLOATING
C16 VCAP VSS 51.8945f $ **FLOATING
C17 VDD.n0 VSS 0.03292f $ **FLOATING
C18 VDD.n1 VSS 0.14179f $ **FLOATING
C19 VDD.t20 VSS 0.23398f $ **FLOATING
C20 VDD.n6 VSS 0.15599f $ **FLOATING
C21 VDD.n7 VSS 0.01961f $ **FLOATING
C22 VDD.n9 VSS 0.11866f $ **FLOATING
C23 VDD.n10 VSS 0.02496f $ **FLOATING
C24 VDD.t26 VSS 0.01698f $ **FLOATING
C25 VDD.n11 VSS 0.0212f $ **FLOATING
C26 VDD.n12 VSS 0.01082f $ **FLOATING
C27 VDD.n13 VSS 0.02161f $ **FLOATING
C28 VDD.n14 VSS 0.01369f $ **FLOATING
C29 VDD.n15 VSS 0.03705f $ **FLOATING
C30 VDD.n16 VSS 0.03255f $ **FLOATING
C31 VDD.t27 VSS 0.19498f $ **FLOATING
C32 VDD.n19 VSS 0.02098f $ **FLOATING
C33 VDD.t19 VSS 0.09234f $ **FLOATING
C34 VDD.n21 VSS 0.02148f $ **FLOATING
C35 VDD.n22 VSS 0.0212f $ **FLOATING
C36 VDD.n23 VSS 0.07319f $ **FLOATING
C37 VDD.t2 VSS 0.15599f $ **FLOATING
C38 VDD.n29 VSS 0.01104f $ **FLOATING
C39 VDD.n31 VSS 0.01104f $ **FLOATING
C40 VDD.t33 VSS 0.29362f $ **FLOATING
C41 VDD.t0 VSS 0.15599f $ **FLOATING
C42 VDD.n41 VSS 0.38379f $ **FLOATING
C43 VDD.n42 VSS 0.01233f $ **FLOATING
C44 VDD.n43 VSS 0.01233f $ **FLOATING
C45 VDD.n44 VSS 0.02206f $ **FLOATING
C46 VDD.n45 VSS 0.02206f $ **FLOATING
C47 VDD.n46 VSS 0.02206f $ **FLOATING
C48 VDD.n47 VSS 0.02206f $ **FLOATING
C49 VDD.n50 VSS 0.01849f $ **FLOATING
C50 VDD.n51 VSS 0.02044f $ **FLOATING
C51 VDD.n52 VSS 0.01687f $ **FLOATING
C52 VDD.n53 VSS 0.0172f $ **FLOATING
C53 VDD.t22 VSS 0.01698f $ **FLOATING
C54 VDD.n56 VSS 0.01784f $ **FLOATING
C55 VDD.n58 VSS 0.01687f $ **FLOATING
C56 VDD.n60 VSS 0.02206f $ **FLOATING
C57 VDD.n61 VSS 0.02206f $ **FLOATING
C58 VDD.n62 VSS 0.02206f $ **FLOATING
C59 VDD.n64 VSS 0.07799f $ **FLOATING
C60 VDD.n65 VSS 0.07799f $ **FLOATING
C61 VDD.n67 VSS 0.07799f $ **FLOATING
C62 VDD.t23 VSS 0.07799f $ **FLOATING
C63 VDD.t32 VSS 0.07799f $ **FLOATING
C64 VDD.n69 VSS 0.07799f $ **FLOATING
C65 VDD.t21 VSS 0.15599f $ **FLOATING
C66 VDD.n74 VSS 0.88006f $ **FLOATING
C67 VDD.n75 VSS 0.02106f $ **FLOATING
C68 VDD.n77 VSS 0.0175f $ **FLOATING
C69 VDD.n80 VSS 0.01722f $ **FLOATING
C70 VDD.n81 VSS 0.01084f $ **FLOATING
C71 VDD.n82 VSS 0.01084f $ **FLOATING
C72 VDD.n83 VSS 0.01167f $ **FLOATING
C73 VDD.n86 VSS 0.01731f $ **FLOATING
C74 VDD.n87 VSS 0.01088f $ **FLOATING
C75 VDD.n89 VSS 0.03563f $ **FLOATING
C76 VDD.n90 VSS 0.03651f $ **FLOATING
C77 VDD.n92 VSS 0.03294f $ **FLOATING
C78 VDD.n93 VSS 0.01529f $ **FLOATING
C79 VDD.n94 VSS 0.03719f $ **FLOATING
C80 VDD.n96 VSS 0.05833f $ **FLOATING
C81 VDD.n97 VSS 0.03318f $ **FLOATING
C82 VDD.n98 VSS 0.24868f $ **FLOATING
C83 VDD.n99 VSS 0.04542f $ **FLOATING
C84 VDD.n100 VSS 0.06867f $ **FLOATING
C85 VDD.t13 VSS 0.01172f $ **FLOATING
C86 VDD.n101 VSS 0.03354f $ **FLOATING
C87 VDD.n103 VSS 0.04946f $ **FLOATING
C88 VDD.t12 VSS 2.06143f $ **FLOATING
C89 VDD.n105 VSS 0.02356f $ **FLOATING
C90 VDD.n107 VSS 0.02206f $ **FLOATING
C91 VDD.n108 VSS 0.02206f $ **FLOATING
C92 VDD.n110 VSS 0.02219f $ **FLOATING
C93 VDD.n111 VSS 0.56696f $ **FLOATING
C94 VDD.n112 VSS 0.18508f $ **FLOATING
C95 VDD.n113 VSS 0.13393f $ **FLOATING
C96 VDD.n114 VSS 0.05036f $ **FLOATING
C97 VDD.n115 VSS 0.0206f $ **FLOATING
C98 VDD.n116 VSS 0.029f $ **FLOATING
C99 VDD.n117 VSS 0.35324f $ **FLOATING
C100 ring_inv_0.A.t8 VSS 0.10399f $ **FLOATING
C101 ring_inv_0.A.t5 VSS 0.05873f $ **FLOATING
C102 ring_inv_0.A.t3 VSS 0.06543f $ **FLOATING
C103 ring_inv_0.A.t4 VSS 0.06972f $ **FLOATING
C104 ring_inv_0.A.n0 VSS 0.08787f $ **FLOATING
C105 ring_inv_0.A.n1 VSS 0.04362f $ **FLOATING
C106 ring_inv_0.A.t0 VSS 0.09829f $ **FLOATING
C107 ring_inv_0.A.t2 VSS 0.11791f $ **FLOATING
C108 ring_inv_0.A.t1 VSS 0.10901f $ **FLOATING
C109 ring_inv_0.A.n2 VSS 0.10457f $ **FLOATING
C110 ring_inv_0.A.n3 VSS 0.054f $ **FLOATING
C111 ring_inv_0.A.n4 VSS 0.10681f $ **FLOATING
C112 ring_inv_0.A.t6 VSS 0.5752f $ **FLOATING
C113 ring_inv_0.A.t7 VSS 0.57991f $ **FLOATING
C114 ring_inv_0.A.n5 VSS 0.36665f $ **FLOATING
C115 ring_inv_0.A.n6 VSS 0.11172f $ **FLOATING
C116 VCAP.t9 VSS 1.90835f $ **FLOATING
C117 VCAP.t10 VSS 0.01531f $ **FLOATING
C118 VCAP.n2 VSS 0.01841f $ **FLOATING
C119 VCAP.n3 VSS 0.36166f $ **FLOATING
C120 VCAP.n11 VSS 0.01276f $ **FLOATING
C121 VCAP.n12 VSS 1.42679f $ **FLOATING
.ends
