** sch_path: /foss/designs/xschemas/POR.sch
.subckt POR VDD RESET VBIAS VSS Nbulk
*.PININFO VSS:B VDD:B RESET:O VBIAS:I nbulk:B
XSCHMITT1 VSS VDD net2 net1 Nbulk Pbulk ring_schmitt
C1 VSS net1 cap_cmim w=40e-6 l=20e-6
M1 VSS VDD net1 Pbulk sg13_lv_pmos w=9.96u l=0.13u ng=12
XINV1 VDD Pbulk RESET net2 nbulk VSS ring_inv
M2 net1 net3 VDD Pbulk sg13_lv_pmos w=0.5u l=0.5u ng=1 m=2
M3 net3 net3 VDD Pbulk sg13_lv_pmos w=0.5u l=0.5u ng=1 m=2
M4 net3 VBIAS VSS nbulk sg13_hv_nmos w=0.5u l=2u ng=1
R1 VDD Pbulk ntap1 A=24.831e-12 P=166.14e-6
R2 VSS nbulk ptap1 A=12.969e-12 P=88.26e-6
M5 VDD VDD VDD Pbulk sg13_lv_pmos w=0.5u l=0.5u ng=1 m=4
.ends

* expanding   symbol:  /foss/designs/xschemas/ring_schmitt.sym # of pins=4
** sym_path: /foss/designs/xschemas/ring_schmitt.sym
** sch_path: /foss/designs/xschemas/ring_schmitt.sch
.subckt ring_schmitt VSS VDD Y A nbulk pbulk
*.PININFO A:I Y:O VDD:B VSS:B
M1 Y A VSPL nbulk sg13_lv_nmos w=10u l=0.13u ng=5
M2 Y A net1 pbulk sg13_lv_pmos w=6.25u l=0.13u ng=5
M3 VSPL A VSS nbulk sg13_lv_nmos w=0.155u l=0.5u ng=1
M4 net1 A VDD pbulk sg13_lv_pmos w=0.5u l=0.5u ng=1
M5 VSS Y net1 pbulk sg13_lv_pmos w=2.5u l=1u ng=1
M6 VDD Y VSPL nbulk sg13_lv_nmos w=2.945u l=0.5u ng=19
.ends

* expanding   symbol:  /foss/designs/xschemas/ring_inv.sym # of pins=6
** sym_path: /foss/designs/xschemas/ring_inv.sym
** sch_path: /foss/designs/xschemas/ring_inv.sch
.subckt ring_inv VDP Pbulk Y A Nbulk VSN
*.PININFO A:I Y:O Pbulk:B Nbulk:B VDP:B VSN:B
M1 Y A VSN Nbulk sg13_lv_nmos w=0.7u l=0.13u ng=1
M2 Y A VDP Pbulk sg13_lv_pmos w=1.12u l=0.13u ng=1
.ends
