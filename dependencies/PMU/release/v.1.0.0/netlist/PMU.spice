** sch_path: /foss/designs/xschemas/PMU.sch
.subckt PMU VBG VSS VDD1v5 VDD1v2 IOVDD Nbulk
*.PININFO IOVDD:B VDD1v2:B VBG:O VSS:B VDD1v5:B Nbulk:B
x1 IOVDD VSS Nbulk VBG bgr
x2 IOVDD Nbulk VDD1v5 VBG VSS ldo_1v5_y
x3 IOVDD Nbulk VDD1v2 VBG VSS ldo_1v2_a
.ends

* expanding   symbol:  /foss/designs/xschemas/Ali/bgr.sym # of pins=4
** sym_path: /foss/designs/xschemas/Ali/bgr.sym
** sch_path: /foss/designs/xschemas/Ali/bgr.sch
.subckt bgr IOVDD VSS Nbulk VBG
*.PININFO VBG:B IOVDD:B VSS:B Nbulk:B
M13 VN net2 IOVDD Pbulk sg13_hv_pmos w=6u l=2u ng=2
M17 VSS VP VN Nbulk sg13_hv_nmos w=5u l=1u ng=1
M14 VP net2 IOVDD Pbulk sg13_hv_pmos w=24u l=2u ng=4
M15 VBG net2 IOVDD Pbulk sg13_hv_pmos w=10u l=1.8u ng=8
M16 VSS Vt Vt Nbulk sg13_hv_nmos w=25u l=1.5u ng=8
M18 IOVDD net1 VN Nbulk sg13_hv_nmos w=2u l=5u ng=1
M20 net1 VBG IOVDD Pbulk sg13_hv_pmos w=0.5u l=10u ng=1
M21 net1 VBG VSS Nbulk sg13_hv_nmos w=10u l=1u ng=1
x1 IOVDD net2 VP VN VSS PbulkO Nbulk opm_fixed
R4 IOVDD Pbulk ntap1 A=38.94e-12 P=259.6e-6
R5 VSS Nbulk ptap1 A=131.19e-12 P=795.16e-6
R6 IOVDD PbulkO ntap1 A=51.216e-12 P=341.44e-6
M1 VN IOVDD IOVDD Pbulk sg13_hv_pmos w=6u l=2u ng=1
M2 VSS VSS VSS Nbulk sg13_hv_nmos w=13.43u l=1.5u ng=2 m=2
M3 IOVDD IOVDD IOVDD Pbulk sg13_hv_pmos w=3.295u l=0.5u ng=1 m=2
M4 IOVDD IOVDD IOVDD Pbulk sg13_hv_pmos w=6u l=2u ng=2
R7 VSS VSS rppd w=0.5e-6 l=1.905e-6 m=24 b=0 ps=0e-6
R13 Vt VP rppd w=0.5e-6 l=39.6e-6 m=1 b=0 ps=0e-6
R14 VSS VP rppd w=0.5e-6 l=11.43e-6 m=1 b=0 ps=0e-6
R9 VSS net3 rppd w=0.5e-6 l=11.43e-6 m=4 b=0 ps=0e-6
R8 VBG net4 rppd w=0.5e-6 l=11.43e-6 m=2 b=0 ps=0e-6
R10 net3 net4 rppd w=0.5e-6 l=13.2e-6 m=1 b=0 ps=0e-6
.ends

* expanding   symbol:  /foss/designs/xschemas/ldo_1v5_y.sym # of pins=5
** sym_path: /foss/designs/xschemas/ldo_1v5_y.sym
** sch_path: /foss/designs/xschemas/ldo_1v5_y.sch
.subckt ldo_1v5_y IOVDD Nbulk VDD1v5 VBG VSS
*.PININFO VDD1v5:B VBG:B IOVDD:B VSS:B Nbulk:B
M1 net1 net1 IOVDD Pbulk sg13_hv_pmos w=5u l=1u ng=1 m=2
M2 net1 Vfb net3 Nbulk sg13_hv_nmos w=10u l=2u ng=1 m=2
M3 net2 net1 IOVDD Pbulk sg13_hv_pmos w=5u l=1u ng=1 m=2
M5 net2 VBG net3 Nbulk sg13_hv_nmos w=10u l=2u ng=1 m=2
M6 vref vref IOVDD Pbulk sg13_hv_pmos w=0.5u l=10u ng=1
M4 net3 vref VSS Nbulk sg13_hv_nmos w=4.5u l=2u ng=1 m=2
M7 vref vref VSS Nbulk sg13_hv_nmos w=4.5u l=2u ng=1
M8 VDD1v5 net2 IOVDD Pbulk sg13_hv_pmos w=399.9u l=1u ng=40
R1 net2 net4 rhigh w=0.7e-6 l=5.7e-6 m=1 b=1 ps=0.18e-6
R2 VDD1v5 Vfb rhigh w=0.5e-6 l=17e-6 m=1 b=1 ps=0.18e-6
R3 Vfb VSS rhigh w=0.5e-6 l=34e-6 m=1 b=1 ps=0.18e-6
C1 net4 VDD1v5 cap_cmim w=33.85e-6 l=47.23e-6
R5 IOVDD Pbulk ntap1 A=56.376e-12 P=375.84e-6
R6 VSS Nbulk ptap1 A=59.9255e-12 P=351.41e-6
R4 VSS VSS rhigh w=0.5e-6 l=1.7e-6 m=10 b=1 ps=0.18e-6
M9 VSS VSS VSS Nbulk sg13_hv_nmos w=4.5u l=2u ng=1
M10 VSS VSS vref Nbulk sg13_hv_nmos w=4.5u l=2u ng=1
M11 VSS VSS VSS Nbulk sg13_hv_nmos w=10u l=2u ng=1 m=4
M12 IOVDD IOVDD IOVDD Pbulk sg13_hv_pmos w=5u l=1u ng=1 m=4
.ends

* expanding   symbol:  /foss/designs/xschemas/ldo_1v2_a.sym # of pins=5
** sym_path: /foss/designs/xschemas/ldo_1v2_a.sym
** sch_path: /foss/designs/xschemas/ldo_1v2_a.sch
.subckt ldo_1v2_a IOVDD Nbulk VDD1v2 VBG VSS
*.PININFO VDD1v2:B VBG:B IOVDD:B VSS:B Nbulk:B
M1 net1 net1 IOVDD Pbulk sg13_hv_pmos w=5u l=1u ng=1 m=2
M2 net1 Vfb net3 Nbulk sg13_hv_nmos w=10u l=2u ng=1 m=2
M3 net2 net1 IOVDD Pbulk sg13_hv_pmos w=5u l=1u ng=1 m=2
M5 net2 VBG net3 Nbulk sg13_hv_nmos w=10u l=2u ng=1 m=2
M6 vref vref IOVDD Pbulk sg13_hv_pmos w=0.5u l=10u ng=1
M4 net3 vref VSS Nbulk sg13_hv_nmos w=4.5u l=2u ng=1 m=2
M7 vref vref VSS Nbulk sg13_hv_nmos w=4.5u l=2u ng=1
M8 VDD1v2 net2 IOVDD PbulkP sg13_hv_pmos w=10u l=1u ng=1 m=35
R1 net2 net4 rhigh w=0.52e-6 l=7.87e-6 m=1 b=0 ps=0
R2 VDD1v2 Vfb rhigh w=0.5e-6 l=3.84e-6 m=1 b=0 ps=0
R3 Vfb VSS rhigh w=0.5e-6 l=19.2e-6 m=1 b=0 ps=0
C1 net4 VDD1v2 cap_cmim w=33.85e-6 l=47.23e-6
R5 IOVDD Pbulk ntap1 A=23.016e-12 P=153.44e-6
R6 VSS Nbulk ptap1 A=52.3527e-12 P=304.37e-6
R7 IOVDD PbulkP ntap1 A=33.504e-12 P=223.36e-6
R4 VSS VSS rhigh w=0.5e-6 l=0.96e-6 m=12 b=0 ps=0
M9 VSS VSS VSS Nbulk sg13_hv_nmos w=4.5u l=2u ng=1
M10 VSS VSS vref Nbulk sg13_hv_nmos w=4.5u l=2u ng=1
M11 VSS VSS VSS Nbulk sg13_hv_nmos w=10u l=2u ng=1 m=4
M12 IOVDD IOVDD IOVDD Pbulk sg13_hv_pmos w=5u l=1u ng=1 m=4
.ends

* expanding   symbol:  /foss/designs/xschemas/Ali/opm_fixed.sym # of pins=7
** sym_path: /foss/designs/xschemas/Ali/opm_fixed.sym
** sch_path: /foss/designs/xschemas/Ali/opm_fixed.sch
.subckt opm_fixed IOVDD out_opm vp_VBG1V vn_VBG1V VSS Pbulk Nbulk
*.PININFO vp_VBG1V:I vn_VBG1V:I IOVDD:B out_opm:O VSS:B Nbulk:B Pbulk:B
M5 out_opm vbias IOVDD Pbulk sg13_hv_pmos w=60u l=1.5u ng=8
M6 VSS net2 net2 Nbulk sg13_hv_nmos w=2.5u l=6u ng=1 m=2
C2 out_opm net1 cap_cmim w=40e-6 l=40e-6
M7 net2 vn_VBG1V net3 Pbulk sg13_hv_pmos w=4u l=1u ng=1 m=2
M8 VSS net2 net1 Nbulk sg13_hv_nmos w=2.5u l=6u ng=1 m=2
M9 net1 vp_VBG1V net3 Pbulk sg13_hv_pmos w=4u l=1u ng=1 m=2
M10 VSS net1 out_opm Nbulk sg13_hv_nmos w=35u l=6u ng=4
M11 net3 vbias IOVDD Pbulk sg13_hv_pmos w=5u l=5u ng=1
M12 vbias vbias IOVDD Pbulk sg13_hv_pmos w=25u l=2u ng=4
M19 vbias vbias VSS Nbulk sg13_hv_nmos w=9.99u l=6u ng=3
M1 VSS VSS VSS Nbulk sg13_hv_nmos w=2.5u l=0.5u ng=1 m=4
M2 IOVDD IOVDD IOVDD Pbulk sg13_hv_pmos w=4u l=0.5u ng=1 m=4
M3 IOVDD IOVDD IOVDD Pbulk sg13_hv_pmos w=5u l=0.5u ng=1 m=2
.ends

.GLOBAL VSS
