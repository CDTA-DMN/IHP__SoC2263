* NGSPICE file created from PMU.ext - technology: ihp-sg13g2

.subckt PMU VBG_1V IOVSS VDD_1v5 VDD_1v2 IOVDD
X0 a_12211_2096.t1 a_12211_1788.t0 IOVSS.t19 rhigh l=3.58u w=0.5u
X1 VDD_1v5.t11 ldo_1v5_y_0.second_stage_1v5_0.dmv.t5 ldo_1v2_a_0.VDD.t21 ldo_1v2_a_0.VDD.t0 sg13_hv_pmos ad=2.5327p pd=13.71u as=2.5327p ps=13.71u w=13.33u l=1u
X2 a_5285_743.t0 a_5563_572.t1 IOVSS.t40 rhigh l=0.96u w=0.5u
X3 bgr_0.v8t.t9 bgr_0.v8t.t1 IOVSS.t53 IOVSS.t47 sg13_hv_nmos ad=1.0625p pd=6.93u as=1.0625p ps=6.93u w=3.125u l=1.5u
X4 IOVSS.t145 IOVSS.t146 IOVSS.t0 rppd l=1.905u w=0.5u
X5 a_13967_15066.t0 IOVSS.t28 IOVSS.t0 rppd l=1.905u w=0.5u
X6 ldo_1v2_a_0.VDD.t67 bgr_0.out_opm.t8 VBG_1V.t7 ldo_1v2_a_0.VDD.t33 sg13_hv_pmos ad=0.2375p pd=1.63u as=0.425p ps=3.18u w=1.25u l=1.8u
X7 IOVSS.t232 IOVSS.t233 IOVSS.t20 rppd l=1.905u w=0.5u
X8 IOVSS.t124 IOVSS.t109 IOVSS.t123 IOVSS.t110 sg13_hv_nmos ad=3.4p pd=20.68u as=0 ps=0 w=10u l=2u
X9 a_4693_228.t1 a_5127_228.t0 IOVSS.t18 rhigh l=0.96u w=0.5u
X10 VDD_1v2.t3 ldo_1v2_a_0.first_stage_0/diff_pairs_0.dmr.t5 ldo_1v2_a_0.VDD.t46 ldo_1v2_a_0.VDD.t35 sg13_hv_pmos ad=3.325p pd=17.88u as=3.325p ps=17.88u w=17.5u l=1u
X11 VDD_1v5.t14 ldo_1v5_y_0.second_stage_1v5_0.dmv.t5 ldo_1v2_a_0.VDD.t19 ldo_1v2_a_0.VDD.t0 sg13_hv_pmos ad=2.5327p pd=13.71u as=2.5327p ps=13.71u w=13.33u l=1u
X12 bgr_0.vp.t3 bgr_0.out_opm.t9 ldo_1v2_a_0.VDD.t74 ldo_1v2_a_0.VDD.t33 sg13_hv_pmos ad=1.14p pd=6.38u as=1.14p ps=6.38u w=6u l=2u
X13 a_12893_15554.t1 a_13360_15724.t0 IOVSS.t9 rppd l=1.905u w=0.5u
X14 ldo_1v2_a_0.VDD.t37 ldo_1v2_a_0.first_stage_0/diff_pairs_0.dmr.t5 VDD_1v2.t4 ldo_1v2_a_0.VDD.t35 sg13_hv_pmos ad=3.325p pd=17.88u as=3.325p ps=17.88u w=17.5u l=1u
X15 ldo_1v2_a_0.VDD.t2 ldo_1v5_y_0.second_stage_1v5_0.dmv.t5 VDD_1v5.t13 ldo_1v2_a_0.VDD.t0 sg13_hv_pmos ad=2.5327p pd=13.71u as=2.5327p ps=13.71u w=13.33u l=1u
X16 IOVSS.t121 IOVSS.t63 IOVSS.t120 IOVSS.t64 sg13_hv_nmos ad=3.4p pd=20.68u as=0 ps=0 w=10u l=2u
X17 a_12893_11222.t1 a_13360_11052.t0 IOVSS.t9 rppd l=1.905u w=0.5u
X18 VDD_1v5.t0 ldo_1v5_y_0.second_stage_1v5_0.dmv.t5 ldo_1v2_a_0.VDD.t24 ldo_1v2_a_0.VDD.t0 sg13_hv_pmos ad=2.5327p pd=13.71u as=2.5327p ps=13.71u w=13.33u l=1u
X19 IOVSS.t171 IOVSS.t172 IOVSS.t20 rppd l=1.905u w=0.5u
X20 a_12834_14386.t0 bgr_0.v8t.t0 IOVSS.t147 rppd l=2.2u w=0.5u
X21 IOVSS.t52 bgr_0.v8t.t1 bgr_0.v8t.t8 IOVSS.t51 sg13_hv_nmos ad=1.0625p pd=6.93u as=1.0625p ps=6.93u w=3.125u l=1.5u
X22 ldo_1v2_a_0.VDD.t9 ldo_1v5_y_0.second_stage_1v5_0.dmv.t5 VDD_1v5.t7 ldo_1v2_a_0.VDD.t0 sg13_hv_pmos ad=2.5327p pd=13.71u as=2.5327p ps=13.71u w=13.33u l=1u
X23 ldo_1v2_a_0.VDD.t53 ldo_1v2_a_0.first_stage_0/diff_pairs_0.dmr.t5 VDD_1v2.t10 ldo_1v2_a_0.VDD.t35 sg13_hv_pmos ad=5.95p pd=35.68u as=3.325p ps=17.88u w=17.5u l=1u
X24 bgr_0.opm_bgr_0.bgr_second_stage_0.bgr_second_stage_cs_0.Vos1.t3 bgr_0.opm_bgr_0.bgr_first_stage_0/bgr_diff_0.ref.t0 IOVSS.t61 IOVSS.t60 sg13_hv_nmos ad=0.85p pd=5.68u as=0.85p ps=5.68u w=2.5u l=6u
X25 bgr_0.out_opm.t1 bgr_0.opm_bgr_0.bgr_second_stage_0.bgr_second_stage_cs_0.Vos1.t5 IOVSS.t17 IOVSS.t15 sg13_hv_nmos ad=1.6625p pd=9.13u as=2.975p ps=18.18u w=8.75u l=6u
X26 IOVSS.t155 IOVSS.t156 IOVSS.t20 rppd l=1.905u w=0.5u
X27 a_13967_13898.t1 a_14434_13728.t0 IOVSS.t0 rppd l=1.905u w=0.5u
X28 a_12834_13558.t0 a_13360_13388.t1 IOVSS.t147 rppd l=2.2u w=0.5u
X29 ldo_1v5_y_0.first_stage$1_0/bias_cur$1_0.i_ref.t0 ldo_1v5_y_0.first_stage$1_0/bias_cur$1_0.i_ref.t1 IOVSS.t239 IOVSS.t241 sg13_hv_nmos ad=0.855p pd=4.88u as=0.855p ps=4.88u w=4.5u l=2u
X30 a_3979_915.t0 IOVSS.t144 IOVSS.t143 rhigh l=0.96u w=0.5u
X31 VBG_1V.t6 bgr_0.out_opm.t10 ldo_1v2_a_0.VDD.t68 ldo_1v2_a_0.VDD.t33 sg13_hv_pmos ad=0.425p pd=3.18u as=0.2375p ps=1.63u w=1.25u l=1.8u
X32 bgr_0.v8t.t7 bgr_0.v8t.t1 IOVSS.t50 IOVSS.t41 sg13_hv_nmos ad=1.0625p pd=6.93u as=1.0625p ps=6.93u w=3.125u l=1.5u
X33 ldo_1v2_a_0.VDD.t61 bgr_0.opm_bgr_0.bgr_second_stage_0.bgr_second_stage_al_0.Vbias.t4 bgr_0.opm_bgr_0.bgr_second_stage_0.bgr_second_stage_al_0.Vbias.t5 ldo_1v2_a_0.VDD.t64 sg13_hv_pmos ad=0.95p pd=5.38u as=0.95p ps=5.38u w=5u l=2u
X34 ldo_1v2_a_0.VDD.t71 ldo_1v2_a_0.VDD.t132 ldo_1v2_a_0.VDD.t71 ldo_1v2_a_0.VDD.t33 sg13_hv_pmos ad=1.14p pd=6.38u as=0 ps=0 w=6u l=2u
X35 a_12834_12390.t1 a_13360_12560.t1 IOVSS.t147 rppd l=2.2u w=0.5u
X36 a_13967_12050.t0 IOVSS.t62 IOVSS.t0 rppd l=1.905u w=0.5u
X37 a_3979_572.t1 a_4257_743.t1 IOVSS.t143 rhigh l=0.96u w=0.5u
X38 VDD_1v5.t15 ldo_1v5_y_0.second_stage_1v5_0.dmv.t5 ldo_1v2_a_0.VDD.t15 ldo_1v2_a_0.VDD.t0 sg13_hv_pmos ad=4.5322p pd=27.34u as=2.5327p ps=13.71u w=13.33u l=1u
X39 ldo_1v2_a_0.VDD.t131 ldo_1v2_a_0.VDD.t129 ldo_1v2_a_0.VDD.t130 ldo_1v2_a_0.VDD.t60 sg13_hv_pmos ad=1.7p pd=10.68u as=0 ps=0 w=5u l=0.5u
X40 ldo_1v2_a_0.VDD.t139 bgr_0.opm_bgr_0.bgr_second_stage_0.bgr_second_stage_al_0.Vbias.t10 bgr_0.out_opm.t7 ldo_1v2_a_0.VDD.t60 sg13_hv_pmos ad=1.425p pd=7.88u as=2.55p ps=15.68u w=7.5u l=1.5u
X41 IOVSS.t207 IOVSS.t208 IOVSS.t0 rppd l=1.905u w=0.5u
X42 bgr_0.out_opm.t6 bgr_0.opm_bgr_0.bgr_second_stage_0.bgr_second_stage_al_0.Vbias.t10 ldo_1v2_a_0.VDD.t140 ldo_1v2_a_0.VDD.t60 sg13_hv_pmos ad=2.55p pd=15.68u as=1.425p ps=7.88u w=7.5u l=1.5u
X43 IOVSS.t59 bgr_0.opm_bgr_0.bgr_first_stage_0/bgr_diff_0.ref.t0 bgr_0.opm_bgr_0.bgr_first_stage_0/bgr_diff_0.ref.t2 IOVSS.t58 sg13_hv_nmos ad=0.85p pd=5.68u as=0.85p ps=5.68u w=2.5u l=6u
X44 IOVSS.t210 IOVSS.t211 IOVSS.t0 rppd l=1.905u w=0.5u
X45 IOVSS.t179 bgr_0.opm_bgr_0.bgr_second_stage_0.bgr_second_stage_al_0.Vbias.t0 bgr_0.opm_bgr_0.bgr_second_stage_0.bgr_second_stage_al_0.Vbias.t1 IOVSS.t178 sg13_hv_nmos ad=1.1322p pd=7.34u as=0.6327p ps=3.71u w=3.33u l=6u
X46 a_5285_400.t1 a_5563_228.t0 IOVSS.t40 rhigh l=0.96u w=0.5u
X47 bgr_0.inv_out.t3 VBG_1V.t8 IOVSS.t136 IOVSS.t137 sg13_hv_nmos ad=0.2375p pd=1.63u as=0.2375p ps=1.63u w=1.25u l=1u
X48 a_15041_14896.t1 a_15508_15066.t1 IOVSS.t20 rppd l=1.905u w=0.5u
X49 IOVSS.t194 IOVSS.t195 IOVSS.t35 rhigh l=0.96u w=0.5u
X50 ldo_1v2_a_0.VDD.t66 bgr_0.out_opm.t8 VBG_1V.t5 ldo_1v2_a_0.VDD.t33 sg13_hv_pmos ad=0.2375p pd=1.63u as=0.425p ps=3.18u w=1.25u l=1.8u
X51 bgr_0.opm_bgr_0.bgr_first_stage_0/bgr_bias_0.VbD.t1 bgr_0.vn.t3 bgr_0.opm_bgr_0.bgr_first_stage_0/bgr_diff_0.ref.t3 ldo_1v2_a_0.VDD.t31 sg13_hv_pmos ad=1.36p pd=8.68u as=1.36p ps=8.68u w=4u l=1u
X52 a_4693_915.t1 a_5127_400.t0 IOVSS.t18 rhigh l=0.96u w=0.5u
X53 ldo_1v2_a_0.VDD.t74 bgr_0.out_opm.t9 bgr_0.vn.t1 ldo_1v2_a_0.VDD.t33 sg13_hv_pmos ad=1.14p pd=6.38u as=1.14p ps=6.38u w=6u l=2u
X54 a_14982_13218.t1 a_15508_13388.t1 IOVSS.t8 rppd l=2.2u w=0.5u
X55 ldo_1v2_a_0.VDD.t24 ldo_1v5_y_0.second_stage_1v5_0.dmv.t5 VDD_1v5.t1 ldo_1v2_a_0.VDD.t0 sg13_hv_pmos ad=2.5327p pd=13.71u as=2.5327p ps=13.71u w=13.33u l=1u
X56 IOVSS.t118 IOVSS.t116 ldo_1v5_y_0.first_stage$1_0/bias_cur$1_0.i_ref.t0 IOVSS.t117 sg13_hv_nmos ad=1.53p pd=9.68u as=0.855p ps=4.88u w=4.5u l=2u
X57 a_4693_743.t0 a_5127_572.t0 IOVSS.t18 rhigh l=0.96u w=0.5u
X58 VDD_1v2.t9 ldo_1v2_a_0.first_stage_0/diff_pairs_0.dmr.t5 ldo_1v2_a_0.VDD.t52 ldo_1v2_a_0.VDD.t35 sg13_hv_pmos ad=3.325p pd=17.88u as=5.95p ps=35.68u w=17.5u l=1u
X59 IOVSS.t244 IOVSS.t245 IOVSS.t29 rhigh l=0.96u w=0.5u
X60 a_4257_1087.t0 a_4693_1087.t0 IOVSS.t23 rhigh l=0.96u w=0.5u
X61 ldo_1v2_a_0.VDD.t128 ldo_1v2_a_0.VDD.t100 ldo_1v2_a_0.VDD.t127 ldo_1v2_a_0.VDD.t101 sg13_hv_pmos ad=1.36p pd=8.68u as=0 ps=0 w=4u l=0.5u
X62 ldo_1v2_a_0.VDD.t18 ldo_1v5_y_0.second_stage_1v5_0.dmv.t5 VDD_1v5.t14 ldo_1v2_a_0.VDD.t0 sg13_hv_pmos ad=2.5327p pd=13.71u as=2.5327p ps=13.71u w=13.33u l=1u
X63 VDD_1v2.t10 ldo_1v2_a_0.first_stage_0/diff_pairs_0.dmr.t5 ldo_1v2_a_0.VDD.t36 ldo_1v2_a_0.VDD.t35 sg13_hv_pmos ad=3.325p pd=17.88u as=3.325p ps=17.88u w=17.5u l=1u
X64 ldo_1v2_a_0.VDD.t125 ldo_1v2_a_0.VDD.t123 ldo_1v2_a_0.VDD.t124 ldo_1v2_a_0.VDD.t33 sg13_hv_pmos ad=1.1203p pd=7.27u as=0 ps=0 w=3.295u l=0.5u
X65 VDD_1v2.t7 ldo_1v2_a_0.first_stage_0/diff_pairs_0.dmr.t5 ldo_1v2_a_0.VDD.t49 ldo_1v2_a_0.VDD.t35 sg13_hv_pmos ad=3.325p pd=17.88u as=3.325p ps=17.88u w=17.5u l=1u
X66 ldo_1v2_a_0.VDD.t63 bgr_0.opm_bgr_0.bgr_second_stage_0.bgr_second_stage_al_0.Vbias.t4 bgr_0.opm_bgr_0.bgr_first_stage_0/bgr_bias_0.VbD.t4 ldo_1v2_a_0.VDD.t62 sg13_hv_pmos ad=1.7p pd=10.68u as=1.7p ps=10.68u w=5u l=5u
X67 VBG_1V.t4 bgr_0.out_opm.t10 ldo_1v2_a_0.VDD.t65 ldo_1v2_a_0.VDD.t33 sg13_hv_pmos ad=0.425p pd=3.18u as=0.2375p ps=1.63u w=1.25u l=1.8u
X68 a_12893_11562.t1 a_13360_11732.t2 IOVSS.t9 rppd l=1.905u w=0.5u
X69 a_12834_14726.t0 a_13360_14896.t1 IOVSS.t147 rppd l=2.2u w=0.5u
X70 a_13967_14386.t0 a_13360_13218.t0 IOVSS.t0 rppd l=1.905u w=0.5u
X71 ldo_1v2_a_0.VDD.t68 bgr_0.out_opm.t8 VBG_1V.t3 ldo_1v2_a_0.VDD.t33 sg13_hv_pmos ad=0.2375p pd=1.63u as=0.2375p ps=1.63u w=1.25u l=1.8u
X72 IOVSS.t21 IOVSS.t22 IOVSS.t20 rppd l=1.905u w=0.5u
X73 ldo_1v2_a_0.VDD.t122 ldo_1v2_a_0.VDD.t117 ldo_1v2_a_0.VDD.t121 ldo_1v2_a_0.VDD.t91 sg13_hv_pmos ad=1.7p pd=10.68u as=0 ps=0 w=5u l=1u
X74 VBG_1V.t3 bgr_0.out_opm.t8 ldo_1v2_a_0.VDD.t67 ldo_1v2_a_0.VDD.t33 sg13_hv_pmos ad=0.2375p pd=1.63u as=0.2375p ps=1.63u w=1.25u l=1.8u
X75 a_13967_13558.t0 a_14434_13388.t1 IOVSS.t0 rppd l=1.905u w=0.5u
X76 IOVSS.t183 IOVSS.t184 IOVSS.t20 rppd l=1.905u w=0.5u
X77 a_3979_228.t1 a_4257_400.t1 IOVSS.t143 rhigh l=0.96u w=0.5u
X78 IOVSS.t115 IOVSS.t94 IOVSS.t114 IOVSS.t95 sg13_hv_nmos ad=0.85p pd=5.68u as=0 ps=0 w=2.5u l=0.5u
X79 a_15041_14556.t1 a_15508_14726.t1 IOVSS.t20 rppd l=1.905u w=0.5u
X80 a_12834_13218.t1 a_13360_13218.t3 IOVSS.t147 rppd l=2.2u w=0.5u
X81 a_13967_12390.t0 a_14434_12560.t1 IOVSS.t0 rppd l=1.905u w=0.5u
X82 ldo_1v2_a_0.VDD.t119 ldo_1v2_a_0.VDD.t117 ldo_1v2_a_0.VDD.t118 ldo_1v2_a_0.VDD.t91 sg13_hv_pmos ad=1.7p pd=10.68u as=0 ps=0 w=5u l=1u
X83 a_12893_16234.t0 a_13360_16064.t0 IOVSS.t9 rppd l=1.905u w=0.5u
X84 a_12834_12050.t1 a_13360_12220.t1 IOVSS.t147 rppd l=2.2u w=0.5u
X85 IOVSS.t112 IOVSS.t109 IOVSS.t111 IOVSS.t110 sg13_hv_nmos ad=3.4p pd=20.68u as=0 ps=0 w=10u l=2u
X86 IOVSS.t165 IOVSS.t166 IOVSS.t0 rppd l=1.905u w=0.5u
X87 IOVSS.t36 IOVSS.t37 IOVSS.t35 rhigh l=0.96u w=0.5u
X88 a_13360_13218.t1 a_15508_12730.t1 IOVSS.t20 rppd l=1.905u w=0.5u
X89 ldo_1v2_a_0.first_stage_0/bias_cur_0.i_ref.t0 ldo_1v2_a_0.first_stage_0/bias_cur_0.i_ref.t1 IOVSS.t235 IOVSS.t237 sg13_hv_nmos ad=0.855p pd=4.88u as=0.855p ps=4.88u w=4.5u l=2u
X90 a_4257_228.t1 a_4693_228.t0 IOVSS.t23 rhigh l=0.96u w=0.5u
X91 a_4693_1087.t1 a_5127_1087.t0 IOVSS.t18 rhigh l=0.96u w=0.5u
X92 a_12834_13898.t1 a_13360_11732.t1 IOVSS.t147 rppd l=2.2u w=0.5u
X93 IOVSS.t149 IOVSS.t150 IOVSS.t35 rhigh l=0.96u w=0.5u
X94 IOVSS.t157 IOVSS.t158 IOVSS.t0 rppd l=1.905u w=0.5u
X95 ldo_1v2_a_0.first_stage_0/diff_pairs_0.dmv.t3 ldo_1v2_a_0.first_stage_0/diff_pairs_0.dmv.t1 ldo_1v2_a_0.VDD.t153 ldo_1v2_a_0.VDD.t105 sg13_hv_pmos ad=1.7p pd=10.68u as=1.7p ps=10.68u w=5u l=1u
X96 ldo_1v2_a_0.VDD.t49 ldo_1v2_a_0.first_stage_0/diff_pairs_0.dmr.t5 VDD_1v2.t8 ldo_1v2_a_0.VDD.t35 sg13_hv_pmos ad=3.325p pd=17.88u as=3.325p ps=17.88u w=17.5u l=1u
X97 a_13717_1480.t1 a_13717_1344.t0 IOVSS.t34 rhigh l=3.58u w=0.5u
X98 a_4693_400.t1 a_5127_400.t1 IOVSS.t18 rhigh l=0.96u w=0.5u
X99 bgr_0.opm_bgr_0.bgr_first_stage_0/bgr_diff_0.ref.t1 bgr_0.opm_bgr_0.bgr_first_stage_0/bgr_diff_0.ref.t0 IOVSS.t57 IOVSS.t56 sg13_hv_nmos ad=0.85p pd=5.68u as=0.85p ps=5.68u w=2.5u l=6u
X100 a_14982_13898.t1 a_15508_13728.t1 IOVSS.t8 rppd l=2.2u w=0.5u
X101 VDD_1v2.t1 ldo_1v2_a_0.first_stage_0/diff_pairs_0.dmr.t5 ldo_1v2_a_0.VDD.t45 ldo_1v2_a_0.VDD.t35 sg13_hv_pmos ad=3.325p pd=17.88u as=3.325p ps=17.88u w=17.5u l=1u
X102 IOVSS.t108 IOVSS.t106 ldo_1v2_a_0.first_stage_0/bias_cur_0.i_ref.t0 IOVSS.t107 sg13_hv_nmos ad=1.53p pd=9.68u as=0.855p ps=4.88u w=4.5u l=2u
X103 a_13717_2404.t0 a_13717_2096.t1 IOVSS.t34 rhigh l=3.58u w=0.5u
X104 ldo_1v2_a_0.first_stage_0/diff_pairs_0.dmr.t4 ldo_1v2_a_0.first_stage_0/diff_pairs_0.dmv.t1 ldo_1v2_a_0.VDD.t152 ldo_1v2_a_0.VDD.t105 sg13_hv_pmos ad=1.7p pd=10.68u as=1.7p ps=10.68u w=5u l=1u
X105 bgr_0.out_opm.t0 bgr_0.opm_bgr_0.bgr_second_stage_0.bgr_second_stage_cs_0.Vos1.t5 IOVSS.t16 IOVSS.t15 sg13_hv_nmos ad=1.6625p pd=9.13u as=2.975p ps=18.18u w=8.75u l=6u
X106 VDD_1v5.t8 ldo_1v5_y_0.second_stage_1v5_0.dmv.t5 ldo_1v2_a_0.VDD.t17 ldo_1v2_a_0.VDD.t0 sg13_hv_pmos ad=2.5327p pd=13.71u as=2.5327p ps=13.71u w=13.33u l=1u
X107 VBG_1V.t2 bgr_0.out_opm.t8 ldo_1v2_a_0.VDD.t66 ldo_1v2_a_0.VDD.t33 sg13_hv_pmos ad=0.2375p pd=1.63u as=0.2375p ps=1.63u w=1.25u l=1.8u
X108 ldo_1v2_a_0.VDD.t65 bgr_0.out_opm.t8 VBG_1V.t2 ldo_1v2_a_0.VDD.t33 sg13_hv_pmos ad=0.2375p pd=1.63u as=0.2375p ps=1.63u w=1.25u l=1.8u
X109 a_5285_400.t0 a_5563_572.t0 IOVSS.t40 rhigh l=0.96u w=0.5u
X110 ldo_1v2_a_0.VDD.t21 ldo_1v5_y_0.second_stage_1v5_0.dmv.t5 VDD_1v5.t12 ldo_1v2_a_0.VDD.t0 sg13_hv_pmos ad=2.5327p pd=13.71u as=2.5327p ps=13.71u w=13.33u l=1u
X111 IOVSS.t55 bgr_0.opm_bgr_0.bgr_first_stage_0/bgr_diff_0.ref.t0 bgr_0.opm_bgr_0.bgr_second_stage_0.bgr_second_stage_cs_0.Vos1.t2 IOVSS.t54 sg13_hv_nmos ad=0.85p pd=5.68u as=0.85p ps=5.68u w=2.5u l=6u
X112 bgr_0.inv_out.t1 VBG_1V.t8 IOVSS.t130 IOVSS.t140 sg13_hv_nmos ad=0.2375p pd=1.63u as=0.2375p ps=1.63u w=1.25u l=1u
X113 a_13967_14726.t0 a_14434_14896.t1 IOVSS.t0 rppd l=1.905u w=0.5u
X114 a_15041_12220.t1 a_15508_12390.t1 IOVSS.t20 rppd l=1.905u w=0.5u
X115 IOVSS.t14 bgr_0.opm_bgr_0.bgr_second_stage_0.bgr_second_stage_cs_0.Vos1.t5 bgr_0.out_opm.t1 IOVSS.t12 sg13_hv_nmos ad=2.975p pd=18.18u as=1.6625p ps=9.13u w=8.75u l=6u
X116 a_12834_14386.t1 a_13360_14556.t0 IOVSS.t147 rppd l=2.2u w=0.5u
X117 ldo_1v2_a_0.VDD.t116 ldo_1v2_a_0.VDD.t111 ldo_1v2_a_0.VDD.t115 ldo_1v2_a_0.VDD.t105 sg13_hv_pmos ad=1.7p pd=10.68u as=0 ps=0 w=5u l=1u
X118 IOVSS.t153 IOVSS.t154 IOVSS.t20 rppd l=1.905u w=0.5u
X119 IOVSS.t192 IOVSS.t193 IOVSS.t4 rhigh l=3.58u w=0.5u
X120 IOVSS.t214 IOVSS.t215 IOVSS.t35 rhigh l=0.96u w=0.5u
X121 ldo_1v2_a_0.VDD.t137 bgr_0.opm_bgr_0.bgr_second_stage_0.bgr_second_stage_al_0.Vbias.t10 bgr_0.out_opm.t5 ldo_1v2_a_0.VDD.t60 sg13_hv_pmos ad=1.425p pd=7.88u as=1.425p ps=7.88u w=7.5u l=1.5u
X122 a_12834_13558.t1 a_13360_13728.t1 IOVSS.t147 rppd l=2.2u w=0.5u
X123 a_13967_13218.t0 bgr_0.vp.t1 IOVSS.t0 rppd l=1.905u w=0.5u
X124 IOVSS.t105 IOVSS.t102 IOVSS.t104 IOVSS.t103 sg13_hv_nmos ad=1.53p pd=9.68u as=0 ps=0 w=4.5u l=2u
X125 IOVSS.t101 IOVSS.t98 IOVSS.t100 IOVSS.t99 sg13_hv_nmos ad=4.5662p pd=27.54u as=0 ps=0 w=13.43u l=1.5u
X126 a_13967_12050.t1 a_14434_12220.t0 IOVSS.t0 rppd l=1.905u w=0.5u
X127 ldo_1v2_a_0.VDD.t113 ldo_1v2_a_0.VDD.t111 ldo_1v2_a_0.VDD.t112 ldo_1v2_a_0.VDD.t105 sg13_hv_pmos ad=1.7p pd=10.68u as=0 ps=0 w=5u l=1u
X128 ldo_1v2_a_0.VDD.t110 ldo_1v2_a_0.VDD.t104 ldo_1v2_a_0.VDD.t109 ldo_1v2_a_0.VDD.t105 sg13_hv_pmos ad=1.7p pd=10.68u as=0 ps=0 w=5u l=1u
X129 VDD_1v5.t9 ldo_1v5_y_0.second_stage_1v5_0.dmv.t5 ldo_1v2_a_0.VDD.t20 ldo_1v2_a_0.VDD.t0 sg13_hv_pmos ad=2.5327p pd=13.71u as=4.5322p ps=27.34u w=13.33u l=1u
X130 a_13717_1788.t1 a_13717_1480.t0 IOVSS.t34 rhigh l=3.58u w=0.5u
X131 IOVSS.t224 IOVSS.t225 IOVSS.t4 rhigh l=3.58u w=0.5u
X132 bgr_0.out_opm.t5 bgr_0.opm_bgr_0.bgr_second_stage_0.bgr_second_stage_al_0.Vbias.t10 ldo_1v2_a_0.VDD.t138 ldo_1v2_a_0.VDD.t60 sg13_hv_pmos ad=1.425p pd=7.88u as=1.425p ps=7.88u w=7.5u l=1.5u
X133 IOVSS.t97 IOVSS.t94 IOVSS.t96 IOVSS.t95 sg13_hv_nmos ad=0.85p pd=5.68u as=0 ps=0 w=2.5u l=0.5u
X134 a_12834_12730.t1 a_13360_12560.t0 IOVSS.t147 rppd l=2.2u w=0.5u
X135 a_12893_10882.t0 VBG_1V.t0 IOVSS.t9 rppd l=1.905u w=0.5u
X136 ldo_1v2_a_0.VDD.t46 ldo_1v2_a_0.first_stage_0/diff_pairs_0.dmr.t5 VDD_1v2.t9 ldo_1v2_a_0.VDD.t35 sg13_hv_pmos ad=3.325p pd=17.88u as=3.325p ps=17.88u w=17.5u l=1u
X137 ldo_1v2_a_0.VDD.t19 ldo_1v5_y_0.second_stage_1v5_0.dmv.t5 VDD_1v5.t10 ldo_1v2_a_0.VDD.t0 sg13_hv_pmos ad=2.5327p pd=13.71u as=2.5327p ps=13.71u w=13.33u l=1u
X138 VDD_1v2.t0 a_4693_915.t0 IOVSS.t23 rhigh l=0.96u w=0.5u
X139 a_13215_2712.t1 a_13717_2404.t1 IOVSS.t34 rhigh l=3.58u w=0.5u
X140 bgr_0.opm_bgr_0.bgr_first_stage_0/bgr_bias_0.VbD.t3 bgr_0.vp.t4 bgr_0.opm_bgr_0.bgr_second_stage_0.bgr_second_stage_cs_0.Vos1.t1 ldo_1v2_a_0.VDD.t31 sg13_hv_pmos ad=1.36p pd=8.68u as=1.36p ps=8.68u w=4u l=1u
X141 ldo_1v2_a_0.VDD.t107 ldo_1v2_a_0.VDD.t104 ldo_1v2_a_0.VDD.t106 ldo_1v2_a_0.VDD.t105 sg13_hv_pmos ad=1.7p pd=10.68u as=0 ps=0 w=5u l=1u
X142 IOVSS.t93 IOVSS.t74 IOVSS.t92 IOVSS.t75 sg13_hv_nmos ad=3.4p pd=20.68u as=0 ps=0 w=10u l=2u
X143 VDD_1v5.t13 ldo_1v5_y_0.second_stage_1v5_0.dmv.t5 ldo_1v2_a_0.VDD.t18 ldo_1v2_a_0.VDD.t0 sg13_hv_pmos ad=2.5327p pd=13.71u as=2.5327p ps=13.71u w=13.33u l=1u
X144 VDD_1v2.t8 ldo_1v2_a_0.first_stage_0/diff_pairs_0.dmr.t5 ldo_1v2_a_0.VDD.t41 ldo_1v2_a_0.VDD.t35 sg13_hv_pmos ad=3.325p pd=17.88u as=3.325p ps=17.88u w=17.5u l=1u
X145 a_12713_1480.t0 a_12713_1344.t0 IOVSS.t38 rhigh l=3.58u w=0.5u
X146 IOVSS.t218 IOVSS.t219 IOVSS.t35 rhigh l=0.96u w=0.5u
X147 IOVSS.t24 IOVSS.t25 IOVSS.t20 rppd l=1.905u w=0.5u
X148 ldo_1v2_a_0.VDD.t45 ldo_1v2_a_0.first_stage_0/diff_pairs_0.dmr.t5 VDD_1v2.t7 ldo_1v2_a_0.VDD.t35 sg13_hv_pmos ad=3.325p pd=17.88u as=3.325p ps=17.88u w=17.5u l=1u
X149 a_4257_743.t0 a_4693_743.t1 IOVSS.t23 rhigh l=0.96u w=0.5u
X150 a_13967_13898.t0 IOVSS.t204 IOVSS.t0 rppd l=1.905u w=0.5u
X151 IOVSS.t176 bgr_0.opm_bgr_0.bgr_second_stage_0.bgr_second_stage_al_0.Vbias.t0 bgr_0.opm_bgr_0.bgr_second_stage_0.bgr_second_stage_al_0.Vbias.t2 IOVSS.t177 sg13_hv_nmos ad=0.6327p pd=3.71u as=1.1322p ps=7.34u w=3.33u l=6u
X152 bgr_0.v8t.t6 bgr_0.v8t.t1 IOVSS.t49 IOVSS.t47 sg13_hv_nmos ad=1.0625p pd=6.93u as=1.0625p ps=6.93u w=3.125u l=1.5u
X153 VDD_1v5.t6 ldo_1v5_y_0.second_stage_1v5_0.dmv.t5 ldo_1v2_a_0.VDD.t3 ldo_1v2_a_0.VDD.t0 sg13_hv_pmos ad=2.5327p pd=13.71u as=2.5327p ps=13.71u w=13.33u l=1u
X154 a_12713_2404.t0 a_12713_2096.t1 IOVSS.t38 rhigh l=3.58u w=0.5u
X155 bgr_0.opm_bgr_0.bgr_second_stage_0.bgr_second_stage_cs_0.Vos1.t0 bgr_0.vp.t5 bgr_0.opm_bgr_0.bgr_first_stage_0/bgr_bias_0.VbD.t2 ldo_1v2_a_0.VDD.t32 sg13_hv_pmos ad=1.36p pd=8.68u as=1.36p ps=8.68u w=4u l=1u
X156 IOVSS.t217 a_15508_15066.t0 IOVSS.t20 rppd l=1.905u w=0.5u
X157 IOVSS.t90 IOVSS.t88 IOVSS.t89 IOVSS.t45 sg13_hv_nmos ad=4.5662p pd=27.54u as=0 ps=0 w=13.43u l=1.5u
X158 IOVSS.t87 IOVSS.t70 IOVSS.t86 IOVSS.t71 sg13_hv_nmos ad=3.4p pd=20.68u as=0 ps=0 w=10u l=2u
X159 ldo_1v2_a_0.VDD.t17 ldo_1v5_y_0.second_stage_1v5_0.dmv.t5 VDD_1v5.t4 ldo_1v2_a_0.VDD.t0 sg13_hv_pmos ad=2.5327p pd=13.71u as=2.5327p ps=13.71u w=13.33u l=1u
X160 a_14721_1480.t1 a_13717_1344.t1 IOVSS.t182 rhigh l=3.58u w=0.5u
X161 ldo_1v2_a_0.VDD.t103 ldo_1v2_a_0.VDD.t100 ldo_1v2_a_0.VDD.t102 ldo_1v2_a_0.VDD.t101 sg13_hv_pmos ad=1.36p pd=8.68u as=0 ps=0 w=4u l=0.5u
X162 IOVSS.t185 IOVSS.t186 IOVSS.t0 rppd l=1.905u w=0.5u
X163 VDD_1v5.t12 ldo_1v5_y_0.second_stage_1v5_0.dmv.t5 ldo_1v2_a_0.VDD.t12 ldo_1v2_a_0.VDD.t0 sg13_hv_pmos ad=2.5327p pd=13.71u as=2.5327p ps=13.71u w=13.33u l=1u
X164 a_3979_572.t0 a_4257_400.t0 IOVSS.t143 rhigh l=0.96u w=0.5u
X165 bgr_0.opm_bgr_0.bgr_second_stage_0.bgr_second_stage_al_0.Vbias.t8 bgr_0.opm_bgr_0.bgr_second_stage_0.bgr_second_stage_al_0.Vbias.t4 ldo_1v2_a_0.VDD.t61 ldo_1v2_a_0.VDD.t60 sg13_hv_pmos ad=1.7p pd=10.68u as=0.95p ps=5.38u w=5u l=2u
X166 ldo_1v2_a_0.first_stage_0/diff_pairs_0.dmr.t1 a_6428_228.t0 IOVSS.t209 rhigh l=3.935u w=0.52u
X167 IOVSS.t26 IOVSS.t27 IOVSS.t4 rhigh l=3.58u w=0.5u
X168 a_14721_2404.t0 a_14721_2096.t0 IOVSS.t182 rhigh l=3.58u w=0.5u
X169 ldo_1v2_a_0.VDD.t15 ldo_1v5_y_0.second_stage_1v5_0.dmv.t5 VDD_1v5.t11 ldo_1v2_a_0.VDD.t0 sg13_hv_pmos ad=2.5327p pd=13.71u as=2.5327p ps=13.71u w=13.33u l=1u
X170 a_14982_13558.t1 a_15508_13388.t0 IOVSS.t8 rppd l=2.2u w=0.5u
X171 a_5127_1087.t1 a_5563_915.t1 IOVSS.t40 rhigh l=0.96u w=0.5u
X172 bgr_0.v8t.t5 bgr_0.v8t.t1 IOVSS.t48 IOVSS.t47 sg13_hv_nmos ad=1.0625p pd=6.93u as=1.0625p ps=6.93u w=3.125u l=1.5u
X173 a_15852_1685.t0 ldo_1v5_y_0.second_stage_1v5_0.dmv.t0 IOVSS.t230 rhigh l=11.58u w=0.7u
X174 a_13717_2096.t0 a_13717_1788.t0 IOVSS.t34 rhigh l=3.58u w=0.5u
X175 IOVSS.t5 IOVSS.t6 IOVSS.t4 rhigh l=3.58u w=0.5u
X176 IOVSS.t84 IOVSS.t81 IOVSS.t83 IOVSS.t82 sg13_hv_nmos ad=1.53p pd=9.68u as=0 ps=0 w=4.5u l=2u
X177 ldo_1v5_y_0.first_stage$1_0/diff_pairs$1_0.dmv.t2 ldo_1v5_y_0.first_stage$1_0/diff_pairs$1_0.dmv.t0 ldo_1v2_a_0.VDD.t148 ldo_1v2_a_0.VDD.t91 sg13_hv_pmos ad=1.7p pd=10.68u as=1.7p ps=10.68u w=5u l=1u
X178 bgr_0.inv_out.t2 VBG_1V.t8 IOVSS.t132 IOVSS.t139 sg13_hv_nmos ad=0.2375p pd=1.63u as=0.2375p ps=1.63u w=1.25u l=1u
X179 IOVSS.t80 IOVSS.t67 IOVSS.t79 IOVSS.t54 sg13_hv_nmos ad=0.85p pd=5.68u as=0 ps=0 w=2.5u l=0.5u
X180 IOVSS.t46 bgr_0.v8t.t1 bgr_0.v8t.t4 IOVSS.t45 sg13_hv_nmos ad=1.0625p pd=6.93u as=1.0625p ps=6.93u w=3.125u l=1.5u
X181 IOVSS.t39 a_15508_12050.t0 IOVSS.t20 rppd l=1.905u w=0.5u
X182 VDD_1v5.t10 ldo_1v5_y_0.second_stage_1v5_0.dmv.t5 ldo_1v2_a_0.VDD.t13 ldo_1v2_a_0.VDD.t0 sg13_hv_pmos ad=2.5327p pd=13.71u as=2.5327p ps=13.71u w=13.33u l=1u
X183 a_12713_1788.t1 a_12713_1480.t1 IOVSS.t38 rhigh l=3.58u w=0.5u
X184 a_13967_14386.t1 a_14434_14556.t1 IOVSS.t0 rppd l=1.905u w=0.5u
X185 IOVSS.t200 IOVSS.t201 IOVSS.t20 rppd l=1.905u w=0.5u
X186 ldo_1v5_y_0.second_stage_1v5_0.dmv.t3 ldo_1v5_y_0.first_stage$1_0/diff_pairs$1_0.dmv.t0 ldo_1v2_a_0.VDD.t147 ldo_1v2_a_0.VDD.t91 sg13_hv_pmos ad=1.7p pd=10.68u as=1.7p ps=10.68u w=5u l=1u
X187 a_4693_572.t1 a_5127_572.t1 IOVSS.t18 rhigh l=0.96u w=0.5u
X188 VDD_1v5.t17 a_12713_2404.t1 IOVSS.t38 rhigh l=3.58u w=0.5u
X189 a_13967_13558.t1 a_14434_13728.t1 IOVSS.t0 rppd l=1.905u w=0.5u
X190 IOVSS.t226 IOVSS.t227 IOVSS.t20 rppd l=1.905u w=0.5u
X191 IOVSS.t77 IOVSS.t74 IOVSS.t76 IOVSS.t75 sg13_hv_nmos ad=3.4p pd=20.68u as=0 ps=0 w=10u l=2u
X192 a_14721_1788.t0 a_14721_1480.t0 IOVSS.t182 rhigh l=3.58u w=0.5u
X193 IOVSS.t138 VBG_1V.t8 bgr_0.inv_out.t3 IOVSS.t137 sg13_hv_nmos ad=0.425p pd=3.18u as=0.2375p ps=1.63u w=1.25u l=1u
X194 IOVSS.t128 bgr_0.vp.t6 bgr_0.vn.t0 IOVSS.t127 sg13_hv_nmos ad=0.85p pd=5.68u as=0.475p ps=2.88u w=2.5u l=1u
X195 ldo_1v2_a_0.VDD.t13 ldo_1v5_y_0.second_stage_1v5_0.dmv.t5 VDD_1v5.t9 ldo_1v2_a_0.VDD.t0 sg13_hv_pmos ad=2.5327p pd=13.71u as=2.5327p ps=13.71u w=13.33u l=1u
X196 IOVSS.t44 bgr_0.v8t.t1 bgr_0.v8t.t3 IOVSS.t43 sg13_hv_nmos ad=1.0625p pd=6.93u as=1.0625p ps=6.93u w=3.125u l=1.5u
X197 a_13967_12730.t0 a_14434_12560.t0 IOVSS.t0 rppd l=1.905u w=0.5u
X198 ldo_1v2_a_0.first_stage_0/diff_pairs_0.dmv.t4 ldo_1v2_a_0.first_stage_0/diff_pairs_0.vn1v2.t2 ldo_1v2_a_0.first_stage_0/bias_cur_0.d_t.t0 IOVSS.t191 sg13_hv_nmos ad=3.4p pd=20.68u as=3.4p ps=20.68u w=10u l=2u
X199 VDD_1v2.t6 ldo_1v2_a_0.first_stage_0/diff_pairs_0.dmr.t5 ldo_1v2_a_0.VDD.t44 ldo_1v2_a_0.VDD.t35 sg13_hv_pmos ad=3.325p pd=17.88u as=5.95p ps=35.68u w=17.5u l=1u
X200 a_12893_16234.t1 VBG_1V.t1 IOVSS.t9 rppd l=1.905u w=0.5u
X201 ldo_1v2_a_0.VDD.t99 ldo_1v2_a_0.VDD.t90 ldo_1v2_a_0.VDD.t98 ldo_1v2_a_0.VDD.t91 sg13_hv_pmos ad=1.7p pd=10.68u as=0 ps=0 w=5u l=1u
X202 ldo_1v2_a_0.VDD.t12 ldo_1v5_y_0.second_stage_1v5_0.dmv.t5 VDD_1v5.t8 ldo_1v2_a_0.VDD.t0 sg13_hv_pmos ad=2.5327p pd=13.71u as=2.5327p ps=13.71u w=13.33u l=1u
X203 ldo_1v2_a_0.first_stage_0/diff_pairs_0.vn1v2.t1 a_4693_400.t0 IOVSS.t23 rhigh l=0.96u w=0.5u
X204 IOVSS.t202 IOVSS.t203 IOVSS.t4 rhigh l=3.58u w=0.5u
X205 ldo_1v5_y_0.second_stage_1v5_0.vfb.t1 a_14721_2404.t1 IOVSS.t182 rhigh l=3.58u w=0.5u
X206 ldo_1v2_a_0.VDD.t96 ldo_1v2_a_0.VDD.t78 ldo_1v2_a_0.VDD.t95 ldo_1v2_a_0.VDD.t79 sg13_hv_pmos ad=1.36p pd=8.68u as=0 ps=0 w=4u l=0.5u
X207 bgr_0.out_opm.t11 bgr_0.opm_bgr_0.bgr_second_stage_0.bgr_second_stage_cs_0.Vos1.t4 cap_cmim l=40u w=40u
X208 a_3979_915.t1 a_4257_1087.t1 IOVSS.t143 rhigh l=0.96u w=0.5u
X209 a_12834_15066.t1 a_13360_14896.t0 IOVSS.t147 rppd l=2.2u w=0.5u
X210 ldo_1v2_a_0.VDD.t40 ldo_1v2_a_0.first_stage_0/diff_pairs_0.dmr.t5 VDD_1v2.t2 ldo_1v2_a_0.VDD.t35 sg13_hv_pmos ad=3.325p pd=17.88u as=3.325p ps=17.88u w=17.5u l=1u
X211 IOVSS.t136 VBG_1V.t8 bgr_0.inv_out.t2 IOVSS.t135 sg13_hv_nmos ad=0.2375p pd=1.63u as=0.2375p ps=1.63u w=1.25u l=1u
X212 ldo_1v2_a_0.VDD.t93 ldo_1v2_a_0.VDD.t90 ldo_1v2_a_0.VDD.t92 ldo_1v2_a_0.VDD.t91 sg13_hv_pmos ad=1.7p pd=10.68u as=0 ps=0 w=5u l=1u
X213 VDD_1v5.t7 ldo_1v5_y_0.second_stage_1v5_0.dmv.t5 ldo_1v2_a_0.VDD.t1 ldo_1v2_a_0.VDD.t0 sg13_hv_pmos ad=2.5327p pd=13.71u as=2.5327p ps=13.71u w=13.33u l=1u
X214 ldo_1v2_a_0.VDD.t6 ldo_1v5_y_0.second_stage_1v5_0.dmv.t5 VDD_1v5.t6 ldo_1v2_a_0.VDD.t0 sg13_hv_pmos ad=2.5327p pd=13.71u as=2.5327p ps=13.71u w=13.33u l=1u
X215 a_14219_1480.t1 a_12713_1344.t1 IOVSS.t148 rhigh l=3.58u w=0.5u
X216 IOVSS.t222 IOVSS.t223 IOVSS.t29 rhigh l=0.96u w=0.5u
X217 a_12893_15894.t0 a_13360_15724.t1 IOVSS.t9 rppd l=1.905u w=0.5u
X218 a_12893_11222.t0 a_13360_11392.t0 IOVSS.t9 rppd l=1.905u w=0.5u
X219 ldo_1v2_a_0.VDD.t146 ldo_1v5_y_0.first_stage$1_0/diff_pairs$1_0.dmv.t0 ldo_1v5_y_0.second_stage_1v5_0.dmv.t4 ldo_1v2_a_0.VDD.t91 sg13_hv_pmos ad=1.7p pd=10.68u as=1.7p ps=10.68u w=5u l=1u
X220 a_12713_2096.t0 a_12713_1788.t0 IOVSS.t38 rhigh l=3.58u w=0.5u
X221 a_14219_2404.t1 a_14219_2096.t1 IOVSS.t148 rhigh l=3.58u w=0.5u
X222 bgr_0.v8t.t2 bgr_0.v8t.t1 IOVSS.t42 IOVSS.t41 sg13_hv_nmos ad=1.0625p pd=6.93u as=1.0625p ps=6.93u w=3.125u l=1.5u
X223 bgr_0.opm_bgr_0.bgr_second_stage_0.bgr_second_stage_al_0.Vbias.t6 bgr_0.opm_bgr_0.bgr_second_stage_0.bgr_second_stage_al_0.Vbias.t4 ldo_1v2_a_0.VDD.t59 ldo_1v2_a_0.VDD.t31 sg13_hv_pmos ad=0.95p pd=5.38u as=1.7p ps=10.68u w=5u l=2u
X224 ldo_1v2_a_0.VDD.t72 bgr_0.out_opm.t9 bgr_0.vp.t3 ldo_1v2_a_0.VDD.t33 sg13_hv_pmos ad=1.14p pd=6.38u as=1.14p ps=6.38u w=6u l=2u
X225 IOVSS.t205 IOVSS.t206 IOVSS.t0 rppd l=1.905u w=0.5u
X226 IOVSS.t73 IOVSS.t70 IOVSS.t72 IOVSS.t71 sg13_hv_nmos ad=3.4p pd=20.68u as=0 ps=0 w=10u l=2u
X227 a_14982_13218.t0 a_13360_12050.t0 IOVSS.t8 rppd l=2.2u w=0.5u
X228 ldo_1v2_a_0.VDD.t145 ldo_1v5_y_0.first_stage$1_0/diff_pairs$1_0.dmv.t0 ldo_1v5_y_0.first_stage$1_0/diff_pairs$1_0.dmv.t1 ldo_1v2_a_0.VDD.t91 sg13_hv_pmos ad=1.7p pd=10.68u as=1.7p ps=10.68u w=5u l=1u
X229 bgr_0.inv_out.t0 VBG_1V.t8 IOVSS.t134 IOVSS.t133 sg13_hv_nmos ad=0.2375p pd=1.63u as=0.425p ps=3.18u w=1.25u l=1u
X230 a_14721_2096.t1 a_14721_1788.t1 IOVSS.t182 rhigh l=3.58u w=0.5u
X231 a_13360_13218.t2 a_15508_14386.t1 IOVSS.t20 rppd l=1.905u w=0.5u
X232 IOVSS.t220 IOVSS.t221 IOVSS.t35 rhigh l=0.96u w=0.5u
X233 IOVSS.t13 bgr_0.opm_bgr_0.bgr_second_stage_0.bgr_second_stage_cs_0.Vos1.t5 bgr_0.out_opm.t0 IOVSS.t12 sg13_hv_nmos ad=2.975p pd=18.18u as=1.6625p ps=9.13u w=8.75u l=6u
X234 ldo_1v2_a_0.VDD.t34 VBG_1V.t9 bgr_0.inv_out.t4 ldo_1v2_a_0.VDD.t33 sg13_hv_pmos ad=0.17p pd=1.68u as=0.17p ps=1.68u w=0.5u l=10u
X235 IOVSS.t159 IOVSS.t160 IOVSS.t0 rppd l=1.905u w=0.5u
X236 ldo_1v2_a_0.VDD.t140 bgr_0.opm_bgr_0.bgr_second_stage_0.bgr_second_stage_al_0.Vbias.t10 bgr_0.out_opm.t4 ldo_1v2_a_0.VDD.t60 sg13_hv_pmos ad=1.425p pd=7.88u as=1.425p ps=7.88u w=7.5u l=1.5u
X237 a_15041_12560.t1 a_15508_12390.t0 IOVSS.t20 rppd l=1.905u w=0.5u
X238 IOVSS.t169 IOVSS.t170 IOVSS.t0 rppd l=1.905u w=0.5u
X239 IOVSS.t69 IOVSS.t67 IOVSS.t68 IOVSS.t58 sg13_hv_nmos ad=0.85p pd=5.68u as=0 ps=0 w=2.5u l=0.5u
X240 a_14982_13898.t0 a_13360_15236.t0 IOVSS.t8 rppd l=2.2u w=0.5u
X241 a_6604_1101.t0 a_6428_228.t1 IOVSS.t216 rhigh l=3.935u w=0.52u
X242 IOVSS.t180 IOVSS.t181 IOVSS.t29 rhigh l=0.96u w=0.5u
X243 a_14219_1788.t0 a_14219_1480.t0 IOVSS.t148 rhigh l=3.58u w=0.5u
X244 bgr_0.out_opm.t4 bgr_0.opm_bgr_0.bgr_second_stage_0.bgr_second_stage_al_0.Vbias.t10 ldo_1v2_a_0.VDD.t139 ldo_1v2_a_0.VDD.t60 sg13_hv_pmos ad=1.425p pd=7.88u as=1.425p ps=7.88u w=7.5u l=1.5u
X245 a_12834_14726.t1 a_13360_14556.t1 IOVSS.t147 rppd l=2.2u w=0.5u
X246 ldo_1v2_a_0.first_stage_0/bias_cur_0.d_t.t4 VBG_1V.t10 ldo_1v2_a_0.first_stage_0/diff_pairs_0.dmr.t2 IOVSS.t142 sg13_hv_nmos ad=3.4p pd=20.68u as=3.4p ps=20.68u w=10u l=2u
X247 IOVSS.t212 IOVSS.t213 IOVSS.t20 rppd l=1.905u w=0.5u
X248 ldo_1v5_y_0.second_stage_1v5_0.vfb.t0 a_14219_2404.t0 IOVSS.t148 rhigh l=3.58u w=0.5u
X249 ldo_1v2_a_0.VDD.t42 ldo_1v2_a_0.first_stage_0/diff_pairs_0.dmr.t5 VDD_1v2.t5 ldo_1v2_a_0.VDD.t35 sg13_hv_pmos ad=5.95p pd=35.68u as=3.325p ps=17.88u w=17.5u l=1u
X250 a_13215_1480.t0 a_12211_1344.t0 IOVSS.t7 rhigh l=3.58u w=0.5u
X251 VDD_1v5.t5 ldo_1v5_y_0.second_stage_1v5_0.dmv.t5 ldo_1v2_a_0.VDD.t9 ldo_1v2_a_0.VDD.t0 sg13_hv_pmos ad=4.5322p pd=27.34u as=2.5327p ps=13.71u w=13.33u l=1u
X252 a_12834_12730.t0 bgr_0.vp.t0 IOVSS.t147 rppd l=2.2u w=0.5u
X253 a_13215_2404.t1 a_13215_2096.t1 IOVSS.t7 rhigh l=3.58u w=0.5u
X254 bgr_0.opm_bgr_0.bgr_first_stage_0/bgr_diff_0.ref.t4 bgr_0.vn.t4 bgr_0.opm_bgr_0.bgr_first_stage_0/bgr_bias_0.VbD.t0 ldo_1v2_a_0.VDD.t32 sg13_hv_pmos ad=1.36p pd=8.68u as=1.36p ps=8.68u w=4u l=1u
X255 a_13967_15066.t1 a_14434_14896.t0 IOVSS.t0 rppd l=1.905u w=0.5u
X256 IOVSS.t242 IOVSS.t243 IOVSS.t20 rppd l=1.905u w=0.5u
X257 IOVSS.t2 IOVSS.t3 IOVSS.t1 rhigh l=3.58u w=0.5u
X258 bgr_0.opm_bgr_0.bgr_second_stage_0.bgr_second_stage_al_0.Vbias.t1 bgr_0.opm_bgr_0.bgr_second_stage_0.bgr_second_stage_al_0.Vbias.t0 IOVSS.t176 IOVSS.t175 sg13_hv_nmos ad=0.6327p pd=3.71u as=0.6327p ps=3.71u w=3.33u l=6u
X259 ldo_1v5_y_0.first_stage$1_0/bias_cur$1_0.d_t.t2 ldo_1v5_y_0.first_stage$1_0/bias_cur$1_0.i_ref.t1 IOVSS.t104 IOVSS.t240 sg13_hv_nmos ad=0.855p pd=4.88u as=0.855p ps=4.88u w=4.5u l=2u
X260 IOVSS.t187 IOVSS.t188 IOVSS.t1 rhigh l=3.58u w=0.5u
X261 a_12893_15554.t0 a_13360_11732.t0 IOVSS.t9 rppd l=1.905u w=0.5u
X262 ldo_1v5_y_0.first_stage$1_0/diff_pairs$1_0.dmv.t3 ldo_1v5_y_0.second_stage_1v5_0.vfb.t2 ldo_1v5_y_0.first_stage$1_0/bias_cur$1_0.d_t.t1 IOVSS.t161 sg13_hv_nmos ad=3.4p pd=20.68u as=3.4p ps=20.68u w=10u l=2u
X263 ldo_1v2_a_0.VDD.t89 ldo_1v2_a_0.VDD.t87 ldo_1v2_a_0.VDD.t88 ldo_1v2_a_0.VDD.t33 sg13_hv_pmos ad=1.1203p pd=7.27u as=0 ps=0 w=3.295u l=0.5u
X264 a_12893_10882.t1 a_13360_11052.t1 IOVSS.t9 rppd l=1.905u w=0.5u
X265 ldo_1v2_a_0.VDD.t151 ldo_1v2_a_0.first_stage_0/diff_pairs_0.dmv.t1 ldo_1v2_a_0.first_stage_0/diff_pairs_0.dmr.t3 ldo_1v2_a_0.VDD.t105 sg13_hv_pmos ad=1.7p pd=10.68u as=1.7p ps=10.68u w=5u l=1u
X266 ldo_1v5_y_0.first_stage$1_0/bias_cur$1_0.d_t.t4 VBG_1V.t11 ldo_1v5_y_0.second_stage_1v5_0.dmv.t1 IOVSS.t162 sg13_hv_nmos ad=3.4p pd=20.68u as=3.4p ps=20.68u w=10u l=2u
X267 a_14219_2096.t0 a_14219_1788.t1 IOVSS.t148 rhigh l=3.58u w=0.5u
X268 a_14982_13558.t0 a_15508_13728.t0 IOVSS.t8 rppd l=2.2u w=0.5u
X269 ldo_1v2_a_0.VDD.t150 ldo_1v2_a_0.first_stage_0/diff_pairs_0.dmv.t1 ldo_1v2_a_0.first_stage_0/diff_pairs_0.dmv.t2 ldo_1v2_a_0.VDD.t105 sg13_hv_pmos ad=1.7p pd=10.68u as=1.7p ps=10.68u w=5u l=1u
X270 ldo_1v2_a_0.first_stage_0/diff_pairs_0.dmr.t0 a_1494_3927# ldo_1v2_a_0.first_stage_0/bias_cur_0.d_t.t2 IOVSS.t191 sg13_hv_nmos ad=3.4p pd=20.68u as=3.4p ps=20.68u w=10u l=2u
X271 IOVSS.t239 ldo_1v5_y_0.first_stage$1_0/bias_cur$1_0.i_ref.t1 ldo_1v5_y_0.first_stage$1_0/bias_cur$1_0.d_t.t2 IOVSS.t238 sg13_hv_nmos ad=0.855p pd=4.88u as=0.855p ps=4.88u w=4.5u l=2u
X272 ldo_1v2_a_0.first_stage_0/diff_pairs_0.vn1v2.t0 a_4693_572.t0 IOVSS.t23 rhigh l=0.96u w=0.5u
X273 a_15041_14896.t0 a_15508_14726.t0 IOVSS.t20 rppd l=1.905u w=0.5u
X274 a_12834_13218.t0 a_13360_13388.t0 IOVSS.t147 rppd l=2.2u w=0.5u
X275 ldo_1v2_a_0.VDD.t41 ldo_1v2_a_0.first_stage_0/diff_pairs_0.dmr.t5 VDD_1v2.t6 ldo_1v2_a_0.VDD.t35 sg13_hv_pmos ad=3.325p pd=17.88u as=3.325p ps=17.88u w=17.5u l=1u
X276 a_15852_1685.t1 VDD_1v5.t16 cap_cmim l=47.23u w=33.85u
X277 a_13215_1788.t0 a_13215_1480.t1 IOVSS.t7 rhigh l=3.58u w=0.5u
X278 bgr_0.vn.t1 ldo_1v2_a_0.VDD.t85 ldo_1v2_a_0.VDD.t86 ldo_1v2_a_0.VDD.t33 sg13_hv_pmos ad=1.14p pd=6.38u as=2.04p ps=12.68u w=6u l=2u
X279 a_12834_12390.t0 a_13360_12220.t0 IOVSS.t147 rppd l=2.2u w=0.5u
X280 VDD_1v5.t2 ldo_1v5_y_0.second_stage_1v5_0.dmv.t5 ldo_1v2_a_0.VDD.t7 ldo_1v2_a_0.VDD.t0 sg13_hv_pmos ad=2.5327p pd=13.71u as=4.5322p ps=27.34u w=13.33u l=1u
X281 IOVSS.t151 IOVSS.t152 IOVSS.t0 rppd l=1.905u w=0.5u
X282 ldo_1v2_a_0.VDD.t3 ldo_1v5_y_0.second_stage_1v5_0.dmv.t5 VDD_1v5.t3 ldo_1v2_a_0.VDD.t0 sg13_hv_pmos ad=2.5327p pd=13.71u as=2.5327p ps=13.71u w=13.33u l=1u
X283 IOVSS.t189 IOVSS.t190 IOVSS.t29 rhigh l=0.96u w=0.5u
X284 ldo_1v2_a_0.first_stage_0/bias_cur_0.d_t.t3 ldo_1v2_a_0.first_stage_0/bias_cur_0.i_ref.t1 IOVSS.t83 IOVSS.t236 sg13_hv_nmos ad=0.855p pd=4.88u as=0.855p ps=4.88u w=4.5u l=2u
X285 a_13215_2712.t0 a_13215_2404.t0 IOVSS.t7 rhigh l=3.58u w=0.5u
X286 ldo_1v2_a_0.VDD.t84 ldo_1v2_a_0.VDD.t82 ldo_1v2_a_0.VDD.t83 ldo_1v2_a_0.VDD.t62 sg13_hv_pmos ad=1.7p pd=10.68u as=0 ps=0 w=5u l=0.5u
X287 IOVSS.t163 IOVSS.t164 IOVSS.t0 rppd l=1.905u w=0.5u
X288 VDD_1v2.t5 ldo_1v2_a_0.first_stage_0/diff_pairs_0.dmr.t5 ldo_1v2_a_0.VDD.t40 ldo_1v2_a_0.VDD.t35 sg13_hv_pmos ad=3.325p pd=17.88u as=3.325p ps=17.88u w=17.5u l=1u
X289 VDD_1v5.t4 ldo_1v5_y_0.second_stage_1v5_0.dmv.t5 ldo_1v2_a_0.VDD.t6 ldo_1v2_a_0.VDD.t0 sg13_hv_pmos ad=2.5327p pd=13.71u as=2.5327p ps=13.71u w=13.33u l=1u
X290 a_12211_1480.t1 a_12211_1344.t1 IOVSS.t19 rhigh l=3.58u w=0.5u
X291 IOVSS.t228 IOVSS.t229 IOVSS.t1 rhigh l=3.58u w=0.5u
X292 a_15041_12220.t0 a_15508_12050.t1 IOVSS.t20 rppd l=1.905u w=0.5u
X293 VDD_1v2.t4 ldo_1v2_a_0.first_stage_0/diff_pairs_0.dmr.t5 ldo_1v2_a_0.VDD.t38 ldo_1v2_a_0.VDD.t35 sg13_hv_pmos ad=3.325p pd=17.88u as=3.325p ps=17.88u w=17.5u l=1u
X294 IOVSS.t167 IOVSS.t168 IOVSS.t29 rhigh l=0.96u w=0.5u
X295 a_13967_14726.t1 a_14434_14556.t0 IOVSS.t0 rppd l=1.905u w=0.5u
X296 a_12211_2404.t0 a_12211_2096.t0 IOVSS.t19 rhigh l=3.58u w=0.5u
X297 ldo_1v2_a_0.VDD.t138 bgr_0.opm_bgr_0.bgr_second_stage_0.bgr_second_stage_al_0.Vbias.t10 bgr_0.out_opm.t3 ldo_1v2_a_0.VDD.t60 sg13_hv_pmos ad=1.425p pd=7.88u as=2.55p ps=15.68u w=7.5u l=1.5u
X298 IOVSS.t173 IOVSS.t174 IOVSS.t1 rhigh l=3.58u w=0.5u
X299 ldo_1v2_a_0.VDD.t57 bgr_0.opm_bgr_0.bgr_second_stage_0.bgr_second_stage_al_0.Vbias.t4 bgr_0.opm_bgr_0.bgr_second_stage_0.bgr_second_stage_al_0.Vbias.t6 ldo_1v2_a_0.VDD.t58 sg13_hv_pmos ad=0.95p pd=5.38u as=0.95p ps=5.38u w=5u l=2u
X300 ldo_1v2_a_0.VDD.t81 ldo_1v2_a_0.VDD.t78 ldo_1v2_a_0.VDD.t80 ldo_1v2_a_0.VDD.t79 sg13_hv_pmos ad=1.36p pd=8.68u as=0 ps=0 w=4u l=0.5u
X301 bgr_0.out_opm.t2 bgr_0.opm_bgr_0.bgr_second_stage_0.bgr_second_stage_al_0.Vbias.t10 ldo_1v2_a_0.VDD.t137 ldo_1v2_a_0.VDD.t60 sg13_hv_pmos ad=2.55p pd=15.68u as=1.425p ps=7.88u w=7.5u l=1.5u
X302 bgr_0.vp.t2 bgr_0.out_opm.t9 ldo_1v2_a_0.VDD.t72 ldo_1v2_a_0.VDD.t33 sg13_hv_pmos ad=1.14p pd=6.38u as=1.14p ps=6.38u w=6u l=2u
X303 ldo_1v2_a_0.first_stage_0/bias_cur_0.i_ref.t3 ldo_1v2_a_0.first_stage_0/bias_cur_0.i_ref.t2 ldo_1v2_a_0.VDD.t136 ldo_1v2_a_0.VDD.t105 sg13_hv_pmos ad=0.17p pd=1.68u as=0.17p ps=1.68u w=0.5u l=10u
X304 a_5127_228.t1 a_5563_228.t1 IOVSS.t40 rhigh l=0.96u w=0.5u
X305 IOVSS.t132 VBG_1V.t8 bgr_0.inv_out.t1 IOVSS.t131 sg13_hv_nmos ad=0.2375p pd=1.63u as=0.2375p ps=1.63u w=1.25u l=1u
X306 a_13967_12730.t1 a_13360_13218.t4 IOVSS.t0 rppd l=1.905u w=0.5u
X307 bgr_0.opm_bgr_0.bgr_second_stage_0.bgr_second_stage_al_0.Vbias.t5 bgr_0.opm_bgr_0.bgr_second_stage_0.bgr_second_stage_al_0.Vbias.t4 ldo_1v2_a_0.VDD.t57 ldo_1v2_a_0.VDD.t56 sg13_hv_pmos ad=0.95p pd=5.38u as=0.95p ps=5.38u w=5u l=2u
X308 a_12834_15066.t0 a_13360_15236.t1 IOVSS.t147 rppd l=2.2u w=0.5u
X309 IOVSS.t196 IOVSS.t197 IOVSS.t20 rppd l=1.905u w=0.5u
X310 a_13215_2096.t0 a_13215_1788.t1 IOVSS.t7 rhigh l=3.58u w=0.5u
X311 bgr_0.vn.t2 bgr_0.inv_out.t5 ldo_1v2_a_0.VDD.t135 IOVSS.t199 sg13_hv_nmos ad=0.19p pd=1.38u as=0.34p ps=2.68u w=1u l=5u
X312 bgr_0.vn.t0 bgr_0.vp.t6 IOVSS.t126 IOVSS.t125 sg13_hv_nmos ad=0.475p pd=2.88u as=0.85p ps=5.68u w=2.5u l=1u
X313 IOVSS.t66 IOVSS.t63 IOVSS.t65 IOVSS.t64 sg13_hv_nmos ad=3.4p pd=20.68u as=0 ps=0 w=10u l=2u
X314 a_12211_1788.t1 a_12211_1480.t0 IOVSS.t19 rhigh l=3.58u w=0.5u
X315 ldo_1v2_a_0.VDD.t134 bgr_0.inv_out.t5 bgr_0.vn.t2 IOVSS.t198 sg13_hv_nmos ad=0.34p pd=2.68u as=0.19p ps=1.38u w=1u l=5u
X316 a_12893_11562.t0 a_13360_11392.t1 IOVSS.t9 rppd l=1.905u w=0.5u
X317 ldo_1v2_a_0.first_stage_0/bias_cur_0.d_t.t1 a_916_3927# ldo_1v2_a_0.first_stage_0/diff_pairs_0.dmv.t0 IOVSS.t142 sg13_hv_nmos ad=3.4p pd=20.68u as=3.4p ps=20.68u w=10u l=2u
X318 IOVSS.t32 IOVSS.t33 IOVSS.t1 rhigh l=3.58u w=0.5u
X319 ldo_1v5_y_0.second_stage_1v5_0.dmv.t2 VBG_1V.t12 ldo_1v5_y_0.first_stage$1_0/bias_cur$1_0.d_t.t3 IOVSS.t161 sg13_hv_nmos ad=3.4p pd=20.68u as=3.4p ps=20.68u w=10u l=2u
X320 VDD_1v5.t3 ldo_1v5_y_0.second_stage_1v5_0.dmv.t5 ldo_1v2_a_0.VDD.t4 ldo_1v2_a_0.VDD.t0 sg13_hv_pmos ad=2.5327p pd=13.71u as=2.5327p ps=13.71u w=13.33u l=1u
X321 IOVSS.t231 a_12211_2404.t1 IOVSS.t19 rhigh l=3.58u w=0.5u
X322 a_13967_13218.t1 a_14434_13388.t0 IOVSS.t0 rppd l=1.905u w=0.5u
X323 ldo_1v5_y_0.first_stage$1_0/bias_cur$1_0.i_ref.t3 ldo_1v5_y_0.first_stage$1_0/bias_cur$1_0.i_ref.t2 ldo_1v2_a_0.VDD.t149 ldo_1v2_a_0.VDD.t91 sg13_hv_pmos ad=0.17p pd=1.68u as=0.17p ps=1.68u w=0.5u l=10u
X324 ldo_1v5_y_0.first_stage$1_0/bias_cur$1_0.d_t.t0 ldo_1v5_y_0.second_stage_1v5_0.vfb.t3 ldo_1v5_y_0.first_stage$1_0/diff_pairs$1_0.dmv.t4 IOVSS.t162 sg13_hv_nmos ad=3.4p pd=20.68u as=3.4p ps=20.68u w=10u l=2u
X325 a_6604_1101.t1 VDD_1v2.t11 cap_cmim l=47.23u w=33.85u
X326 a_15041_14556.t0 a_15508_14386.t0 IOVSS.t20 rppd l=1.905u w=0.5u
X327 a_12834_13898.t0 a_13360_13728.t0 IOVSS.t147 rppd l=2.2u w=0.5u
X328 ldo_1v2_a_0.VDD.t38 ldo_1v2_a_0.first_stage_0/diff_pairs_0.dmr.t5 VDD_1v2.t3 ldo_1v2_a_0.VDD.t35 sg13_hv_pmos ad=3.325p pd=17.88u as=3.325p ps=17.88u w=17.5u l=1u
X329 ldo_1v2_a_0.VDD.t4 ldo_1v5_y_0.second_stage_1v5_0.dmv.t5 VDD_1v5.t2 ldo_1v2_a_0.VDD.t0 sg13_hv_pmos ad=2.5327p pd=13.71u as=2.5327p ps=13.71u w=13.33u l=1u
X330 a_13967_12390.t1 a_14434_12220.t1 IOVSS.t0 rppd l=1.905u w=0.5u
X331 VDD_1v2.t2 ldo_1v2_a_0.first_stage_0/diff_pairs_0.dmr.t5 ldo_1v2_a_0.VDD.t37 ldo_1v2_a_0.VDD.t35 sg13_hv_pmos ad=3.325p pd=17.88u as=3.325p ps=17.88u w=17.5u l=1u
X332 VDD_1v5.t1 ldo_1v5_y_0.second_stage_1v5_0.dmv.t5 ldo_1v2_a_0.VDD.t2 ldo_1v2_a_0.VDD.t0 sg13_hv_pmos ad=2.5327p pd=13.71u as=2.5327p ps=13.71u w=13.33u l=1u
X333 a_12893_15894.t1 a_13360_16064.t1 IOVSS.t9 rppd l=1.905u w=0.5u
X334 IOVSS.t130 VBG_1V.t8 bgr_0.inv_out.t0 IOVSS.t129 sg13_hv_nmos ad=0.2375p pd=1.63u as=0.2375p ps=1.63u w=1.25u l=1u
X335 a_12834_12050.t0 a_13360_12050.t1 IOVSS.t147 rppd l=2.2u w=0.5u
X336 ldo_1v2_a_0.VDD.t1 ldo_1v5_y_0.second_stage_1v5_0.dmv.t5 VDD_1v5.t0 ldo_1v2_a_0.VDD.t0 sg13_hv_pmos ad=2.5327p pd=13.71u as=2.5327p ps=13.71u w=13.33u l=1u
X337 ldo_1v2_a_0.VDD.t36 ldo_1v2_a_0.first_stage_0/diff_pairs_0.dmr.t5 VDD_1v2.t1 ldo_1v2_a_0.VDD.t35 sg13_hv_pmos ad=3.325p pd=17.88u as=3.325p ps=17.88u w=17.5u l=1u
X338 a_3979_228.t0 a_4257_228.t0 IOVSS.t143 rhigh l=0.96u w=0.5u
X339 IOVSS.t30 IOVSS.t31 IOVSS.t29 rhigh l=0.96u w=0.5u
X340 ldo_1v2_a_0.VDD.t71 bgr_0.out_opm.t9 bgr_0.vp.t2 ldo_1v2_a_0.VDD.t33 sg13_hv_pmos ad=1.14p pd=6.38u as=1.14p ps=6.38u w=6u l=2u
X341 IOVSS.t10 IOVSS.t11 IOVSS.t0 rppd l=1.905u w=0.5u
X342 a_15041_12560.t0 a_15508_12730.t0 IOVSS.t20 rppd l=1.905u w=0.5u
X343 IOVSS.t235 ldo_1v2_a_0.first_stage_0/bias_cur_0.i_ref.t1 ldo_1v2_a_0.first_stage_0/bias_cur_0.d_t.t3 IOVSS.t234 sg13_hv_nmos ad=0.855p pd=4.88u as=0.855p ps=4.88u w=4.5u l=2u
X344 a_5285_743.t1 a_5563_915.t0 IOVSS.t40 rhigh l=0.96u w=0.5u
C0 a_14381_1960# a_14381_1652# 0.05861f
C1 ldo_1v2_a_0.VDD ldo_1v2_a_0.first_stage_0/diff_pairs_0.vn1v2 0.07957f
C2 a_12920_15066# a_12920_14896# 0.07815f
C3 a_5804_1087# a_5804_915# 0.0331f
C4 a_12920_14896# a_12920_14726# 0.07815f
C5 ldo_1v2_a_0.VDD VBG_1V 14.5237f
C6 a_13377_2576# VDD_1v5 0.01741f
C7 a_15127_11562# a_15127_11392# 0.06767f
C8 a_12920_14726# a_12920_14556# 0.07815f
C9 a_4501_743# a_4501_572# 0.03359f
C10 a_14053_11222# a_14053_11052# 0.06767f
C11 a_13377_2268# VDD_1v5 0.01557f
C12 ldo_1v5_y_0.second_stage_1v5_0.vfb ldo_1v5_y_0.first_stage$1_0/bias_cur$1_0.d_t 0.72751f
C13 a_14053_11052# a_14053_10882# 0.06767f
C14 a_13377_1960# VDD_1v5 0.01557f
C15 a_13879_1344# VDD_1v5 0.0174f
C16 a_12920_13728# a_12920_13558# 0.07815f
C17 ldo_1v2_a_0.VDD bgr_0.opm_bgr_0.bgr_first_stage_0/bgr_diff_0.ref 0.82051f
C18 a_13377_1652# VDD_1v5 0.01557f
C19 ldo_1v5_y_0.second_stage_1v5_0.vfb VDD_1v5 1.87583f
C20 a_1494_3927# VDD_1v2 0.1662f
C21 a_12373_2576# a_12373_2268# 0.05861f
C22 a_13879_2576# a_13879_2268# 0.05861f
C23 a_916_3927# VDD_1v2 0.16857f
C24 a_12979_16404# a_12979_16234# 0.06767f
C25 ldo_1v5_y_0.second_stage_1v5_0.dmv ldo_1v5_y_0.second_stage_1v5_0.vfb 0.41329f
C26 ldo_1v2_a_0.VDD a_15676_1771# 0.0137f
C27 a_4065_743# a_4065_572# 0.03359f
C28 a_15127_16234# a_15127_16064# 0.06767f
C29 ldo_1v5_y_0.second_stage_1v5_0.vfb a_11451_2576# 0.01015f
C30 a_4501_1087# VDD_1v2 0.01074f
C31 a_13879_2268# a_13879_1960# 0.05861f
C32 ldo_1v5_y_0.second_stage_1v5_0.vfb a_14381_2576# 0.07498f
C33 a_12920_12730# a_12920_12560# 0.07815f
C34 a_14053_15894# a_14053_15724# 0.06767f
C35 ldo_1v2_a_0.first_stage_0/diff_pairs_0.dmr VDD_1v5 0.05459f
C36 a_4065_1087# a_4065_915# 0.0331f
C37 ldo_1v5_y_0.second_stage_1v5_0.vfb a_14381_2268# 0.01005f
C38 bgr_0.opm_bgr_0.bgr_second_stage_0.bgr_second_stage_cs_0.Vos1 VBG_1V 1.83683f
C39 a_12373_1652# a_12373_1344# 0.05861f
C40 a_13879_1960# a_13879_1652# 0.05861f
C41 ldo_1v2_a_0.VDD bgr_0.opm_bgr_0.bgr_first_stage_0/bgr_bias_0.VbD 1.67916f
C42 a_14053_12390# a_14053_12220# 0.06767f
C43 a_3629_743# a_3629_572# 0.03359f
C44 ldo_1v2_a_0.first_stage_0/diff_pairs_0.vn1v2 VDD_1v2 2.02163f
C45 a_15127_12050# a_15127_11732# 0.02087f
C46 bgr_0.opm_bgr_0.bgr_first_stage_0/bgr_diff_0.ref bgr_0.opm_bgr_0.bgr_second_stage_0.bgr_second_stage_cs_0.Vos1 3.28321f
C47 a_5804_915# a_5804_743# 0.0331f
C48 VBG_1V VDD_1v2 2.74152f
C49 ldo_1v2_a_0.VDD VDD_1v5 22.3281f
C50 a_14053_11562# a_14053_11392# 0.06767f
C51 a_12875_2576# VDD_1v5 0.04488f
C52 a_12373_2268# VDD_1v5 0.01568f
C53 a_15068_14068# a_15068_13898# 0.07815f
C54 ldo_1v2_a_0.VDD ldo_1v5_y_0.second_stage_1v5_0.dmv 56.1967f
C55 a_12920_14556# a_12920_14386# 0.07815f
C56 a_12979_11052# a_12979_10882# 0.06767f
C57 a_12373_1960# VDD_1v5 0.01563f
C58 a_12875_1344# VDD_1v5 0.01835f
C59 a_12373_1652# VDD_1v5 0.01561f
C60 a_5371_915# a_5371_743# 0.0331f
C61 a_12920_13558# a_12920_13388# 0.07815f
C62 a_11871_2576# a_11871_2268# 0.05861f
C63 a_13377_2576# a_13377_2268# 0.05861f
C64 a_11451_2268# a_11871_2268# 0.0364f
C65 ldo_1v2_a_0.first_stage_0/diff_pairs_0.dmv a_1494_3927# 0.06132f
C66 a_15127_16404# a_15127_16234# 0.06767f
C67 bgr_0.opm_bgr_0.bgr_first_stage_0/bgr_bias_0.VbD bgr_0.opm_bgr_0.bgr_second_stage_0.bgr_second_stage_cs_0.Vos1 0.93675f
C68 a_14053_16234# a_14053_16064# 0.06767f
C69 ldo_1v2_a_0.first_stage_0/diff_pairs_0.dmv a_916_3927# 0.4079f
C70 a_13377_2268# a_13377_1960# 0.05861f
C71 ldo_1v5_y_0.second_stage_1v5_0.vfb a_13377_2576# 0.01015f
C72 a_11451_1960# a_11871_1960# 0.0364f
C73 bgr_0.opm_bgr_0.bgr_second_stage_0.bgr_second_stage_al_0.Vbias VBG_1V 0.21735f
C74 a_12979_15724# a_12979_15554# 0.06767f
C75 a_12920_12560# a_12920_12390# 0.07815f
C76 a_11871_1652# a_11871_1344# 0.05861f
C77 a_13377_1960# a_13377_1652# 0.05861f
C78 bgr_0.opm_bgr_0.bgr_second_stage_0.bgr_second_stage_cs_0.Vos1 VDD_1v5 0.14091f
C79 a_12920_15066# VBG_1V 0.01293f
C80 a_11451_1652# a_11871_1652# 0.0364f
C81 a_4935_915# a_4935_743# 0.0331f
C82 ldo_1v5_y_0.first_stage$1_0/diff_pairs$1_0.dmv VBG_1V 0.2753f
C83 a_12920_14896# VBG_1V 0.02281f
C84 a_15127_15236# a_15127_15066# 0.06767f
C85 a_12920_14726# VBG_1V 0.01371f
C86 a_14053_12050# a_14053_11732# 0.02087f
C87 ldo_1v2_a_0.first_stage_0/diff_pairs_0.dmr ldo_1v2_a_0.first_stage_0/bias_cur_0.d_t 0.47986f
C88 ldo_1v2_a_0.first_stage_0/diff_pairs_0.dmv ldo_1v2_a_0.first_stage_0/diff_pairs_0.vn1v2 0.36998f
C89 bgr_0.opm_bgr_0.bgr_second_stage_0.bgr_second_stage_al_0.Vbias bgr_0.opm_bgr_0.bgr_first_stage_0/bgr_diff_0.ref 0.18977f
C90 a_11871_2576# VDD_1v5 0.01729f
C91 VDD_1v2 VDD_1v5 11.1204f
C92 a_14883_2576# VDD_1v5 0.0104f
C93 a_12979_11392# a_12979_11222# 0.06767f
C94 a_11451_2268# VDD_1v5 0.01562f
C95 ldo_1v2_a_0.first_stage_0/diff_pairs_0.dmv VBG_1V 0.34388f
C96 ldo_1v5_y_0.second_stage_1v5_0.dmv a_11871_2576# 0.01101f
C97 ldo_1v5_y_0.second_stage_1v5_0.dmv a_14883_2576# 0.01432f
C98 a_11451_1960# VDD_1v5 0.01562f
C99 a_11871_1344# VDD_1v5 0.01853f
C100 a_4501_915# a_4501_743# 0.0331f
C101 a_15068_13898# a_15068_13728# 0.07815f
C102 a_11451_2576# a_11871_2576# 0.0364f
C103 a_11451_1652# VDD_1v5 0.01562f
C104 a_11451_2576# a_11451_2268# 0.05861f
C105 a_12920_13388# a_12920_13218# 0.07815f
C106 bgr_0.opm_bgr_0.bgr_second_stage_0.bgr_second_stage_al_0.Vbias bgr_0.opm_bgr_0.bgr_first_stage_0/bgr_bias_0.VbD 0.33006f
C107 a_5804_400# a_5804_228# 0.0331f
C108 a_14053_16404# a_14053_16234# 0.06767f
C109 a_4065_915# a_4065_743# 0.0331f
C110 a_12875_2268# a_12875_1960# 0.05861f
C111 a_6604_314# VDD_1v2 0.02472f
C112 ldo_1v2_a_0.VDD ldo_1v5_y_0.second_stage_1v5_0.vfb 0.16131f
C113 a_12979_16064# a_12979_15894# 0.06767f
C114 ldo_1v5_y_0.second_stage_1v5_0.vfb a_12875_2576# 0.01015f
C115 a_15127_12900# a_15127_12730# 0.06767f
C116 a_14053_16404# VBG_1V 0.01655f
C117 a_11451_1344# a_11871_1344# 0.0364f
C118 ldo_1v5_y_0.first_stage$1_0/diff_pairs$1_0.dmv ldo_1v5_y_0.first_stage$1_0/bias_cur$1_0.d_t 0.47689f
C119 a_11451_1652# a_11451_1344# 0.05861f
C120 a_15127_15724# a_15127_15554# 0.06767f
C121 a_12875_1960# a_12875_1652# 0.05861f
C122 a_12920_12390# a_12920_12220# 0.07815f
C123 a_5371_400# a_5371_228# 0.0331f
C124 a_14883_1652# a_14883_1344# 0.05861f
C125 a_12920_15236# a_12920_15066# 0.07815f
C126 a_3629_915# a_3629_743# 0.0331f
C127 ldo_1v5_y_0.first_stage$1_0/diff_pairs$1_0.dmv VDD_1v5 0.99048f
C128 ldo_1v2_a_0.VDD ldo_1v2_a_0.first_stage_0/diff_pairs_0.dmr 47.2822f
C129 a_1494_3927# ldo_1v2_a_0.first_stage_0/diff_pairs_0.vn1v2 0.08239f
C130 a_12920_12050# a_12979_11732# 0.02087f
C131 a_15127_15066# a_15127_14896# 0.06767f
C132 a_12979_11732# a_12979_11562# 0.06767f
C133 a_916_3927# ldo_1v2_a_0.first_stage_0/diff_pairs_0.vn1v2 0.10745f
C134 ldo_1v5_y_0.second_stage_1v5_0.dmv ldo_1v5_y_0.first_stage$1_0/diff_pairs$1_0.dmv 2.07288f
C135 a_15127_14896# a_15127_14726# 0.06767f
C136 a_13879_2576# VDD_1v5 0.01755f
C137 a_1494_3927# VBG_1V 0.02781f
C138 a_15127_14386# a_15068_14068# 0.02087f
C139 a_4935_400# a_4935_228# 0.0331f
C140 a_14053_14556# a_14053_14386# 0.06767f
C141 a_15127_11392# a_15127_11222# 0.06767f
C142 a_14053_14068# a_14053_13898# 0.06767f
C143 a_12920_14386# a_12920_14068# 0.0241f
C144 a_15127_14726# a_15127_14556# 0.06767f
C145 a_13879_2268# VDD_1v5 0.01557f
C146 a_916_3927# VBG_1V 0.1628f
C147 a_13879_1960# VDD_1v5 0.01557f
C148 a_14381_1344# VDD_1v5 0.01847f
C149 a_15068_13728# a_15068_13558# 0.07815f
C150 a_13879_1652# VDD_1v5 0.01557f
C151 ldo_1v2_a_0.first_stage_0/bias_cur_0.d_t VDD_1v2 0.98624f
C152 a_12979_10882# VBG_1V 0.02372f
C153 a_4501_400# a_4501_228# 0.0331f
C154 a_12373_2268# a_12373_1960# 0.05861f
C155 ldo_1v2_a_0.first_stage_0/diff_pairs_0.vn1v2 VBG_1V 0.39871f
C156 ldo_1v5_y_0.second_stage_1v5_0.vfb a_11871_2576# 0.0101f
C157 bgr_0.opm_bgr_0.bgr_second_stage_0.bgr_second_stage_cs_0.Vos1 ldo_1v2_a_0.first_stage_0/diff_pairs_0.dmr 0.01566f
C158 a_15127_16064# a_15127_15894# 0.06767f
C159 ldo_1v5_y_0.second_stage_1v5_0.vfb a_14883_2576# 0.02707f
C160 a_14053_16234# VBG_1V 0.01176f
C161 a_15127_12730# a_15127_12560# 0.06767f
C162 a_14053_15724# a_14053_15554# 0.06767f
C163 a_12373_1960# a_12373_1652# 0.05861f
C164 a_4065_400# a_4065_228# 0.0331f
C165 a_14381_1652# a_14381_1344# 0.05861f
C166 a_14053_15236# a_14053_15066# 0.06767f
C167 a_12920_12220# a_12920_12050# 0.07815f
C168 ldo_1v2_a_0.first_stage_0/diff_pairs_0.vn1v2 a_4501_400# 0.01283f
C169 ldo_1v2_a_0.first_stage_0/diff_pairs_0.dmr VDD_1v2 13.5887f
C170 ldo_1v2_a_0.VDD bgr_0.opm_bgr_0.bgr_second_stage_0.bgr_second_stage_cs_0.Vos1 6.0507f
C171 a_15127_11732# a_15127_11562# 0.06767f
C172 a_6428_314# a_6604_314# 0.13566f
C173 a_3629_400# a_3629_228# 0.0331f
C174 a_14053_11392# a_14053_11222# 0.06767f
C175 a_5371_1087# a_5371_915# 0.0331f
C176 a_12875_2268# VDD_1v5 0.0157f
C177 a_14053_13898# a_14053_13728# 0.06767f
C178 a_12875_1960# VDD_1v5 0.01565f
C179 a_13377_1344# VDD_1v5 0.01642f
C180 a_5804_572# a_5804_400# 0.0331f
C181 ldo_1v2_a_0.VDD VDD_1v2 17.1874f
C182 a_4501_915# VDD_1v2 0.02194f
C183 a_12875_1652# VDD_1v5 0.01562f
C184 a_15068_13558# a_15068_13388# 0.07815f
C185 ldo_1v5_y_0.first_stage$1_0/diff_pairs$1_0.dmv ldo_1v5_y_0.second_stage_1v5_0.vfb 0.77497f
C186 a_14053_13388# a_14053_13218# 0.06767f
C187 ldo_1v2_a_0.first_stage_0/diff_pairs_0.dmv ldo_1v2_a_0.first_stage_0/bias_cur_0.d_t 0.47689f
C188 a_12920_13218# a_12920_12900# 0.0241f
C189 bgr_0.opm_bgr_0.bgr_first_stage_0/bgr_bias_0.VbD VBG_1V 0.01958f
C190 a_11871_2268# a_11871_1960# 0.05861f
C191 a_5371_572# a_5371_400# 0.0331f
C192 a_14053_12900# a_14053_12730# 0.06767f
C193 ldo_1v5_y_0.first_stage$1_0/bias_cur$1_0.d_t VBG_1V 0.82138f
C194 a_14053_16064# a_14053_15894# 0.06767f
C195 ldo_1v5_y_0.second_stage_1v5_0.vfb a_13879_2576# 0.02536f
C196 a_11871_1960# a_11871_1652# 0.05861f
C197 ldo_1v2_a_0.VDD IOVDD 1.74177f
C198 a_12979_15554# a_12920_15236# 0.02087f
C199 a_15127_12560# a_15127_12390# 0.06767f
C200 ldo_1v2_a_0.first_stage_0/diff_pairs_0.vn1v2 a_4501_572# 0.01283f
C201 VBG_1V VDD_1v5 1.25152f
C202 a_13879_1652# a_13879_1344# 0.05861f
C203 a_15127_15554# a_15127_15236# 0.02087f
C204 bgr_0.opm_bgr_0.bgr_first_stage_0/bgr_bias_0.VbD bgr_0.opm_bgr_0.bgr_first_stage_0/bgr_diff_0.ref 0.39133f
C205 a_3629_1087# a_3629_915# 0.0331f
C206 a_4935_572# a_4935_400# 0.0331f
C207 ldo_1v5_y_0.second_stage_1v5_0.dmv VBG_1V 0.86545f
C208 a_15127_12220# a_15127_12050# 0.06767f
C209 ldo_1v2_a_0.VDD bgr_0.opm_bgr_0.bgr_second_stage_0.bgr_second_stage_al_0.Vbias 25.2827f
C210 a_14053_15066# a_14053_14896# 0.06767f
C211 a_14053_11732# a_14053_11562# 0.06767f
C212 bgr_0.opm_bgr_0.bgr_second_stage_0.bgr_second_stage_cs_0.Vos1 VDD_1v2 0.74392f
C213 a_14053_14896# a_14053_14726# 0.06767f
C214 ldo_1v2_a_0.first_stage_0/diff_pairs_0.dmv ldo_1v2_a_0.first_stage_0/diff_pairs_0.dmr 2.07289f
C215 a_12373_2576# VDD_1v5 0.03298f
C216 a_14053_14386# a_14053_14068# 0.02087f
C217 ldo_1v2_a_0.VDD ldo_1v5_y_0.first_stage$1_0/diff_pairs$1_0.dmv 3.74781f
C218 a_12920_14068# a_12920_13898# 0.07815f
C219 a_15127_14556# a_15127_14386# 0.06767f
C220 a_14053_14726# a_14053_14556# 0.06767f
C221 a_12979_11222# a_12979_11052# 0.06767f
C222 a_11871_2268# VDD_1v5 0.01546f
C223 ldo_1v5_y_0.second_stage_1v5_0.dmv a_12373_2576# 0.0106f
C224 a_11871_1960# VDD_1v5 0.01546f
C225 a_12373_1344# VDD_1v5 0.0185f
C226 a_4501_572# a_4501_400# 0.0331f
C227 a_15676_1771# VDD_1v5 0.09902f
C228 a_14053_13728# a_14053_13558# 0.06767f
C229 a_11871_1652# VDD_1v5 0.01546f
C230 ldo_1v2_a_0.first_stage_0/diff_pairs_0.dmr a_6428_314# 0.02793f
C231 a_4935_1087# a_4935_915# 0.0331f
C232 ldo_1v2_a_0.VDD ldo_1v2_a_0.first_stage_0/diff_pairs_0.dmv 3.74781f
C233 ldo_1v5_y_0.second_stage_1v5_0.dmv a_15676_1771# 0.12564f
C234 a_1494_3927# ldo_1v2_a_0.first_stage_0/bias_cur_0.d_t 0.2068f
C235 a_14883_2576# a_14883_2268# 0.05861f
C236 a_916_3927# ldo_1v2_a_0.first_stage_0/bias_cur_0.d_t 0.22117f
C237 a_15068_13218# a_15127_12900# 0.02087f
C238 a_11451_2268# a_11451_1960# 0.05861f
C239 a_4065_572# a_4065_400# 0.0331f
C240 a_14883_2268# a_14883_1960# 0.05861f
C241 ldo_1v5_y_0.first_stage$1_0/bias_cur$1_0.d_t VDD_1v5 0.98444f
C242 a_12979_15894# a_12979_15724# 0.06767f
C243 a_14053_12730# a_14053_12560# 0.06767f
C244 bgr_0.opm_bgr_0.bgr_second_stage_0.bgr_second_stage_al_0.Vbias bgr_0.opm_bgr_0.bgr_second_stage_0.bgr_second_stage_cs_0.Vos1 3.24942f
C245 a_11451_1960# a_11451_1652# 0.05861f
C246 ldo_1v5_y_0.second_stage_1v5_0.dmv ldo_1v5_y_0.first_stage$1_0/bias_cur$1_0.d_t 0.48027f
C247 VDD_1v2 IOVDD 9.96745f
C248 a_13377_1652# a_13377_1344# 0.05861f
C249 a_14053_15554# a_14053_15236# 0.02087f
C250 a_14883_1960# a_14883_1652# 0.05861f
C251 a_15127_12390# a_15127_12220# 0.06767f
C252 a_3629_572# a_3629_400# 0.0331f
C253 a_14053_12220# a_14053_12050# 0.06767f
C254 ldo_1v2_a_0.first_stage_0/bias_cur_0.d_t ldo_1v2_a_0.first_stage_0/diff_pairs_0.vn1v2 0.53821f
C255 ldo_1v5_y_0.second_stage_1v5_0.dmv VDD_1v5 17.3201f
C256 ldo_1v2_a_0.first_stage_0/diff_pairs_0.dmr a_1494_3927# 0.483f
C257 a_11451_2576# VDD_1v5 0.01823f
C258 a_12979_11562# a_12979_11392# 0.06767f
C259 ldo_1v2_a_0.first_stage_0/diff_pairs_0.dmr a_916_3927# 0.18552f
C260 a_5804_743# a_5804_572# 0.03359f
C261 a_14381_2576# VDD_1v5 0.01752f
C262 ldo_1v2_a_0.first_stage_0/bias_cur_0.d_t VBG_1V 0.61712f
C263 a_14381_2268# VDD_1v5 0.01555f
C264 a_15127_11222# a_15127_11052# 0.06767f
C265 a_12920_13898# a_12920_13728# 0.07815f
C266 a_15127_11052# a_15127_10882# 0.06767f
C267 a_11451_1344# VDD_1v5 0.01815f
C268 a_14381_1960# VDD_1v5 0.01555f
C269 ldo_1v5_y_0.second_stage_1v5_0.vfb VBG_1V 0.82114f
C270 ldo_1v2_a_0.VDD a_1494_3927# 0.01395f
C271 a_14381_1652# VDD_1v5 0.01555f
C272 a_5371_743# a_5371_572# 0.03359f
C273 a_14053_13558# a_14053_13388# 0.06767f
C274 a_12875_2576# a_12875_2268# 0.05861f
C275 a_14381_2576# a_14381_2268# 0.05861f
C276 ldo_1v2_a_0.VDD a_916_3927# 0.01314f
C277 ldo_1v2_a_0.first_stage_0/diff_pairs_0.dmv VDD_1v2 0.99251f
C278 ldo_1v2_a_0.first_stage_0/diff_pairs_0.dmr ldo_1v2_a_0.first_stage_0/diff_pairs_0.vn1v2 0.0647f
C279 a_15068_13388# a_15068_13218# 0.07815f
C280 a_14053_13218# a_14053_12900# 0.02087f
C281 a_12979_16234# a_12979_16064# 0.06767f
C282 a_12920_12900# a_12920_12730# 0.07815f
C283 a_4501_1087# a_4501_915# 0.0331f
C284 ldo_1v5_y_0.second_stage_1v5_0.vfb a_12373_2576# 0.01015f
C285 a_12979_16404# VBG_1V 0.0246f
C286 a_14381_2268# a_14381_1960# 0.05861f
C287 ldo_1v2_a_0.first_stage_0/diff_pairs_0.dmr VBG_1V 0.84909f
C288 a_15127_15894# a_15127_15724# 0.06767f
C289 a_14053_12560# a_14053_12390# 0.06767f
C290 a_4935_743# a_4935_572# 0.03359f
C291 a_12875_1652# a_12875_1344# 0.05861f
C292 a_6428_314# VDD_1v2 0.02761f
R0 a_12211_2096.t0 a_12211_2096.t1 30.3643
R1 a_12211_1788.t0 a_12211_1788.t1 30.3643
R2 IOVSS.n1750 IOVSS.t12 19441.1
R3 IOVSS.n1642 IOVSS.n1641 13658.4
R4 IOVSS.n2024 IOVSS.n396 11601.4
R5 IOVSS.n1718 IOVSS.n1642 11368.3
R6 IOVSS.n2229 IOVSS.n37 10559.1
R7 IOVSS.n1642 IOVSS.n1022 9513.91
R8 IOVSS.n1022 IOVSS.n1021 6655.68
R9 IOVSS.n2017 IOVSS.n1773 4413.59
R10 IOVSS.t45 IOVSS.t51 4027.34
R11 IOVSS.n1461 IOVSS.t43 2382.81
R12 IOVSS.t51 IOVSS.n1033 2380.32
R13 IOVSS.n1503 IOVSS.t43 2128.91
R14 IOVSS.n1307 IOVSS.n1022 735.808
R15 IOVSS.n1461 IOVSS.n1139 669.659
R16 IOVSS.n349 IOVSS.n348 452.921
R17 IOVSS.t54 IOVSS.n1714 396.661
R18 IOVSS.t137 IOVSS.n1582 355.882
R19 IOVSS.n1707 IOVSS.t56 293.901
R20 IOVSS.n1582 IOVSS.n1581 282.94
R21 IOVSS.n2089 IOVSS.n2088 272.022
R22 IOVSS.t12 IOVSS.n785 267.553
R23 IOVSS.t198 IOVSS.n1139 258.226
R24 IOVSS.t198 IOVSS.n1140 258.221
R25 IOVSS.n1333 IOVSS.n1310 178.058
R26 IOVSS.n2025 IOVSS.n2024 151.752
R27 IOVSS.n1714 IOVSS.t175 123.228
R28 IOVSS.n1752 IOVSS.n724 113.263
R29 IOVSS.n1641 IOVSS.n779 103.971
R30 IOVSS.n1583 IOVSS.t137 90.252
R31 IOVSS.n1641 IOVSS.n1640 85.1435
R32 IOVSS.n2229 IOVSS.n18 78.7425
R33 IOVSS.n2226 IOVSS.t71 76.8415
R34 IOVSS.n2222 IOVSS.n79 58.7676
R35 IOVSS.t161 IOVSS.n46 52.0806
R36 IOVSS.n2226 IOVSS.t162 50.1749
R37 IOVSS.t175 IOVSS.n634 47.3213
R38 IOVSS.n1769 IOVSS.n525 45.3882
R39 IOVSS.n1717 IOVSS.t54 45.1772
R40 IOVSS.n309 IOVSS.t209 42.7705
R41 IOVSS.n339 IOVSS.n338 41.3211
R42 IOVSS.n338 IOVSS.n337 41.3211
R43 IOVSS.n289 IOVSS.n288 41.3211
R44 IOVSS.t161 IOVSS.n47 40.6492
R45 IOVSS.t216 IOVSS.n308 40.2241
R46 IOVSS.t40 IOVSS.n281 40.1058
R47 IOVSS.t162 IOVSS.n79 39.72
R48 IOVSS.n1752 IOVSS.n694 39.4971
R49 IOVSS.n724 IOVSS.n723 39.4971
R50 IOVSS.n261 IOVSS.t143 38.8905
R51 IOVSS.t58 IOVSS.n1715 36.9896
R52 IOVSS.n734 IOVSS.t15 34.8505
R53 IOVSS.n1705 IOVSS.n617 33.4034
R54 IOVSS.n1703 IOVSS.n650 33.4034
R55 IOVSS.n1701 IOVSS.n619 33.4034
R56 IOVSS.n1699 IOVSS.n648 33.4034
R57 IOVSS.n1697 IOVSS.n621 33.4034
R58 IOVSS.n1695 IOVSS.n646 33.4034
R59 IOVSS.n1693 IOVSS.n623 33.4034
R60 IOVSS.n1691 IOVSS.n644 33.4034
R61 IOVSS.n1689 IOVSS.n625 33.4034
R62 IOVSS.n1687 IOVSS.n642 33.4034
R63 IOVSS.n1685 IOVSS.n627 33.4034
R64 IOVSS.n1683 IOVSS.n640 33.4034
R65 IOVSS.n1681 IOVSS.n629 33.4034
R66 IOVSS.n1679 IOVSS.n638 33.4034
R67 IOVSS.n1677 IOVSS.n631 33.4034
R68 IOVSS.n1656 IOVSS.n636 33.4034
R69 IOVSS.n1655 IOVSS.n633 33.4034
R70 IOVSS.n578 IOVSS.n563 32.2743
R71 IOVSS.n579 IOVSS.n561 32.2743
R72 IOVSS.n582 IOVSS.n559 32.2743
R73 IOVSS.n583 IOVSS.n557 32.2743
R74 IOVSS.n586 IOVSS.n555 32.2743
R75 IOVSS.n587 IOVSS.n553 32.2743
R76 IOVSS.n590 IOVSS.n551 32.2743
R77 IOVSS.n594 IOVSS.n547 32.2743
R78 IOVSS.n595 IOVSS.n545 32.2743
R79 IOVSS.n598 IOVSS.n543 32.2743
R80 IOVSS.n599 IOVSS.n541 32.2743
R81 IOVSS.n602 IOVSS.n539 32.2743
R82 IOVSS.n603 IOVSS.n537 32.2743
R83 IOVSS.n1762 IOVSS.n535 32.2743
R84 IOVSS.n2222 IOVSS.n47 31.153
R85 IOVSS.n1713 IOVSS.n571 30.6198
R86 IOVSS.n574 IOVSS.n532 30.6198
R87 IOVSS.n1333 IOVSS.n1332 30.5944
R88 IOVSS.n1021 IOVSS.n892 30.4346
R89 IOVSS.n1015 IOVSS.n1014 30.4346
R90 IOVSS.n206 IOVSS.n147 30.4346
R91 IOVSS.n2088 IOVSS.n89 30.4346
R92 IOVSS.n2219 IOVSS.n2218 30.4346
R93 IOVSS.t1 IOVSS.n2071 29.5395
R94 IOVSS.n259 IOVSS.t144 29.1894
R95 IOVSS.n1772 IOVSS.n523 27.9597
R96 IOVSS.n1760 IOVSS.n1759 27.8805
R97 IOVSS.n683 IOVSS.n609 27.8805
R98 IOVSS.n682 IOVSS.n659 27.8805
R99 IOVSS.n680 IOVSS.n611 27.8805
R100 IOVSS.n1649 IOVSS.n657 27.8805
R101 IOVSS.n1652 IOVSS.n612 27.8805
R102 IOVSS.n1647 IOVSS.n656 27.8805
R103 IOVSS.n1654 IOVSS.n613 27.8805
R104 IOVSS.n1645 IOVSS.n654 27.8805
R105 IOVSS.n1711 IOVSS.n615 27.8805
R106 IOVSS.t54 IOVSS.n549 27.8734
R107 IOVSS.n208 IOVSS.t19 27.7493
R108 IOVSS.n151 IOVSS.t4 27.7493
R109 IOVSS.n1773 IOVSS.t177 27.5365
R110 IOVSS.n325 IOVSS.t29 27.345
R111 IOVSS.n2078 IOVSS.t182 26.8541
R112 IOVSS.n384 IOVSS.t35 26.7374
R113 IOVSS.n2181 IOVSS.n2089 26.5772
R114 IOVSS.n1309 IOVSS.t0 26.1861
R115 IOVSS.n88 IOVSS.t240 25.0639
R116 IOVSS.n80 IOVSS.t103 25.0639
R117 IOVSS.n2024 IOVSS.n2023 25.0591
R118 IOVSS.n1714 IOVSS.n575 23.4724
R119 IOVSS.n785 IOVSS.n778 23.448
R120 IOVSS.t18 IOVSS.n274 23.0914
R121 IOVSS.t148 IOVSS.n119 22.3785
R122 IOVSS.n2223 IOVSS.n2222 22.3785
R123 IOVSS.n786 IOVSS.n37 22.0721
R124 IOVSS.t99 IOVSS.n1024 21.9617
R125 IOVSS.n268 IOVSS.t23 21.8761
R126 IOVSS.n788 IOVSS.n778 21.5932
R127 IOVSS.n139 IOVSS.t38 21.4834
R128 IOVSS.n793 IOVSS.n738 21.0218
R129 IOVSS.n794 IOVSS.n738 21.0218
R130 IOVSS.n1640 IOVSS.n1639 20.6763
R131 IOVSS.n1310 IOVSS.t147 20.0679
R132 IOVSS.n1771 IOVSS.n1770 19.9245
R133 IOVSS.t45 IOVSS.n1502 19.7965
R134 IOVSS.n271 IOVSS.n270 19.7199
R135 IOVSS.n272 IOVSS.n271 19.7199
R136 IOVSS.n2183 IOVSS.n2182 19.6932
R137 IOVSS.n2185 IOVSS.n2184 19.6932
R138 IOVSS.n2187 IOVSS.n2186 19.6932
R139 IOVSS.n2191 IOVSS.n2190 19.6932
R140 IOVSS.n2193 IOVSS.n2192 19.6932
R141 IOVSS.n2195 IOVSS.n2194 19.6932
R142 IOVSS.n2197 IOVSS.n2196 19.6932
R143 IOVSS.n2199 IOVSS.n2198 19.6932
R144 IOVSS.n2201 IOVSS.n2200 19.6932
R145 IOVSS.n2205 IOVSS.n2204 19.6932
R146 IOVSS.n2207 IOVSS.n2206 19.6932
R147 IOVSS.n2209 IOVSS.n2208 19.6932
R148 IOVSS.n2213 IOVSS.n2212 19.6932
R149 IOVSS.n2215 IOVSS.n2214 19.6932
R150 IOVSS.n2218 IOVSS.n2217 19.6932
R151 IOVSS.n1708 IOVSS.n1707 19.4855
R152 IOVSS.t23 IOVSS.n267 19.4455
R153 IOVSS.n1158 IOVSS.n1040 19.4081
R154 IOVSS.n2022 IOVSS.n2021 19.2195
R155 IOVSS.n324 IOVSS.n252 18.6538
R156 IOVSS.n324 IOVSS.n253 18.6538
R157 IOVSS.n287 IOVSS.n286 18.6538
R158 IOVSS.n285 IOVSS.n284 18.6538
R159 IOVSS.n280 IOVSS.n279 18.6538
R160 IOVSS.n278 IOVSS.n277 18.6538
R161 IOVSS.n273 IOVSS.n272 18.6538
R162 IOVSS.n266 IOVSS.n265 18.6538
R163 IOVSS.n264 IOVSS.n263 18.6538
R164 IOVSS.n256 IOVSS.n255 18.6538
R165 IOVSS.n257 IOVSS.n256 18.6538
R166 IOVSS.n258 IOVSS.n257 18.6538
R167 IOVSS.n258 IOVSS.n249 18.6538
R168 IOVSS.n382 IOVSS.n249 18.6538
R169 IOVSS.n386 IOVSS.n385 18.6538
R170 IOVSS.n387 IOVSS.n386 18.6538
R171 IOVSS.n388 IOVSS.n387 18.6538
R172 IOVSS.n263 IOVSS.n262 18.6538
R173 IOVSS.n265 IOVSS.n264 18.6538
R174 IOVSS.n270 IOVSS.n269 18.6538
R175 IOVSS.n277 IOVSS.n276 18.6538
R176 IOVSS.n279 IOVSS.n278 18.6538
R177 IOVSS.n284 IOVSS.n283 18.6538
R178 IOVSS.n286 IOVSS.n285 18.6538
R179 IOVSS.n1261 IOVSS.t204 18.3901
R180 IOVSS.t137 IOVSS.n1503 18.3866
R181 IOVSS.n788 IOVSS.n743 18.2729
R182 IOVSS.n790 IOVSS.n742 18.2729
R183 IOVSS.n790 IOVSS.n741 18.2729
R184 IOVSS.n791 IOVSS.n741 18.2729
R185 IOVSS.n791 IOVSS.n740 18.2729
R186 IOVSS.n792 IOVSS.n740 18.2729
R187 IOVSS.n792 IOVSS.n739 18.2729
R188 IOVSS.n793 IOVSS.n739 18.2729
R189 IOVSS.n794 IOVSS.n737 18.2729
R190 IOVSS.n795 IOVSS.n737 18.2729
R191 IOVSS.n795 IOVSS.n736 18.2729
R192 IOVSS.n796 IOVSS.n736 18.2729
R193 IOVSS.n796 IOVSS.n735 18.2729
R194 IOVSS.n797 IOVSS.n735 18.2729
R195 IOVSS.n798 IOVSS.n732 18.2729
R196 IOVSS.n799 IOVSS.n732 18.2729
R197 IOVSS.n799 IOVSS.n731 18.2729
R198 IOVSS.n800 IOVSS.n731 18.2729
R199 IOVSS.n800 IOVSS.n730 18.2729
R200 IOVSS.n801 IOVSS.n730 18.2729
R201 IOVSS.n801 IOVSS.n729 18.2729
R202 IOVSS.n802 IOVSS.n729 18.2729
R203 IOVSS.n802 IOVSS.n728 18.2729
R204 IOVSS.n803 IOVSS.n728 18.2729
R205 IOVSS.n803 IOVSS.n727 18.2729
R206 IOVSS.n275 IOVSS.t18 18.2302
R207 IOVSS.n1783 IOVSS.n477 18.1223
R208 IOVSS.n575 IOVSS.n563 17.6044
R209 IOVSS.n578 IOVSS.n561 17.6044
R210 IOVSS.n579 IOVSS.n559 17.6044
R211 IOVSS.n582 IOVSS.n557 17.6044
R212 IOVSS.n583 IOVSS.n555 17.6044
R213 IOVSS.n586 IOVSS.n553 17.6044
R214 IOVSS.n587 IOVSS.n551 17.6044
R215 IOVSS.n590 IOVSS.n549 17.6044
R216 IOVSS.n591 IOVSS.n547 17.6044
R217 IOVSS.n594 IOVSS.n545 17.6044
R218 IOVSS.n595 IOVSS.n543 17.6044
R219 IOVSS.n598 IOVSS.n541 17.6044
R220 IOVSS.n599 IOVSS.n539 17.6044
R221 IOVSS.n602 IOVSS.n537 17.6044
R222 IOVSS.n603 IOVSS.n535 17.6044
R223 IOVSS.n1762 IOVSS.n524 17.6044
R224 IOVSS.n1771 IOVSS.n524 17.6044
R225 IOVSS.n197 IOVSS.n128 17.3424
R226 IOVSS.t236 IOVSS.n481 17.1137
R227 IOVSS.n1885 IOVSS.t82 17.1137
R228 IOVSS.t20 IOVSS.n1307 17.1116
R229 IOVSS.t162 IOVSS.n88 17.0078
R230 IOVSS.n379 IOVSS.n254 17.0005
R231 IOVSS.n379 IOVSS.n289 17.0005
R232 IOVSS.n379 IOVSS.n378 17.0005
R233 IOVSS.n377 IOVSS.n376 17.0005
R234 IOVSS.n376 IOVSS.n375 17.0005
R235 IOVSS.n374 IOVSS.n373 17.0005
R236 IOVSS.n373 IOVSS.n372 17.0005
R237 IOVSS.n371 IOVSS.n370 17.0005
R238 IOVSS.n370 IOVSS.n369 17.0005
R239 IOVSS.n368 IOVSS.n367 17.0005
R240 IOVSS.n367 IOVSS.n366 17.0005
R241 IOVSS.n365 IOVSS.n364 17.0005
R242 IOVSS.n364 IOVSS.n363 17.0005
R243 IOVSS.n362 IOVSS.n361 17.0005
R244 IOVSS.n361 IOVSS.n360 17.0005
R245 IOVSS.n359 IOVSS.n358 17.0005
R246 IOVSS.n358 IOVSS.n357 17.0005
R247 IOVSS.n356 IOVSS.n355 17.0005
R248 IOVSS.n355 IOVSS.n354 17.0005
R249 IOVSS.n384 IOVSS.n233 17.0005
R250 IOVSS.n383 IOVSS.n233 17.0005
R251 IOVSS.n261 IOVSS.n233 17.0005
R252 IOVSS.n267 IOVSS.n233 17.0005
R253 IOVSS.n268 IOVSS.n233 17.0005
R254 IOVSS.n274 IOVSS.n233 17.0005
R255 IOVSS.n275 IOVSS.n233 17.0005
R256 IOVSS.n281 IOVSS.n233 17.0005
R257 IOVSS.n282 IOVSS.n233 17.0005
R258 IOVSS.n288 IOVSS.n233 17.0005
R259 IOVSS.n326 IOVSS.n289 17.0005
R260 IOVSS.n326 IOVSS.n325 17.0005
R261 IOVSS.n337 IOVSS.n336 17.0005
R262 IOVSS.t69 IOVSS.n871 17.0005
R263 IOVSS.n875 IOVSS.t68 17.0005
R264 IOVSS.t80 IOVSS.n877 17.0005
R265 IOVSS.n881 IOVSS.t79 17.0005
R266 IOVSS.t97 IOVSS.n666 17.0005
R267 IOVSS.n670 IOVSS.t96 17.0005
R268 IOVSS.t115 IOVSS.n672 17.0005
R269 IOVSS.n676 IOVSS.t114 17.0005
R270 IOVSS.n1668 IOVSS.t55 17.0005
R271 IOVSS.t57 IOVSS.n1664 17.0005
R272 IOVSS.n1673 IOVSS.t59 17.0005
R273 IOVSS.t61 IOVSS.n1669 17.0005
R274 IOVSS.n1764 IOVSS.n605 17.0005
R275 IOVSS.n1764 IOVSS.n1762 17.0005
R276 IOVSS.n1764 IOVSS.n604 17.0005
R277 IOVSS.n1764 IOVSS.n603 17.0005
R278 IOVSS.n1764 IOVSS.n601 17.0005
R279 IOVSS.n1764 IOVSS.n602 17.0005
R280 IOVSS.n1764 IOVSS.n600 17.0005
R281 IOVSS.n1764 IOVSS.n599 17.0005
R282 IOVSS.n1764 IOVSS.n597 17.0005
R283 IOVSS.n1764 IOVSS.n598 17.0005
R284 IOVSS.n1764 IOVSS.n596 17.0005
R285 IOVSS.n1764 IOVSS.n595 17.0005
R286 IOVSS.n1764 IOVSS.n593 17.0005
R287 IOVSS.n1764 IOVSS.n594 17.0005
R288 IOVSS.n1764 IOVSS.n592 17.0005
R289 IOVSS.n1764 IOVSS.n591 17.0005
R290 IOVSS.n1764 IOVSS.n589 17.0005
R291 IOVSS.n1764 IOVSS.n590 17.0005
R292 IOVSS.n1764 IOVSS.n588 17.0005
R293 IOVSS.n1764 IOVSS.n587 17.0005
R294 IOVSS.n1764 IOVSS.n585 17.0005
R295 IOVSS.n1764 IOVSS.n586 17.0005
R296 IOVSS.n1764 IOVSS.n584 17.0005
R297 IOVSS.n1764 IOVSS.n583 17.0005
R298 IOVSS.n1764 IOVSS.n581 17.0005
R299 IOVSS.n1764 IOVSS.n582 17.0005
R300 IOVSS.n1764 IOVSS.n580 17.0005
R301 IOVSS.n1764 IOVSS.n579 17.0005
R302 IOVSS.n1764 IOVSS.n577 17.0005
R303 IOVSS.n1764 IOVSS.n578 17.0005
R304 IOVSS.n1764 IOVSS.n576 17.0005
R305 IOVSS.n1764 IOVSS.n575 17.0005
R306 IOVSS.n1761 IOVSS.n575 17.0005
R307 IOVSS.n1761 IOVSS.n578 17.0005
R308 IOVSS.n1761 IOVSS.n579 17.0005
R309 IOVSS.n1761 IOVSS.n582 17.0005
R310 IOVSS.n1761 IOVSS.n583 17.0005
R311 IOVSS.n1761 IOVSS.n586 17.0005
R312 IOVSS.n1761 IOVSS.n587 17.0005
R313 IOVSS.n1761 IOVSS.n590 17.0005
R314 IOVSS.n1761 IOVSS.n591 17.0005
R315 IOVSS.n1761 IOVSS.n594 17.0005
R316 IOVSS.n1761 IOVSS.n595 17.0005
R317 IOVSS.n1761 IOVSS.n598 17.0005
R318 IOVSS.n1761 IOVSS.n599 17.0005
R319 IOVSS.n1761 IOVSS.n602 17.0005
R320 IOVSS.n1761 IOVSS.n603 17.0005
R321 IOVSS.n1762 IOVSS.n1761 17.0005
R322 IOVSS.n1767 IOVSS.n564 17.0005
R323 IOVSS.n1767 IOVSS.n563 17.0005
R324 IOVSS.n1767 IOVSS.n562 17.0005
R325 IOVSS.n1767 IOVSS.n561 17.0005
R326 IOVSS.n1767 IOVSS.n560 17.0005
R327 IOVSS.n1767 IOVSS.n559 17.0005
R328 IOVSS.n1767 IOVSS.n558 17.0005
R329 IOVSS.n1767 IOVSS.n557 17.0005
R330 IOVSS.n1767 IOVSS.n556 17.0005
R331 IOVSS.n1767 IOVSS.n555 17.0005
R332 IOVSS.n1767 IOVSS.n554 17.0005
R333 IOVSS.n1767 IOVSS.n553 17.0005
R334 IOVSS.n1767 IOVSS.n552 17.0005
R335 IOVSS.n1767 IOVSS.n551 17.0005
R336 IOVSS.n1767 IOVSS.n550 17.0005
R337 IOVSS.n1767 IOVSS.n549 17.0005
R338 IOVSS.n1767 IOVSS.n548 17.0005
R339 IOVSS.n1767 IOVSS.n547 17.0005
R340 IOVSS.n1767 IOVSS.n546 17.0005
R341 IOVSS.n1767 IOVSS.n545 17.0005
R342 IOVSS.n1767 IOVSS.n544 17.0005
R343 IOVSS.n1767 IOVSS.n543 17.0005
R344 IOVSS.n1767 IOVSS.n542 17.0005
R345 IOVSS.n1767 IOVSS.n541 17.0005
R346 IOVSS.n1767 IOVSS.n540 17.0005
R347 IOVSS.n1767 IOVSS.n539 17.0005
R348 IOVSS.n1767 IOVSS.n538 17.0005
R349 IOVSS.n1767 IOVSS.n537 17.0005
R350 IOVSS.n1767 IOVSS.n536 17.0005
R351 IOVSS.n1767 IOVSS.n535 17.0005
R352 IOVSS.n1767 IOVSS.n534 17.0005
R353 IOVSS.n1767 IOVSS.n524 17.0005
R354 IOVSS.n524 IOVSS.n523 17.0005
R355 IOVSS.n535 IOVSS.n523 17.0005
R356 IOVSS.n537 IOVSS.n523 17.0005
R357 IOVSS.n539 IOVSS.n523 17.0005
R358 IOVSS.n541 IOVSS.n523 17.0005
R359 IOVSS.n543 IOVSS.n523 17.0005
R360 IOVSS.n545 IOVSS.n523 17.0005
R361 IOVSS.n547 IOVSS.n523 17.0005
R362 IOVSS.n549 IOVSS.n523 17.0005
R363 IOVSS.n551 IOVSS.n523 17.0005
R364 IOVSS.n553 IOVSS.n523 17.0005
R365 IOVSS.n555 IOVSS.n523 17.0005
R366 IOVSS.n557 IOVSS.n523 17.0005
R367 IOVSS.n559 IOVSS.n523 17.0005
R368 IOVSS.n561 IOVSS.n523 17.0005
R369 IOVSS.n563 IOVSS.n523 17.0005
R370 IOVSS.n1764 IOVSS.n573 17.0005
R371 IOVSS.n1764 IOVSS.n574 17.0005
R372 IOVSS.n1764 IOVSS.n571 17.0005
R373 IOVSS.n1761 IOVSS.n635 17.0005
R374 IOVSS.n1761 IOVSS.n632 17.0005
R375 IOVSS.n1761 IOVSS.n637 17.0005
R376 IOVSS.n1761 IOVSS.n630 17.0005
R377 IOVSS.n1761 IOVSS.n639 17.0005
R378 IOVSS.n1761 IOVSS.n628 17.0005
R379 IOVSS.n1761 IOVSS.n641 17.0005
R380 IOVSS.n1761 IOVSS.n626 17.0005
R381 IOVSS.n1761 IOVSS.n643 17.0005
R382 IOVSS.n1761 IOVSS.n624 17.0005
R383 IOVSS.n1761 IOVSS.n645 17.0005
R384 IOVSS.n1761 IOVSS.n622 17.0005
R385 IOVSS.n1761 IOVSS.n647 17.0005
R386 IOVSS.n1761 IOVSS.n620 17.0005
R387 IOVSS.n1761 IOVSS.n649 17.0005
R388 IOVSS.n1761 IOVSS.n618 17.0005
R389 IOVSS.n1761 IOVSS.n571 17.0005
R390 IOVSS.n1761 IOVSS.n574 17.0005
R391 IOVSS.n1712 IOVSS.n1709 17.0005
R392 IOVSS.n1712 IOVSS.n1708 17.0005
R393 IOVSS.n1712 IOVSS.n1706 17.0005
R394 IOVSS.n1712 IOVSS.n1705 17.0005
R395 IOVSS.n1712 IOVSS.n1704 17.0005
R396 IOVSS.n1712 IOVSS.n1703 17.0005
R397 IOVSS.n1712 IOVSS.n1702 17.0005
R398 IOVSS.n1712 IOVSS.n1701 17.0005
R399 IOVSS.n1712 IOVSS.n1700 17.0005
R400 IOVSS.n1712 IOVSS.n1699 17.0005
R401 IOVSS.n1712 IOVSS.n1698 17.0005
R402 IOVSS.n1712 IOVSS.n1697 17.0005
R403 IOVSS.n1712 IOVSS.n1696 17.0005
R404 IOVSS.n1712 IOVSS.n1695 17.0005
R405 IOVSS.n1712 IOVSS.n1694 17.0005
R406 IOVSS.n1712 IOVSS.n1693 17.0005
R407 IOVSS.n1712 IOVSS.n1692 17.0005
R408 IOVSS.n1712 IOVSS.n1691 17.0005
R409 IOVSS.n1712 IOVSS.n1690 17.0005
R410 IOVSS.n1712 IOVSS.n1689 17.0005
R411 IOVSS.n1712 IOVSS.n1688 17.0005
R412 IOVSS.n1712 IOVSS.n1687 17.0005
R413 IOVSS.n1712 IOVSS.n1686 17.0005
R414 IOVSS.n1712 IOVSS.n1685 17.0005
R415 IOVSS.n1712 IOVSS.n1684 17.0005
R416 IOVSS.n1712 IOVSS.n1683 17.0005
R417 IOVSS.n1712 IOVSS.n1682 17.0005
R418 IOVSS.n1712 IOVSS.n1681 17.0005
R419 IOVSS.n1712 IOVSS.n1680 17.0005
R420 IOVSS.n1712 IOVSS.n1679 17.0005
R421 IOVSS.n1712 IOVSS.n1678 17.0005
R422 IOVSS.n1712 IOVSS.n1677 17.0005
R423 IOVSS.n1712 IOVSS.n1676 17.0005
R424 IOVSS.n1712 IOVSS.n1656 17.0005
R425 IOVSS.n1712 IOVSS.n1655 17.0005
R426 IOVSS.n1713 IOVSS.n1712 17.0005
R427 IOVSS.n1767 IOVSS.n532 17.0005
R428 IOVSS.n1767 IOVSS.n565 17.0005
R429 IOVSS.n1767 IOVSS.n566 17.0005
R430 IOVSS.n566 IOVSS.n523 17.0005
R431 IOVSS.n532 IOVSS.n523 17.0005
R432 IOVSS.n1713 IOVSS.n523 17.0005
R433 IOVSS.n1655 IOVSS.n523 17.0005
R434 IOVSS.n1656 IOVSS.n523 17.0005
R435 IOVSS.n1677 IOVSS.n523 17.0005
R436 IOVSS.n1679 IOVSS.n523 17.0005
R437 IOVSS.n1681 IOVSS.n523 17.0005
R438 IOVSS.n1683 IOVSS.n523 17.0005
R439 IOVSS.n1685 IOVSS.n523 17.0005
R440 IOVSS.n1687 IOVSS.n523 17.0005
R441 IOVSS.n1689 IOVSS.n523 17.0005
R442 IOVSS.n1691 IOVSS.n523 17.0005
R443 IOVSS.n1693 IOVSS.n523 17.0005
R444 IOVSS.n1695 IOVSS.n523 17.0005
R445 IOVSS.n1697 IOVSS.n523 17.0005
R446 IOVSS.n1699 IOVSS.n523 17.0005
R447 IOVSS.n1701 IOVSS.n523 17.0005
R448 IOVSS.n1703 IOVSS.n523 17.0005
R449 IOVSS.n1705 IOVSS.n523 17.0005
R450 IOVSS.n1708 IOVSS.n523 17.0005
R451 IOVSS.n1900 IOVSS.n229 17.0005
R452 IOVSS.n1893 IOVSS.n229 17.0005
R453 IOVSS.n1897 IOVSS.n229 17.0005
R454 IOVSS.n1896 IOVSS.n229 17.0005
R455 IOVSS.n1907 IOVSS.n229 17.0005
R456 IOVSS.n1899 IOVSS.n229 17.0005
R457 IOVSS.n1910 IOVSS.n229 17.0005
R458 IOVSS.n1909 IOVSS.n229 17.0005
R459 IOVSS.n1913 IOVSS.n229 17.0005
R460 IOVSS.n1912 IOVSS.n229 17.0005
R461 IOVSS.n1916 IOVSS.n229 17.0005
R462 IOVSS.n1915 IOVSS.n229 17.0005
R463 IOVSS.n1919 IOVSS.n229 17.0005
R464 IOVSS.n1918 IOVSS.n229 17.0005
R465 IOVSS.n1922 IOVSS.n229 17.0005
R466 IOVSS.n1921 IOVSS.n229 17.0005
R467 IOVSS.n1925 IOVSS.n229 17.0005
R468 IOVSS.n1924 IOVSS.n229 17.0005
R469 IOVSS.n2012 IOVSS.n229 17.0005
R470 IOVSS.n2019 IOVSS.n482 17.0005
R471 IOVSS.n2019 IOVSS.n481 17.0005
R472 IOVSS.n2019 IOVSS.n477 17.0005
R473 IOVSS.n2019 IOVSS.n475 17.0005
R474 IOVSS.n2019 IOVSS.n473 17.0005
R475 IOVSS.n2019 IOVSS.n471 17.0005
R476 IOVSS.n2019 IOVSS.n469 17.0005
R477 IOVSS.n2019 IOVSS.n467 17.0005
R478 IOVSS.n2019 IOVSS.n465 17.0005
R479 IOVSS.n2019 IOVSS.n463 17.0005
R480 IOVSS.n2019 IOVSS.n461 17.0005
R481 IOVSS.n2019 IOVSS.n459 17.0005
R482 IOVSS.n2019 IOVSS.n457 17.0005
R483 IOVSS.n2019 IOVSS.n455 17.0005
R484 IOVSS.n2019 IOVSS.n453 17.0005
R485 IOVSS.n2019 IOVSS.n451 17.0005
R486 IOVSS.n2019 IOVSS.n449 17.0005
R487 IOVSS.n2019 IOVSS.n447 17.0005
R488 IOVSS.n2019 IOVSS.n445 17.0005
R489 IOVSS.n2019 IOVSS.n443 17.0005
R490 IOVSS.n1963 IOVSS.n1962 17.0005
R491 IOVSS.n1964 IOVSS.n1963 17.0005
R492 IOVSS.n1863 IOVSS.n1862 17.0005
R493 IOVSS.n1862 IOVSS.n1861 17.0005
R494 IOVSS.n2014 IOVSS.n1880 17.0005
R495 IOVSS.n2015 IOVSS.n2014 17.0005
R496 IOVSS.n2014 IOVSS.n1807 17.0005
R497 IOVSS.n2014 IOVSS.n1882 17.0005
R498 IOVSS.n2014 IOVSS.n1804 17.0005
R499 IOVSS.n2014 IOVSS.n1884 17.0005
R500 IOVSS.n2014 IOVSS.n1801 17.0005
R501 IOVSS.n2014 IOVSS.n1885 17.0005
R502 IOVSS.n2014 IOVSS.n1798 17.0005
R503 IOVSS.n2014 IOVSS.n1887 17.0005
R504 IOVSS.n2014 IOVSS.n1795 17.0005
R505 IOVSS.n2014 IOVSS.n1889 17.0005
R506 IOVSS.n2014 IOVSS.n1792 17.0005
R507 IOVSS.n2014 IOVSS.n482 17.0005
R508 IOVSS.n2014 IOVSS.n481 17.0005
R509 IOVSS.n2014 IOVSS.n1890 17.0005
R510 IOVSS.n2014 IOVSS.n1786 17.0005
R511 IOVSS.n2014 IOVSS.n1892 17.0005
R512 IOVSS.n2014 IOVSS.n1784 17.0005
R513 IOVSS.n2014 IOVSS.n1895 17.0005
R514 IOVSS.n2014 IOVSS.n477 17.0005
R515 IOVSS.n2014 IOVSS.n1782 17.0005
R516 IOVSS.n2014 IOVSS.n475 17.0005
R517 IOVSS.n2014 IOVSS.n1898 17.0005
R518 IOVSS.n2014 IOVSS.n473 17.0005
R519 IOVSS.n2014 IOVSS.n1781 17.0005
R520 IOVSS.n2014 IOVSS.n471 17.0005
R521 IOVSS.n2014 IOVSS.n1908 17.0005
R522 IOVSS.n2014 IOVSS.n469 17.0005
R523 IOVSS.n2014 IOVSS.n1780 17.0005
R524 IOVSS.n2014 IOVSS.n467 17.0005
R525 IOVSS.n2014 IOVSS.n1911 17.0005
R526 IOVSS.n2014 IOVSS.n465 17.0005
R527 IOVSS.n2014 IOVSS.n1779 17.0005
R528 IOVSS.n2014 IOVSS.n463 17.0005
R529 IOVSS.n2014 IOVSS.n1914 17.0005
R530 IOVSS.n2014 IOVSS.n461 17.0005
R531 IOVSS.n2014 IOVSS.n1778 17.0005
R532 IOVSS.n2014 IOVSS.n459 17.0005
R533 IOVSS.n2014 IOVSS.n1917 17.0005
R534 IOVSS.n2014 IOVSS.n457 17.0005
R535 IOVSS.n2014 IOVSS.n1777 17.0005
R536 IOVSS.n2014 IOVSS.n455 17.0005
R537 IOVSS.n2014 IOVSS.n1920 17.0005
R538 IOVSS.n2014 IOVSS.n453 17.0005
R539 IOVSS.n2014 IOVSS.n1776 17.0005
R540 IOVSS.n2014 IOVSS.n451 17.0005
R541 IOVSS.n2014 IOVSS.n1923 17.0005
R542 IOVSS.n2014 IOVSS.n449 17.0005
R543 IOVSS.n2014 IOVSS.n1775 17.0005
R544 IOVSS.n2014 IOVSS.n447 17.0005
R545 IOVSS.n2014 IOVSS.n1926 17.0005
R546 IOVSS.n2014 IOVSS.n445 17.0005
R547 IOVSS.n2014 IOVSS.n1774 17.0005
R548 IOVSS.n2014 IOVSS.n443 17.0005
R549 IOVSS.n2014 IOVSS.n2013 17.0005
R550 IOVSS.n861 IOVSS.n852 17.0005
R551 IOVSS.n864 IOVSS.n852 17.0005
R552 IOVSS.n1764 IOVSS.n569 17.0005
R553 IOVSS.n1765 IOVSS.n1764 17.0005
R554 IOVSS.n1764 IOVSS.n567 17.0005
R555 IOVSS.n1764 IOVSS.n1763 17.0005
R556 IOVSS.n1767 IOVSS.n531 17.0005
R557 IOVSS.n1767 IOVSS.n1766 17.0005
R558 IOVSS.n568 IOVSS.n530 17.0005
R559 IOVSS.n868 IOVSS.n530 17.0005
R560 IOVSS.n863 IOVSS.n862 17.0005
R561 IOVSS.n862 IOVSS.n851 17.0005
R562 IOVSS.n1376 IOVSS.t90 17.0005
R563 IOVSS.t89 IOVSS.n1356 17.0005
R564 IOVSS.t101 IOVSS.n1409 17.0005
R565 IOVSS.n1429 IOVSS.t100 17.0005
R566 IOVSS.n1536 IOVSS.n1099 17.0005
R567 IOVSS.n1535 IOVSS.n1099 17.0005
R568 IOVSS.n1533 IOVSS.n1099 17.0005
R569 IOVSS.n1531 IOVSS.n1099 17.0005
R570 IOVSS.n1521 IOVSS.n1099 17.0005
R571 IOVSS.n1527 IOVSS.n1099 17.0005
R572 IOVSS.n1522 IOVSS.n1099 17.0005
R573 IOVSS.n1523 IOVSS.n1099 17.0005
R574 IOVSS.n1594 IOVSS.n1099 17.0005
R575 IOVSS.n1592 IOVSS.n1099 17.0005
R576 IOVSS.n1590 IOVSS.n1099 17.0005
R577 IOVSS.n1593 IOVSS.n1099 17.0005
R578 IOVSS.n1614 IOVSS.n1141 17.0005
R579 IOVSS.n1525 IOVSS.n1524 17.0005
R580 IOVSS.n1526 IOVSS.n1525 17.0005
R581 IOVSS.n1529 IOVSS.n1528 17.0005
R582 IOVSS.n1530 IOVSS.n1529 17.0005
R583 IOVSS.n1532 IOVSS.n1506 17.0005
R584 IOVSS.n1534 IOVSS.n1506 17.0005
R585 IOVSS.n1579 IOVSS.n1537 17.0005
R586 IOVSS.n1579 IOVSS.n1520 17.0005
R587 IOVSS.n1332 IOVSS.n1033 17.0005
R588 IOVSS.n1502 IOVSS.n1501 17.0005
R589 IOVSS.n1622 IOVSS.n1044 17.0005
R590 IOVSS.n1622 IOVSS.n1046 17.0005
R591 IOVSS.n1622 IOVSS.n1042 17.0005
R592 IOVSS.n1622 IOVSS.n1077 17.0005
R593 IOVSS.n1622 IOVSS.n1047 17.0005
R594 IOVSS.n1622 IOVSS.n1041 17.0005
R595 IOVSS.n1622 IOVSS.n1048 17.0005
R596 IOVSS.n1622 IOVSS.n1040 17.0005
R597 IOVSS.n1622 IOVSS.n1049 17.0005
R598 IOVSS.n1622 IOVSS.n1039 17.0005
R599 IOVSS.n1622 IOVSS.n1050 17.0005
R600 IOVSS.n1622 IOVSS.n1038 17.0005
R601 IOVSS.n1622 IOVSS.n1051 17.0005
R602 IOVSS.n1622 IOVSS.n1037 17.0005
R603 IOVSS.n1626 IOVSS.n1044 17.0005
R604 IOVSS.n1626 IOVSS.n1046 17.0005
R605 IOVSS.n1626 IOVSS.n1042 17.0005
R606 IOVSS.n1627 IOVSS.n1626 17.0005
R607 IOVSS.n1626 IOVSS.n1047 17.0005
R608 IOVSS.n1626 IOVSS.n1041 17.0005
R609 IOVSS.n1626 IOVSS.n1048 17.0005
R610 IOVSS.n1626 IOVSS.n1040 17.0005
R611 IOVSS.n1626 IOVSS.n1049 17.0005
R612 IOVSS.n1626 IOVSS.n1039 17.0005
R613 IOVSS.n1626 IOVSS.n1050 17.0005
R614 IOVSS.n1626 IOVSS.n1038 17.0005
R615 IOVSS.n1626 IOVSS.n1051 17.0005
R616 IOVSS.n1626 IOVSS.n1037 17.0005
R617 IOVSS.n1616 IOVSS.n1030 17.0005
R618 IOVSS.n1193 IOVSS.n1030 17.0005
R619 IOVSS.n1192 IOVSS.n1030 17.0005
R620 IOVSS.n1190 IOVSS.n1030 17.0005
R621 IOVSS.n1188 IOVSS.n1033 17.0005
R622 IOVSS.n1186 IOVSS.n1033 17.0005
R623 IOVSS.n1183 IOVSS.n1033 17.0005
R624 IOVSS.n1181 IOVSS.n1033 17.0005
R625 IOVSS.n1179 IOVSS.n1033 17.0005
R626 IOVSS.n1177 IOVSS.n1033 17.0005
R627 IOVSS.n1174 IOVSS.n1033 17.0005
R628 IOVSS.n1100 IOVSS.n1033 17.0005
R629 IOVSS.n1122 IOVSS.n1033 17.0005
R630 IOVSS.n1171 IOVSS.n1033 17.0005
R631 IOVSS.n1169 IOVSS.n1033 17.0005
R632 IOVSS.n1167 IOVSS.n1033 17.0005
R633 IOVSS.n1164 IOVSS.n1033 17.0005
R634 IOVSS.n1162 IOVSS.n1033 17.0005
R635 IOVSS.n1160 IOVSS.n1033 17.0005
R636 IOVSS.n1158 IOVSS.n1033 17.0005
R637 IOVSS.n1156 IOVSS.n1033 17.0005
R638 IOVSS.n1154 IOVSS.n1033 17.0005
R639 IOVSS.n1151 IOVSS.n1033 17.0005
R640 IOVSS.n1149 IOVSS.n1033 17.0005
R641 IOVSS.n1147 IOVSS.n1033 17.0005
R642 IOVSS.n1115 IOVSS.n1033 17.0005
R643 IOVSS.n1144 IOVSS.n1033 17.0005
R644 IOVSS.n1135 IOVSS.n1033 17.0005
R645 IOVSS.n1610 IOVSS.n1099 17.0005
R646 IOVSS.n1198 IOVSS.n1099 17.0005
R647 IOVSS.n1617 IOVSS.n1099 17.0005
R648 IOVSS.n1577 IOVSS.n1099 17.0005
R649 IOVSS.n1575 IOVSS.n1099 17.0005
R650 IOVSS.n1128 IOVSS.n1099 17.0005
R651 IOVSS.n1574 IOVSS.n1099 17.0005
R652 IOVSS.n1102 IOVSS.n1099 17.0005
R653 IOVSS.n1572 IOVSS.n1099 17.0005
R654 IOVSS.n1127 IOVSS.n1099 17.0005
R655 IOVSS.n1571 IOVSS.n1099 17.0005
R656 IOVSS.n1103 IOVSS.n1099 17.0005
R657 IOVSS.n1569 IOVSS.n1099 17.0005
R658 IOVSS.n1126 IOVSS.n1099 17.0005
R659 IOVSS.n1568 IOVSS.n1099 17.0005
R660 IOVSS.n1104 IOVSS.n1099 17.0005
R661 IOVSS.n1566 IOVSS.n1099 17.0005
R662 IOVSS.n1125 IOVSS.n1099 17.0005
R663 IOVSS.n1565 IOVSS.n1099 17.0005
R664 IOVSS.n1105 IOVSS.n1099 17.0005
R665 IOVSS.n1563 IOVSS.n1099 17.0005
R666 IOVSS.n1124 IOVSS.n1099 17.0005
R667 IOVSS.n1562 IOVSS.n1099 17.0005
R668 IOVSS.n1619 IOVSS.n1099 17.0005
R669 IOVSS.n1560 IOVSS.n1099 17.0005
R670 IOVSS.n1123 IOVSS.n1099 17.0005
R671 IOVSS.n1559 IOVSS.n1099 17.0005
R672 IOVSS.n1106 IOVSS.n1099 17.0005
R673 IOVSS.n1557 IOVSS.n1099 17.0005
R674 IOVSS.n1121 IOVSS.n1099 17.0005
R675 IOVSS.n1556 IOVSS.n1099 17.0005
R676 IOVSS.n1107 IOVSS.n1099 17.0005
R677 IOVSS.n1554 IOVSS.n1099 17.0005
R678 IOVSS.n1120 IOVSS.n1099 17.0005
R679 IOVSS.n1553 IOVSS.n1099 17.0005
R680 IOVSS.n1108 IOVSS.n1099 17.0005
R681 IOVSS.n1551 IOVSS.n1099 17.0005
R682 IOVSS.n1119 IOVSS.n1099 17.0005
R683 IOVSS.n1550 IOVSS.n1099 17.0005
R684 IOVSS.n1109 IOVSS.n1099 17.0005
R685 IOVSS.n1548 IOVSS.n1099 17.0005
R686 IOVSS.n1118 IOVSS.n1099 17.0005
R687 IOVSS.n1547 IOVSS.n1099 17.0005
R688 IOVSS.n1110 IOVSS.n1099 17.0005
R689 IOVSS.n1545 IOVSS.n1099 17.0005
R690 IOVSS.n1117 IOVSS.n1099 17.0005
R691 IOVSS.n1544 IOVSS.n1099 17.0005
R692 IOVSS.n1111 IOVSS.n1099 17.0005
R693 IOVSS.n1542 IOVSS.n1099 17.0005
R694 IOVSS.n1116 IOVSS.n1099 17.0005
R695 IOVSS.n1541 IOVSS.n1099 17.0005
R696 IOVSS.n1099 IOVSS.n1054 17.0005
R697 IOVSS.n1539 IOVSS.n1099 17.0005
R698 IOVSS.n1114 IOVSS.n1099 17.0005
R699 IOVSS.n1538 IOVSS.n1099 17.0005
R700 IOVSS.n1112 IOVSS.n1099 17.0005
R701 IOVSS.n1606 IOVSS.n1099 17.0005
R702 IOVSS.n1205 IOVSS.n1099 17.0005
R703 IOVSS.n1203 IOVSS.n1099 17.0005
R704 IOVSS.n1618 IOVSS.n1112 17.0005
R705 IOVSS.n1618 IOVSS.n1114 17.0005
R706 IOVSS.n1618 IOVSS.n1054 17.0005
R707 IOVSS.n1618 IOVSS.n1116 17.0005
R708 IOVSS.n1618 IOVSS.n1111 17.0005
R709 IOVSS.n1618 IOVSS.n1117 17.0005
R710 IOVSS.n1618 IOVSS.n1110 17.0005
R711 IOVSS.n1618 IOVSS.n1118 17.0005
R712 IOVSS.n1618 IOVSS.n1109 17.0005
R713 IOVSS.n1618 IOVSS.n1119 17.0005
R714 IOVSS.n1618 IOVSS.n1108 17.0005
R715 IOVSS.n1618 IOVSS.n1120 17.0005
R716 IOVSS.n1618 IOVSS.n1107 17.0005
R717 IOVSS.n1618 IOVSS.n1121 17.0005
R718 IOVSS.n1618 IOVSS.n1106 17.0005
R719 IOVSS.n1618 IOVSS.n1123 17.0005
R720 IOVSS.n1619 IOVSS.n1618 17.0005
R721 IOVSS.n1618 IOVSS.n1124 17.0005
R722 IOVSS.n1618 IOVSS.n1105 17.0005
R723 IOVSS.n1618 IOVSS.n1125 17.0005
R724 IOVSS.n1618 IOVSS.n1104 17.0005
R725 IOVSS.n1618 IOVSS.n1126 17.0005
R726 IOVSS.n1618 IOVSS.n1103 17.0005
R727 IOVSS.n1618 IOVSS.n1127 17.0005
R728 IOVSS.n1618 IOVSS.n1102 17.0005
R729 IOVSS.n1618 IOVSS.n1128 17.0005
R730 IOVSS.n1618 IOVSS.n1617 17.0005
R731 IOVSS.n1201 IOVSS.n1099 17.0005
R732 IOVSS.n1614 IOVSS.n1130 17.0005
R733 IOVSS.n1614 IOVSS.n1191 17.0005
R734 IOVSS.n1614 IOVSS.n1189 17.0005
R735 IOVSS.n1614 IOVSS.n1187 17.0005
R736 IOVSS.n1614 IOVSS.n1184 17.0005
R737 IOVSS.n1614 IOVSS.n1182 17.0005
R738 IOVSS.n1614 IOVSS.n1180 17.0005
R739 IOVSS.n1614 IOVSS.n1178 17.0005
R740 IOVSS.n1614 IOVSS.n1175 17.0005
R741 IOVSS.n1614 IOVSS.n1173 17.0005
R742 IOVSS.n1614 IOVSS.n1082 17.0005
R743 IOVSS.n1614 IOVSS.n1172 17.0005
R744 IOVSS.n1614 IOVSS.n1170 17.0005
R745 IOVSS.n1614 IOVSS.n1168 17.0005
R746 IOVSS.n1614 IOVSS.n1165 17.0005
R747 IOVSS.n1614 IOVSS.n1163 17.0005
R748 IOVSS.n1614 IOVSS.n1161 17.0005
R749 IOVSS.n1614 IOVSS.n1159 17.0005
R750 IOVSS.n1614 IOVSS.n1157 17.0005
R751 IOVSS.n1614 IOVSS.n1155 17.0005
R752 IOVSS.n1614 IOVSS.n1152 17.0005
R753 IOVSS.n1614 IOVSS.n1150 17.0005
R754 IOVSS.n1614 IOVSS.n1148 17.0005
R755 IOVSS.n1614 IOVSS.n1060 17.0005
R756 IOVSS.n1614 IOVSS.n1145 17.0005
R757 IOVSS.n1614 IOVSS.n1136 17.0005
R758 IOVSS.n1579 IOVSS.n1540 17.0005
R759 IOVSS.n1579 IOVSS.n1136 17.0005
R760 IOVSS.n1579 IOVSS.n1519 17.0005
R761 IOVSS.n1579 IOVSS.n1145 17.0005
R762 IOVSS.n1579 IOVSS.n1543 17.0005
R763 IOVSS.n1579 IOVSS.n1060 17.0005
R764 IOVSS.n1579 IOVSS.n1518 17.0005
R765 IOVSS.n1579 IOVSS.n1148 17.0005
R766 IOVSS.n1579 IOVSS.n1546 17.0005
R767 IOVSS.n1579 IOVSS.n1150 17.0005
R768 IOVSS.n1579 IOVSS.n1517 17.0005
R769 IOVSS.n1579 IOVSS.n1152 17.0005
R770 IOVSS.n1579 IOVSS.n1549 17.0005
R771 IOVSS.n1579 IOVSS.n1155 17.0005
R772 IOVSS.n1579 IOVSS.n1516 17.0005
R773 IOVSS.n1579 IOVSS.n1157 17.0005
R774 IOVSS.n1579 IOVSS.n1552 17.0005
R775 IOVSS.n1579 IOVSS.n1159 17.0005
R776 IOVSS.n1579 IOVSS.n1515 17.0005
R777 IOVSS.n1579 IOVSS.n1161 17.0005
R778 IOVSS.n1579 IOVSS.n1555 17.0005
R779 IOVSS.n1579 IOVSS.n1163 17.0005
R780 IOVSS.n1579 IOVSS.n1514 17.0005
R781 IOVSS.n1579 IOVSS.n1165 17.0005
R782 IOVSS.n1579 IOVSS.n1558 17.0005
R783 IOVSS.n1579 IOVSS.n1168 17.0005
R784 IOVSS.n1579 IOVSS.n1513 17.0005
R785 IOVSS.n1579 IOVSS.n1170 17.0005
R786 IOVSS.n1579 IOVSS.n1561 17.0005
R787 IOVSS.n1579 IOVSS.n1172 17.0005
R788 IOVSS.n1579 IOVSS.n1512 17.0005
R789 IOVSS.n1579 IOVSS.n1082 17.0005
R790 IOVSS.n1579 IOVSS.n1564 17.0005
R791 IOVSS.n1579 IOVSS.n1173 17.0005
R792 IOVSS.n1579 IOVSS.n1511 17.0005
R793 IOVSS.n1579 IOVSS.n1175 17.0005
R794 IOVSS.n1579 IOVSS.n1567 17.0005
R795 IOVSS.n1579 IOVSS.n1178 17.0005
R796 IOVSS.n1579 IOVSS.n1510 17.0005
R797 IOVSS.n1579 IOVSS.n1180 17.0005
R798 IOVSS.n1579 IOVSS.n1570 17.0005
R799 IOVSS.n1579 IOVSS.n1182 17.0005
R800 IOVSS.n1579 IOVSS.n1509 17.0005
R801 IOVSS.n1579 IOVSS.n1184 17.0005
R802 IOVSS.n1579 IOVSS.n1573 17.0005
R803 IOVSS.n1579 IOVSS.n1187 17.0005
R804 IOVSS.n1579 IOVSS.n1508 17.0005
R805 IOVSS.n1579 IOVSS.n1189 17.0005
R806 IOVSS.n1579 IOVSS.n1576 17.0005
R807 IOVSS.n1579 IOVSS.n1191 17.0005
R808 IOVSS.n1579 IOVSS.n1507 17.0005
R809 IOVSS.n1579 IOVSS.n1578 17.0005
R810 IOVSS.n1579 IOVSS.n1130 17.0005
R811 IOVSS.n1135 IOVSS.n1023 17.0005
R812 IOVSS.n1144 IOVSS.n1023 17.0005
R813 IOVSS.n1115 IOVSS.n1023 17.0005
R814 IOVSS.n1147 IOVSS.n1023 17.0005
R815 IOVSS.n1149 IOVSS.n1023 17.0005
R816 IOVSS.n1151 IOVSS.n1023 17.0005
R817 IOVSS.n1154 IOVSS.n1023 17.0005
R818 IOVSS.n1156 IOVSS.n1023 17.0005
R819 IOVSS.n1158 IOVSS.n1023 17.0005
R820 IOVSS.n1160 IOVSS.n1023 17.0005
R821 IOVSS.n1162 IOVSS.n1023 17.0005
R822 IOVSS.n1164 IOVSS.n1023 17.0005
R823 IOVSS.n1167 IOVSS.n1023 17.0005
R824 IOVSS.n1169 IOVSS.n1023 17.0005
R825 IOVSS.n1171 IOVSS.n1023 17.0005
R826 IOVSS.n1122 IOVSS.n1023 17.0005
R827 IOVSS.n1100 IOVSS.n1023 17.0005
R828 IOVSS.n1174 IOVSS.n1023 17.0005
R829 IOVSS.n1177 IOVSS.n1023 17.0005
R830 IOVSS.n1179 IOVSS.n1023 17.0005
R831 IOVSS.n1181 IOVSS.n1023 17.0005
R832 IOVSS.n1183 IOVSS.n1023 17.0005
R833 IOVSS.n1186 IOVSS.n1023 17.0005
R834 IOVSS.n1188 IOVSS.n1023 17.0005
R835 IOVSS.n1190 IOVSS.n1023 17.0005
R836 IOVSS.n1192 IOVSS.n1023 17.0005
R837 IOVSS.n1193 IOVSS.n1023 17.0005
R838 IOVSS.n1616 IOVSS.n1023 17.0005
R839 IOVSS.n1133 IOVSS.n1023 17.0005
R840 IOVSS.n1131 IOVSS.n1023 17.0005
R841 IOVSS.n1024 IOVSS.n1023 17.0005
R842 IOVSS.n1750 IOVSS.n733 17.0005
R843 IOVSS.n1750 IOVSS.n734 17.0005
R844 IOVSS.n1761 IOVSS.n651 17.0005
R845 IOVSS.n1761 IOVSS.n616 17.0005
R846 IOVSS.n1761 IOVSS.n653 17.0005
R847 IOVSS.n1761 IOVSS.n614 17.0005
R848 IOVSS.n1761 IOVSS.n655 17.0005
R849 IOVSS.n1761 IOVSS.n610 17.0005
R850 IOVSS.n1758 IOVSS.n685 17.0005
R851 IOVSS.n1759 IOVSS.n1758 17.0005
R852 IOVSS.n1758 IOVSS.n684 17.0005
R853 IOVSS.n1758 IOVSS.n683 17.0005
R854 IOVSS.n1758 IOVSS.n682 17.0005
R855 IOVSS.n1758 IOVSS.n680 17.0005
R856 IOVSS.n1712 IOVSS.n1649 17.0005
R857 IOVSS.n1712 IOVSS.n1651 17.0005
R858 IOVSS.n1712 IOVSS.n1652 17.0005
R859 IOVSS.n1712 IOVSS.n1648 17.0005
R860 IOVSS.n1712 IOVSS.n1647 17.0005
R861 IOVSS.n1712 IOVSS.n1653 17.0005
R862 IOVSS.n1712 IOVSS.n1654 17.0005
R863 IOVSS.n1712 IOVSS.n1646 17.0005
R864 IOVSS.n1712 IOVSS.n1645 17.0005
R865 IOVSS.n1712 IOVSS.n1710 17.0005
R866 IOVSS.n1712 IOVSS.n1711 17.0005
R867 IOVSS.n822 IOVSS.n690 17.0005
R868 IOVSS.n823 IOVSS.n822 17.0005
R869 IOVSS.n827 IOVSS.n826 17.0005
R870 IOVSS.n828 IOVSS.n827 17.0005
R871 IOVSS.n832 IOVSS.n831 17.0005
R872 IOVSS.n833 IOVSS.n832 17.0005
R873 IOVSS.n837 IOVSS.n836 17.0005
R874 IOVSS.n838 IOVSS.n837 17.0005
R875 IOVSS.n842 IOVSS.n841 17.0005
R876 IOVSS.n843 IOVSS.n842 17.0005
R877 IOVSS.n847 IOVSS.n846 17.0005
R878 IOVSS.n848 IOVSS.n847 17.0005
R879 IOVSS.n1732 IOVSS.n1730 17.0005
R880 IOVSS.n1711 IOVSS.n523 17.0005
R881 IOVSS.n1645 IOVSS.n523 17.0005
R882 IOVSS.n1654 IOVSS.n523 17.0005
R883 IOVSS.n1647 IOVSS.n523 17.0005
R884 IOVSS.n1652 IOVSS.n523 17.0005
R885 IOVSS.n1649 IOVSS.n523 17.0005
R886 IOVSS.n680 IOVSS.n523 17.0005
R887 IOVSS.n682 IOVSS.n523 17.0005
R888 IOVSS.n683 IOVSS.n523 17.0005
R889 IOVSS.n1759 IOVSS.n523 17.0005
R890 IOVSS.n679 IOVSS.n523 17.0005
R891 IOVSS.n723 IOVSS.n523 17.0005
R892 IOVSS.n1733 IOVSS.n1732 17.0005
R893 IOVSS.n849 IOVSS.n810 17.0005
R894 IOVSS.n850 IOVSS.n849 17.0005
R895 IOVSS.n844 IOVSS.n812 17.0005
R896 IOVSS.n845 IOVSS.n844 17.0005
R897 IOVSS.n839 IOVSS.n814 17.0005
R898 IOVSS.n840 IOVSS.n839 17.0005
R899 IOVSS.n834 IOVSS.n816 17.0005
R900 IOVSS.n835 IOVSS.n834 17.0005
R901 IOVSS.n829 IOVSS.n818 17.0005
R902 IOVSS.n830 IOVSS.n829 17.0005
R903 IOVSS.n824 IOVSS.n820 17.0005
R904 IOVSS.n825 IOVSS.n824 17.0005
R905 IOVSS.n1754 IOVSS.n691 17.0005
R906 IOVSS.n1755 IOVSS.n1754 17.0005
R907 IOVSS.n1742 IOVSS.n694 17.0005
R908 IOVSS.n1748 IOVSS.n786 17.0005
R909 IOVSS.n1749 IOVSS.n1748 17.0005
R910 IOVSS.n1019 IOVSS.n899 17.0005
R911 IOVSS.n1019 IOVSS.n898 17.0005
R912 IOVSS.n1019 IOVSS.n897 17.0005
R913 IOVSS.n1019 IOVSS.n896 17.0005
R914 IOVSS.n1001 IOVSS.n944 17.0005
R915 IOVSS.n1002 IOVSS.n1001 17.0005
R916 IOVSS.n993 IOVSS.n945 17.0005
R917 IOVSS.n994 IOVSS.n993 17.0005
R918 IOVSS.n987 IOVSS.n946 17.0005
R919 IOVSS.n988 IOVSS.n987 17.0005
R920 IOVSS.n981 IOVSS.n947 17.0005
R921 IOVSS.n982 IOVSS.n981 17.0005
R922 IOVSS.n980 IOVSS.n979 17.0005
R923 IOVSS.n979 IOVSS.n978 17.0005
R924 IOVSS.n974 IOVSS.n973 17.0005
R925 IOVSS.n973 IOVSS.n972 17.0005
R926 IOVSS.n965 IOVSS.n953 17.0005
R927 IOVSS.n963 IOVSS.n953 17.0005
R928 IOVSS.n962 IOVSS.n955 17.0005
R929 IOVSS.n960 IOVSS.n955 17.0005
R930 IOVSS.n1001 IOVSS.n898 17.0005
R931 IOVSS.n1001 IOVSS.n897 17.0005
R932 IOVSS.n1001 IOVSS.n892 17.0005
R933 IOVSS.n2086 IOVSS.n151 17.0005
R934 IOVSS.n2086 IOVSS.n149 17.0005
R935 IOVSS.n2086 IOVSS.n148 17.0005
R936 IOVSS.n2086 IOVSS.n147 17.0005
R937 IOVSS.n2086 IOVSS.n143 17.0005
R938 IOVSS.n2086 IOVSS.n142 17.0005
R939 IOVSS.n2086 IOVSS.n139 17.0005
R940 IOVSS.n2086 IOVSS.n137 17.0005
R941 IOVSS.n2086 IOVSS.n136 17.0005
R942 IOVSS.n2086 IOVSS.n135 17.0005
R943 IOVSS.n2086 IOVSS.n132 17.0005
R944 IOVSS.n2086 IOVSS.n131 17.0005
R945 IOVSS.n2086 IOVSS.n127 17.0005
R946 IOVSS.n2086 IOVSS.n126 17.0005
R947 IOVSS.n2086 IOVSS.n123 17.0005
R948 IOVSS.n2086 IOVSS.n121 17.0005
R949 IOVSS.n2086 IOVSS.n120 17.0005
R950 IOVSS.n2086 IOVSS.n119 17.0005
R951 IOVSS.n2086 IOVSS.n116 17.0005
R952 IOVSS.n2086 IOVSS.n115 17.0005
R953 IOVSS.n2086 IOVSS.n111 17.0005
R954 IOVSS.n2086 IOVSS.n110 17.0005
R955 IOVSS.n2086 IOVSS.n104 17.0005
R956 IOVSS.n958 IOVSS.n957 17.0005
R957 IOVSS.n959 IOVSS.n958 17.0005
R958 IOVSS.n961 IOVSS.n960 17.0005
R959 IOVSS.n962 IOVSS.n961 17.0005
R960 IOVSS.n964 IOVSS.n963 17.0005
R961 IOVSS.n965 IOVSS.n964 17.0005
R962 IOVSS.n967 IOVSS.n966 17.0005
R963 IOVSS.n968 IOVSS.n967 17.0005
R964 IOVSS.n976 IOVSS.n975 17.0005
R965 IOVSS.n977 IOVSS.n976 17.0005
R966 IOVSS.n985 IOVSS.n984 17.0005
R967 IOVSS.n986 IOVSS.n985 17.0005
R968 IOVSS.n990 IOVSS.n989 17.0005
R969 IOVSS.n991 IOVSS.n990 17.0005
R970 IOVSS.n996 IOVSS.n995 17.0005
R971 IOVSS.n997 IOVSS.n996 17.0005
R972 IOVSS.n1004 IOVSS.n1003 17.0005
R973 IOVSS.n1005 IOVSS.n1004 17.0005
R974 IOVSS.n1007 IOVSS.n923 17.0005
R975 IOVSS.n1009 IOVSS.n923 17.0005
R976 IOVSS.n180 IOVSS.n179 17.0005
R977 IOVSS.n179 IOVSS.n178 17.0005
R978 IOVSS.n171 IOVSS.n170 17.0005
R979 IOVSS.n170 IOVSS.n169 17.0005
R980 IOVSS.n168 IOVSS.n167 17.0005
R981 IOVSS.n167 IOVSS.n166 17.0005
R982 IOVSS.n2139 IOVSS.n2 17.0005
R983 IOVSS.n2141 IOVSS.n2 17.0005
R984 IOVSS.n2143 IOVSS.n2 17.0005
R985 IOVSS.n2145 IOVSS.n2 17.0005
R986 IOVSS.n2147 IOVSS.n2 17.0005
R987 IOVSS.n2150 IOVSS.n2 17.0005
R988 IOVSS.n2152 IOVSS.n2 17.0005
R989 IOVSS.n2154 IOVSS.n2 17.0005
R990 IOVSS.n2156 IOVSS.n2 17.0005
R991 IOVSS.n2158 IOVSS.n2 17.0005
R992 IOVSS.n2160 IOVSS.n2 17.0005
R993 IOVSS.n2162 IOVSS.n2 17.0005
R994 IOVSS.n2164 IOVSS.n2 17.0005
R995 IOVSS.n2166 IOVSS.n2 17.0005
R996 IOVSS.n2168 IOVSS.n2 17.0005
R997 IOVSS.n2170 IOVSS.n2 17.0005
R998 IOVSS.n2172 IOVSS.n2 17.0005
R999 IOVSS.n2174 IOVSS.n2 17.0005
R1000 IOVSS.n2176 IOVSS.n2 17.0005
R1001 IOVSS.n7 IOVSS.n6 17.0005
R1002 IOVSS.n341 IOVSS.n7 17.0005
R1003 IOVSS.n80 IOVSS.n7 17.0005
R1004 IOVSS.n88 IOVSS.n7 17.0005
R1005 IOVSS.n2225 IOVSS.n7 17.0005
R1006 IOVSS.n2223 IOVSS.n7 17.0005
R1007 IOVSS.n2221 IOVSS.n7 17.0005
R1008 IOVSS.n2138 IOVSS.n7 17.0005
R1009 IOVSS.n2219 IOVSS.n7 17.0005
R1010 IOVSS.n2140 IOVSS.n7 17.0005
R1011 IOVSS.n2217 IOVSS.n7 17.0005
R1012 IOVSS.n2142 IOVSS.n7 17.0005
R1013 IOVSS.n2215 IOVSS.n7 17.0005
R1014 IOVSS.n2144 IOVSS.n7 17.0005
R1015 IOVSS.n2213 IOVSS.n7 17.0005
R1016 IOVSS.n2146 IOVSS.n7 17.0005
R1017 IOVSS.n2211 IOVSS.n7 17.0005
R1018 IOVSS.n2148 IOVSS.n7 17.0005
R1019 IOVSS.n2209 IOVSS.n7 17.0005
R1020 IOVSS.n2151 IOVSS.n7 17.0005
R1021 IOVSS.n2207 IOVSS.n7 17.0005
R1022 IOVSS.n2153 IOVSS.n7 17.0005
R1023 IOVSS.n2205 IOVSS.n7 17.0005
R1024 IOVSS.n2155 IOVSS.n7 17.0005
R1025 IOVSS.n2203 IOVSS.n7 17.0005
R1026 IOVSS.n2157 IOVSS.n7 17.0005
R1027 IOVSS.n2201 IOVSS.n7 17.0005
R1028 IOVSS.n2159 IOVSS.n7 17.0005
R1029 IOVSS.n2199 IOVSS.n7 17.0005
R1030 IOVSS.n2161 IOVSS.n7 17.0005
R1031 IOVSS.n2197 IOVSS.n7 17.0005
R1032 IOVSS.n2163 IOVSS.n7 17.0005
R1033 IOVSS.n2195 IOVSS.n7 17.0005
R1034 IOVSS.n2165 IOVSS.n7 17.0005
R1035 IOVSS.n2193 IOVSS.n7 17.0005
R1036 IOVSS.n2167 IOVSS.n7 17.0005
R1037 IOVSS.n2191 IOVSS.n7 17.0005
R1038 IOVSS.n2169 IOVSS.n7 17.0005
R1039 IOVSS.n2189 IOVSS.n7 17.0005
R1040 IOVSS.n2171 IOVSS.n7 17.0005
R1041 IOVSS.n2187 IOVSS.n7 17.0005
R1042 IOVSS.n2173 IOVSS.n7 17.0005
R1043 IOVSS.n2185 IOVSS.n7 17.0005
R1044 IOVSS.n2175 IOVSS.n7 17.0005
R1045 IOVSS.n2183 IOVSS.n7 17.0005
R1046 IOVSS.n2177 IOVSS.n7 17.0005
R1047 IOVSS.n2232 IOVSS.n2231 17.0005
R1048 IOVSS.n2231 IOVSS.n16 17.0005
R1049 IOVSS.n2083 IOVSS.n89 17.0005
R1050 IOVSS.n2083 IOVSS.n149 17.0005
R1051 IOVSS.n2083 IOVSS.n148 17.0005
R1052 IOVSS.n2083 IOVSS.n147 17.0005
R1053 IOVSS.n2081 IOVSS.n206 17.0005
R1054 IOVSS.n2081 IOVSS.n205 17.0005
R1055 IOVSS.n2081 IOVSS.n143 17.0005
R1056 IOVSS.n2081 IOVSS.n142 17.0005
R1057 IOVSS.n2081 IOVSS.n208 17.0005
R1058 IOVSS.n2081 IOVSS.n137 17.0005
R1059 IOVSS.n2081 IOVSS.n136 17.0005
R1060 IOVSS.n2081 IOVSS.n131 17.0005
R1061 IOVSS.n2081 IOVSS.n209 17.0005
R1062 IOVSS.n2081 IOVSS.n196 17.0005
R1063 IOVSS.n2081 IOVSS.n120 17.0005
R1064 IOVSS.n2081 IOVSS.n2078 17.0005
R1065 IOVSS.n2081 IOVSS.n116 17.0005
R1066 IOVSS.n2081 IOVSS.n115 17.0005
R1067 IOVSS.n2081 IOVSS.n2076 17.0005
R1068 IOVSS.n2081 IOVSS.n2073 17.0005
R1069 IOVSS.n2081 IOVSS.n111 17.0005
R1070 IOVSS.n2081 IOVSS.n110 17.0005
R1071 IOVSS.n2081 IOVSS.n2071 17.0005
R1072 IOVSS.n2081 IOVSS.n127 17.0005
R1073 IOVSS.n2081 IOVSS.n121 17.0005
R1074 IOVSS.n785 IOVSS.n779 16.7693
R1075 IOVSS.n571 IOVSS.n532 16.702
R1076 IOVSS.n574 IOVSS.n566 16.702
R1077 IOVSS.n144 IOVSS.t231 16.6959
R1078 IOVSS.n347 IOVSS.n346 16.2087
R1079 IOVSS.t38 IOVSS.n135 16.1127
R1080 IOVSS.n2189 IOVSS.t117 16.1127
R1081 IOVSS.n2203 IOVSS.t241 16.1127
R1082 IOVSS.n2217 IOVSS.t238 16.1127
R1083 IOVSS.n1215 IOVSS.n1214 16.1051
R1084 IOVSS.n1214 IOVSS.n1213 16.1051
R1085 IOVSS.n1213 IOVSS.n1211 16.1051
R1086 IOVSS.n999 IOVSS.n895 16.0607
R1087 IOVSS.n1000 IOVSS.n900 16.0607
R1088 IOVSS.n902 IOVSS.n900 16.0607
R1089 IOVSS.n212 IOVSS.n106 16.0607
R1090 IOVSS.n2070 IOVSS.n108 16.0607
R1091 IOVSS.n2074 IOVSS.n112 16.0607
R1092 IOVSS.n2075 IOVSS.n113 16.0607
R1093 IOVSS.n2079 IOVSS.n117 16.0607
R1094 IOVSS.n2080 IOVSS.n118 16.0607
R1095 IOVSS.n194 IOVSS.n124 16.0607
R1096 IOVSS.n195 IOVSS.n125 16.0607
R1097 IOVSS.n197 IOVSS.n129 16.0607
R1098 IOVSS.n198 IOVSS.n129 16.0607
R1099 IOVSS.n198 IOVSS.n130 16.0607
R1100 IOVSS.n200 IOVSS.n133 16.0607
R1101 IOVSS.n201 IOVSS.n133 16.0607
R1102 IOVSS.n201 IOVSS.n134 16.0607
R1103 IOVSS.n202 IOVSS.n134 16.0607
R1104 IOVSS.n203 IOVSS.n140 16.0607
R1105 IOVSS.n204 IOVSS.n140 16.0607
R1106 IOVSS.n204 IOVSS.n141 16.0607
R1107 IOVSS.n2084 IOVSS.n152 16.0607
R1108 IOVSS.n2085 IOVSS.n2084 16.0607
R1109 IOVSS.n192 IOVSS.n152 16.0607
R1110 IOVSS.n2079 IOVSS.n118 16.0607
R1111 IOVSS.n2075 IOVSS.n114 16.0607
R1112 IOVSS.n2074 IOVSS.n113 16.0607
R1113 IOVSS.n2070 IOVSS.n109 16.0607
R1114 IOVSS.n212 IOVSS.n108 16.0607
R1115 IOVSS.n194 IOVSS.n125 16.0607
R1116 IOVSS.n193 IOVSS.n124 16.0607
R1117 IOVSS.t0 IOVSS.n1308 16.0597
R1118 IOVSS.n1584 IOVSS.n1583 16.0373
R1119 IOVSS.n1581 IOVSS.n1140 16.0361
R1120 IOVSS.t71 IOVSS.n18 15.8863
R1121 IOVSS.n1260 IOVSS.t39 15.3484
R1122 IOVSS.n1260 IOVSS.t62 15.3472
R1123 IOVSS.n1262 IOVSS.t28 15.3435
R1124 IOVSS.n1291 IOVSS.t165 15.3122
R1125 IOVSS.n1258 IOVSS.t22 15.3021
R1126 IOVSS.n1270 IOVSS.t21 15.3021
R1127 IOVSS.n1277 IOVSS.t212 15.3021
R1128 IOVSS.n1284 IOVSS.t213 15.3021
R1129 IOVSS.n1298 IOVSS.t166 15.3021
R1130 IOVSS.n1244 IOVSS.t152 15.2838
R1131 IOVSS.n1251 IOVSS.t151 15.2498
R1132 IOVSS.n123 IOVSS.t148 15.2176
R1133 IOVSS.n349 IOVSS.t216 15.133
R1134 IOVSS.n1008 IOVSS.t3 15.0671
R1135 IOVSS.n1263 IOVSS.t217 15.0029
R1136 IOVSS.n188 IOVSS.t193 15.0005
R1137 IOVSS.n186 IOVSS.t192 15.0005
R1138 IOVSS.n184 IOVSS.t27 15.0005
R1139 IOVSS.n182 IOVSS.t26 15.0005
R1140 IOVSS.n159 IOVSS.t203 15.0005
R1141 IOVSS.n177 IOVSS.t202 15.0005
R1142 IOVSS.n175 IOVSS.t225 15.0005
R1143 IOVSS.n173 IOVSS.t224 15.0005
R1144 IOVSS.n163 IOVSS.t6 15.0005
R1145 IOVSS.n164 IOVSS.t5 15.0005
R1146 IOVSS.n1006 IOVSS.t2 15.0005
R1147 IOVSS.n998 IOVSS.t229 15.0005
R1148 IOVSS.n992 IOVSS.t228 15.0005
R1149 IOVSS.n983 IOVSS.t33 15.0005
R1150 IOVSS.n948 IOVSS.t32 15.0005
R1151 IOVSS.n949 IOVSS.t188 15.0005
R1152 IOVSS.n969 IOVSS.t187 15.0005
R1153 IOVSS.n952 IOVSS.t174 15.0005
R1154 IOVSS.n954 IOVSS.t173 15.0005
R1155 IOVSS.n327 IOVSS.t223 15.0005
R1156 IOVSS.n327 IOVSS.t222 15.0005
R1157 IOVSS.n328 IOVSS.t190 15.0005
R1158 IOVSS.n328 IOVSS.t189 15.0005
R1159 IOVSS.n329 IOVSS.t168 15.0005
R1160 IOVSS.n329 IOVSS.t167 15.0005
R1161 IOVSS.n330 IOVSS.t245 15.0005
R1162 IOVSS.n330 IOVSS.t244 15.0005
R1163 IOVSS.n331 IOVSS.t31 15.0005
R1164 IOVSS.n331 IOVSS.t30 15.0005
R1165 IOVSS.n332 IOVSS.t181 15.0005
R1166 IOVSS.n332 IOVSS.t180 15.0005
R1167 IOVSS.n241 IOVSS.t195 15.0005
R1168 IOVSS.n241 IOVSS.t194 15.0005
R1169 IOVSS.n242 IOVSS.t219 15.0005
R1170 IOVSS.n242 IOVSS.t218 15.0005
R1171 IOVSS.n243 IOVSS.t221 15.0005
R1172 IOVSS.n243 IOVSS.t220 15.0005
R1173 IOVSS.n244 IOVSS.t150 15.0005
R1174 IOVSS.n244 IOVSS.t149 15.0005
R1175 IOVSS.n245 IOVSS.t37 15.0005
R1176 IOVSS.n245 IOVSS.t36 15.0005
R1177 IOVSS.n246 IOVSS.t215 15.0005
R1178 IOVSS.n246 IOVSS.t214 15.0005
R1179 IOVSS.n1244 IOVSS.t208 15.0005
R1180 IOVSS.n1245 IOVSS.t160 15.0005
R1181 IOVSS.n1246 IOVSS.t146 15.0005
R1182 IOVSS.n1247 IOVSS.t158 15.0005
R1183 IOVSS.n1248 IOVSS.t206 15.0005
R1184 IOVSS.n1251 IOVSS.t207 15.0005
R1185 IOVSS.n1252 IOVSS.t159 15.0005
R1186 IOVSS.n1253 IOVSS.t145 15.0005
R1187 IOVSS.n1254 IOVSS.t157 15.0005
R1188 IOVSS.n1255 IOVSS.t205 15.0005
R1189 IOVSS.n1258 IOVSS.t201 15.0005
R1190 IOVSS.n1259 IOVSS.t172 15.0005
R1191 IOVSS.n1265 IOVSS.t25 15.0005
R1192 IOVSS.n1266 IOVSS.t243 15.0005
R1193 IOVSS.n1267 IOVSS.t233 15.0005
R1194 IOVSS.n1270 IOVSS.t200 15.0005
R1195 IOVSS.n1271 IOVSS.t171 15.0005
R1196 IOVSS.n1272 IOVSS.t24 15.0005
R1197 IOVSS.n1273 IOVSS.t242 15.0005
R1198 IOVSS.n1274 IOVSS.t232 15.0005
R1199 IOVSS.n1277 IOVSS.t153 15.0005
R1200 IOVSS.n1278 IOVSS.t155 15.0005
R1201 IOVSS.n1279 IOVSS.t226 15.0005
R1202 IOVSS.n1280 IOVSS.t183 15.0005
R1203 IOVSS.n1281 IOVSS.t196 15.0005
R1204 IOVSS.n1284 IOVSS.t154 15.0005
R1205 IOVSS.n1285 IOVSS.t156 15.0005
R1206 IOVSS.n1286 IOVSS.t227 15.0005
R1207 IOVSS.n1287 IOVSS.t184 15.0005
R1208 IOVSS.n1288 IOVSS.t197 15.0005
R1209 IOVSS.n1291 IOVSS.t10 15.0005
R1210 IOVSS.n1292 IOVSS.t169 15.0005
R1211 IOVSS.n1293 IOVSS.t210 15.0005
R1212 IOVSS.n1294 IOVSS.t163 15.0005
R1213 IOVSS.n1295 IOVSS.t185 15.0005
R1214 IOVSS.n1298 IOVSS.t11 15.0005
R1215 IOVSS.n1299 IOVSS.t170 15.0005
R1216 IOVSS.n1300 IOVSS.t211 15.0005
R1217 IOVSS.n1301 IOVSS.t164 15.0005
R1218 IOVSS.n1302 IOVSS.t186 15.0005
R1219 IOVSS.t35 IOVSS.n383 14.5843
R1220 IOVSS.t64 IOVSS.n46 14.3798
R1221 IOVSS.n1136 IOVSS.n1112 14.3008
R1222 IOVSS.n1145 IOVSS.n1114 14.3008
R1223 IOVSS.n1173 IOVSS.n1124 14.3008
R1224 IOVSS.n1175 IOVSS.n1105 14.3008
R1225 IOVSS.n1180 IOVSS.n1104 14.3008
R1226 IOVSS.n1182 IOVSS.n1126 14.3008
R1227 IOVSS.n1189 IOVSS.n1102 14.3008
R1228 IOVSS.n1191 IOVSS.n1128 14.3008
R1229 IOVSS.n1195 IOVSS.n1194 14.3008
R1230 IOVSS.n1617 IOVSS.n1130 14.3008
R1231 IOVSS.n1615 IOVSS.n1134 14.3008
R1232 IOVSS.t29 IOVSS.n289 13.9766
R1233 IOVSS.n1708 IOVSS.n617 13.9184
R1234 IOVSS.n1705 IOVSS.n650 13.9184
R1235 IOVSS.n1703 IOVSS.n619 13.9184
R1236 IOVSS.n1701 IOVSS.n648 13.9184
R1237 IOVSS.n1699 IOVSS.n621 13.9184
R1238 IOVSS.n1697 IOVSS.n646 13.9184
R1239 IOVSS.n1695 IOVSS.n623 13.9184
R1240 IOVSS.n1691 IOVSS.n625 13.9184
R1241 IOVSS.n1689 IOVSS.n642 13.9184
R1242 IOVSS.n1687 IOVSS.n627 13.9184
R1243 IOVSS.n1685 IOVSS.n640 13.9184
R1244 IOVSS.n1683 IOVSS.n629 13.9184
R1245 IOVSS.n1681 IOVSS.n638 13.9184
R1246 IOVSS.n1679 IOVSS.n631 13.9184
R1247 IOVSS.n1677 IOVSS.n636 13.9184
R1248 IOVSS.n1655 IOVSS.n634 13.9184
R1249 IOVSS.t175 IOVSS.n1713 13.9184
R1250 IOVSS.n1135 IOVSS.n1114 13.7901
R1251 IOVSS.n1144 IOVSS.n1054 13.7901
R1252 IOVSS.n1116 IOVSS.n1115 13.7901
R1253 IOVSS.n1147 IOVSS.n1111 13.7901
R1254 IOVSS.n1149 IOVSS.n1117 13.7901
R1255 IOVSS.n1151 IOVSS.n1110 13.7901
R1256 IOVSS.n1154 IOVSS.n1118 13.7901
R1257 IOVSS.n1156 IOVSS.n1109 13.7901
R1258 IOVSS.n1119 IOVSS.t41 13.7901
R1259 IOVSS.n1264 IOVSS.n1263 13.7363
R1260 IOVSS.n346 IOVSS.n345 13.4857
R1261 IOVSS.n344 IOVSS.n343 13.4857
R1262 IOVSS.n82 IOVSS.n81 13.4857
R1263 IOVSS.n84 IOVSS.n83 13.4857
R1264 IOVSS.n86 IOVSS.n85 13.4857
R1265 IOVSS.n85 IOVSS.n84 13.4851
R1266 IOVSS.n83 IOVSS.n82 13.4851
R1267 IOVSS.n343 IOVSS.n342 13.4851
R1268 IOVSS.n345 IOVSS.n344 13.4851
R1269 IOVSS.n1716 IOVSS.n852 13.4538
R1270 IOVSS.n443 IOVSS.n440 13.4466
R1271 IOVSS.n445 IOVSS.n444 13.4466
R1272 IOVSS.n447 IOVSS.n446 13.4466
R1273 IOVSS.n451 IOVSS.n450 13.4466
R1274 IOVSS.n453 IOVSS.n452 13.4466
R1275 IOVSS.n455 IOVSS.n454 13.4466
R1276 IOVSS.n457 IOVSS.n456 13.4466
R1277 IOVSS.n459 IOVSS.n458 13.4466
R1278 IOVSS.n461 IOVSS.n460 13.4466
R1279 IOVSS.n465 IOVSS.n464 13.4466
R1280 IOVSS.n467 IOVSS.n466 13.4466
R1281 IOVSS.n469 IOVSS.n468 13.4466
R1282 IOVSS.n473 IOVSS.n472 13.4466
R1283 IOVSS.n475 IOVSS.n474 13.4466
R1284 IOVSS.t34 IOVSS.n127 13.4273
R1285 IOVSS.t162 IOVSS.n2225 13.4273
R1286 IOVSS.t7 IOVSS.n131 13.4124
R1287 IOVSS.n1718 IOVSS.n1717 13.0266
R1288 IOVSS IOVSS.n2051 12.995
R1289 IOVSS.n1770 IOVSS.n1769 12.9902
R1290 IOVSS.t12 IOVSS.n37 12.7788
R1291 IOVSS.n1160 IOVSS.n1119 12.7686
R1292 IOVSS.n1162 IOVSS.n1108 12.7686
R1293 IOVSS.n1164 IOVSS.n1120 12.7686
R1294 IOVSS.n1167 IOVSS.n1107 12.7686
R1295 IOVSS.n1169 IOVSS.n1121 12.7686
R1296 IOVSS.n1171 IOVSS.n1106 12.7686
R1297 IOVSS.n1123 IOVSS.n1122 12.7686
R1298 IOVSS.n1619 IOVSS.n1100 12.7686
R1299 IOVSS.n1174 IOVSS.n1124 12.7686
R1300 IOVSS.n1177 IOVSS.n1105 12.7686
R1301 IOVSS.n1179 IOVSS.n1125 12.7686
R1302 IOVSS.n1181 IOVSS.n1104 12.7686
R1303 IOVSS.n1183 IOVSS.n1126 12.7686
R1304 IOVSS.n1186 IOVSS.n1103 12.7686
R1305 IOVSS.n1188 IOVSS.n1127 12.7686
R1306 IOVSS.n1190 IOVSS.n1102 12.7686
R1307 IOVSS.n1192 IOVSS.n1128 12.7686
R1308 IOVSS.n1194 IOVSS.n1193 12.7686
R1309 IOVSS.n1617 IOVSS.n1616 12.7686
R1310 IOVSS.n1134 IOVSS.n1133 12.7686
R1311 IOVSS.n1131 IOVSS.t99 12.7686
R1312 IOVSS.n2072 IOVSS.n111 12.6819
R1313 IOVSS.n1308 IOVSS.t8 12.6151
R1314 IOVSS.n2211 IOVSS.t161 12.5322
R1315 IOVSS.n633 IOVSS.n396 12.5266
R1316 IOVSS.n339 IOVSS.n309 12.274
R1317 IOVSS.t209 IOVSS.n308 12.2713
R1318 IOVSS.t8 IOVSS.t20 11.9248
R1319 IOVSS.t147 IOVSS.t9 11.9248
R1320 IOVSS.n207 IOVSS.n143 11.6674
R1321 IOVSS.n150 IOVSS.n148 11.6674
R1322 IOVSS.n1760 IOVSS.n679 11.6172
R1323 IOVSS.n1759 IOVSS.n609 11.6172
R1324 IOVSS.n683 IOVSS.n659 11.6172
R1325 IOVSS.n682 IOVSS.n611 11.6172
R1326 IOVSS.n1649 IOVSS.n612 11.6172
R1327 IOVSS.n1652 IOVSS.n656 11.6172
R1328 IOVSS.n1647 IOVSS.n613 11.6172
R1329 IOVSS.n1654 IOVSS.n654 11.6172
R1330 IOVSS.n1645 IOVSS.n615 11.6172
R1331 IOVSS.n1711 IOVSS.n652 11.6172
R1332 IOVSS.t142 IOVSS.n481 11.613
R1333 IOVSS.n2077 IOVSS.n115 11.1602
R1334 IOVSS.t60 IOVSS.n644 11.1348
R1335 IOVSS.n449 IOVSS.t107 11.0018
R1336 IOVSS.n463 IOVSS.t237 11.0018
R1337 IOVSS.n477 IOVSS.t234 11.0018
R1338 IOVSS.t182 IOVSS.n2076 10.742
R1339 IOVSS.n2182 IOVSS.n2181 10.742
R1340 IOVSS.n2184 IOVSS.n2183 10.742
R1341 IOVSS.n2186 IOVSS.n2185 10.742
R1342 IOVSS.n2188 IOVSS.n2187 10.742
R1343 IOVSS.n2190 IOVSS.n2189 10.742
R1344 IOVSS.n2192 IOVSS.n2191 10.742
R1345 IOVSS.n2196 IOVSS.n2195 10.742
R1346 IOVSS.n2198 IOVSS.n2197 10.742
R1347 IOVSS.n2200 IOVSS.n2199 10.742
R1348 IOVSS.n2202 IOVSS.n2201 10.742
R1349 IOVSS.n2204 IOVSS.n2203 10.742
R1350 IOVSS.n2206 IOVSS.n2205 10.742
R1351 IOVSS.n2208 IOVSS.n2207 10.742
R1352 IOVSS.n2210 IOVSS.n2209 10.742
R1353 IOVSS.n2212 IOVSS.n2211 10.742
R1354 IOVSS.n2214 IOVSS.n2213 10.742
R1355 IOVSS.n2216 IOVSS.n2215 10.742
R1356 IOVSS.t95 IOVSS.n657 10.4555
R1357 IOVSS.n1630 IOVSS.n1629 10.209
R1358 IOVSS.n1449 IOVSS.n1448 10.2064
R1359 IOVSS.t19 IOVSS.n205 9.84684
R1360 IOVSS.t4 IOVSS.n147 9.84684
R1361 IOVSS.t230 IOVSS.n897 9.80106
R1362 IOVSS.n2023 IOVSS.n2022 9.75615
R1363 IOVSS.t9 IOVSS.n1309 9.71029
R1364 IOVSS.t230 IOVSS.n898 9.43488
R1365 IOVSS.t230 IOVSS.n896 9.39928
R1366 IOVSS.n325 IOVSS.n253 9.32714
R1367 IOVSS.n283 IOVSS.n282 9.32714
R1368 IOVSS.n276 IOVSS.n275 9.32714
R1369 IOVSS.n269 IOVSS.n268 9.32714
R1370 IOVSS.n262 IOVSS.n261 9.32714
R1371 IOVSS.n383 IOVSS.n382 9.32714
R1372 IOVSS.n2025 IOVSS.n388 9.32714
R1373 IOVSS.n385 IOVSS.n384 9.32714
R1374 IOVSS.n267 IOVSS.n266 9.32714
R1375 IOVSS.n274 IOVSS.n273 9.32714
R1376 IOVSS.n281 IOVSS.n280 9.32714
R1377 IOVSS.n288 IOVSS.n287 9.32714
R1378 IOVSS.n337 IOVSS.n252 9.32714
R1379 IOVSS.n255 IOVSS.n254 9.32714
R1380 IOVSS.n196 IOVSS.n128 9.31233
R1381 IOVSS.t178 IOVSS.n652 9.29382
R1382 IOVSS.t47 IOVSS.n1103 9.19355
R1383 IOVSS.n1890 IOVSS.t142 9.16827
R1384 IOVSS.n1749 IOVSS.n743 9.13669
R1385 IOVSS.n797 IOVSS.n734 9.13669
R1386 IOVSS.n727 IOVSS.n694 9.13669
R1387 IOVSS.n686 IOVSS.n679 9.13669
R1388 IOVSS.n786 IOVSS.n742 9.13669
R1389 IOVSS.n723 IOVSS.n686 9.13669
R1390 IOVSS.n798 IOVSS.n733 9.13669
R1391 IOVSS.n2194 IOVSS.t64 8.95172
R1392 IOVSS.n1624 IOVSS.n1060 8.68283
R1393 IOVSS.n1150 IOVSS.n1051 8.68283
R1394 IOVSS.n1152 IOVSS.n1038 8.68283
R1395 IOVSS.n1155 IOVSS.n1050 8.68283
R1396 IOVSS.n1159 IOVSS.n1049 8.68283
R1397 IOVSS.n122 IOVSS.n121 8.624
R1398 IOVSS.n1132 IOVSS.n1131 8.5912
R1399 IOVSS.n1639 IOVSS.n1024 8.5912
R1400 IOVSS.n1133 IOVSS.n1132 8.5912
R1401 IOVSS.n471 IOVSS.t191 8.55709
R1402 IOVSS.n380 IOVSS.n247 8.501
R1403 IOVSS.n339 IOVSS.n323 8.501
R1404 IOVSS.n339 IOVSS.n320 8.501
R1405 IOVSS.n339 IOVSS.n318 8.501
R1406 IOVSS.n339 IOVSS.n316 8.501
R1407 IOVSS.n339 IOVSS.n314 8.501
R1408 IOVSS.n339 IOVSS.n312 8.501
R1409 IOVSS.n338 IOVSS.n292 8.501
R1410 IOVSS.n338 IOVSS.n294 8.501
R1411 IOVSS.n338 IOVSS.n296 8.501
R1412 IOVSS.n338 IOVSS.n298 8.501
R1413 IOVSS.n338 IOVSS.n300 8.501
R1414 IOVSS.n338 IOVSS.n302 8.501
R1415 IOVSS.n338 IOVSS.n304 8.501
R1416 IOVSS.n338 IOVSS.n306 8.501
R1417 IOVSS.n2025 IOVSS.n394 8.501
R1418 IOVSS.n2025 IOVSS.n393 8.501
R1419 IOVSS.n2025 IOVSS.n392 8.501
R1420 IOVSS.n2025 IOVSS.n391 8.501
R1421 IOVSS.n2025 IOVSS.n390 8.501
R1422 IOVSS.n2025 IOVSS.n389 8.501
R1423 IOVSS.n334 IOVSS.n333 8.501
R1424 IOVSS.n335 IOVSS.n334 8.501
R1425 IOVSS.n2023 IOVSS.n397 8.501
R1426 IOVSS.n2023 IOVSS.n398 8.501
R1427 IOVSS.n2023 IOVSS.n399 8.501
R1428 IOVSS.n2023 IOVSS.n400 8.501
R1429 IOVSS.n2023 IOVSS.n401 8.501
R1430 IOVSS.n2023 IOVSS.n402 8.501
R1431 IOVSS.n2023 IOVSS.n403 8.501
R1432 IOVSS.n2023 IOVSS.n405 8.501
R1433 IOVSS.n2021 IOVSS.n407 8.501
R1434 IOVSS.n2021 IOVSS.n408 8.501
R1435 IOVSS.n2021 IOVSS.n409 8.501
R1436 IOVSS.n2021 IOVSS.n410 8.501
R1437 IOVSS.n2021 IOVSS.n411 8.501
R1438 IOVSS.n2021 IOVSS.n412 8.501
R1439 IOVSS.n2021 IOVSS.n413 8.501
R1440 IOVSS.n2021 IOVSS.n414 8.501
R1441 IOVSS.n2021 IOVSS.n415 8.501
R1442 IOVSS.n2021 IOVSS.n416 8.501
R1443 IOVSS.n2021 IOVSS.n417 8.501
R1444 IOVSS.n2021 IOVSS.n418 8.501
R1445 IOVSS.n2021 IOVSS.n419 8.501
R1446 IOVSS.n2021 IOVSS.n420 8.501
R1447 IOVSS.n2021 IOVSS.n421 8.501
R1448 IOVSS.n2021 IOVSS.n422 8.501
R1449 IOVSS.n2021 IOVSS.n423 8.501
R1450 IOVSS.n2021 IOVSS.n424 8.501
R1451 IOVSS.n2021 IOVSS.n425 8.501
R1452 IOVSS.n2021 IOVSS.n426 8.501
R1453 IOVSS.n2021 IOVSS.n427 8.501
R1454 IOVSS.n2021 IOVSS.n428 8.501
R1455 IOVSS.n2021 IOVSS.n429 8.501
R1456 IOVSS.n2021 IOVSS.n430 8.501
R1457 IOVSS.n2021 IOVSS.n431 8.501
R1458 IOVSS.n2021 IOVSS.n432 8.501
R1459 IOVSS.n2021 IOVSS.n433 8.501
R1460 IOVSS.n2021 IOVSS.n434 8.501
R1461 IOVSS.n2021 IOVSS.n435 8.501
R1462 IOVSS.n2021 IOVSS.n436 8.501
R1463 IOVSS.n2021 IOVSS.n437 8.501
R1464 IOVSS.n2021 IOVSS.n438 8.501
R1465 IOVSS.n2021 IOVSS.n439 8.501
R1466 IOVSS.n2017 IOVSS.n522 8.501
R1467 IOVSS.n2017 IOVSS.n521 8.501
R1468 IOVSS.n2017 IOVSS.n520 8.501
R1469 IOVSS.n2017 IOVSS.n519 8.501
R1470 IOVSS.n2017 IOVSS.n518 8.501
R1471 IOVSS.n2017 IOVSS.n517 8.501
R1472 IOVSS.n2017 IOVSS.n516 8.501
R1473 IOVSS.n2017 IOVSS.n515 8.501
R1474 IOVSS.n2017 IOVSS.n514 8.501
R1475 IOVSS.n2017 IOVSS.n513 8.501
R1476 IOVSS.n2017 IOVSS.n512 8.501
R1477 IOVSS.n2017 IOVSS.n511 8.501
R1478 IOVSS.n2017 IOVSS.n510 8.501
R1479 IOVSS.n2017 IOVSS.n509 8.501
R1480 IOVSS.n2017 IOVSS.n508 8.501
R1481 IOVSS.n2017 IOVSS.n507 8.501
R1482 IOVSS.n2017 IOVSS.n506 8.501
R1483 IOVSS.n2017 IOVSS.n505 8.501
R1484 IOVSS.n2017 IOVSS.n504 8.501
R1485 IOVSS.n2017 IOVSS.n503 8.501
R1486 IOVSS.n2017 IOVSS.n502 8.501
R1487 IOVSS.n2017 IOVSS.n501 8.501
R1488 IOVSS.n2017 IOVSS.n500 8.501
R1489 IOVSS.n2017 IOVSS.n499 8.501
R1490 IOVSS.n2017 IOVSS.n498 8.501
R1491 IOVSS.n2017 IOVSS.n497 8.501
R1492 IOVSS.n2017 IOVSS.n496 8.501
R1493 IOVSS.n2017 IOVSS.n495 8.501
R1494 IOVSS.n2017 IOVSS.n494 8.501
R1495 IOVSS.n2017 IOVSS.n493 8.501
R1496 IOVSS.n2017 IOVSS.n492 8.501
R1497 IOVSS.n2017 IOVSS.n491 8.501
R1498 IOVSS.n2017 IOVSS.n490 8.501
R1499 IOVSS.n1719 IOVSS.n1718 8.501
R1500 IOVSS.n1718 IOVSS.n1643 8.501
R1501 IOVSS.n1722 IOVSS.n853 8.501
R1502 IOVSS.n1769 IOVSS.n526 8.501
R1503 IOVSS.n1769 IOVSS.n527 8.501
R1504 IOVSS.n1769 IOVSS.n528 8.501
R1505 IOVSS.n1584 IOVSS.n1209 8.501
R1506 IOVSS.n1584 IOVSS.n1210 8.501
R1507 IOVSS.n1585 IOVSS.n1584 8.501
R1508 IOVSS.n1581 IOVSS.n1142 8.501
R1509 IOVSS.n1581 IOVSS.n1504 8.501
R1510 IOVSS.n1581 IOVSS.n1505 8.501
R1511 IOVSS.n1461 IOVSS.n1382 8.501
R1512 IOVSS.n1462 IOVSS.n1461 8.501
R1513 IOVSS.n1461 IOVSS.n1384 8.501
R1514 IOVSS.n1333 IOVSS.n1311 8.501
R1515 IOVSS.n1333 IOVSS.n1312 8.501
R1516 IOVSS.n1333 IOVSS.n1313 8.501
R1517 IOVSS.n1333 IOVSS.n1314 8.501
R1518 IOVSS.n1333 IOVSS.n1315 8.501
R1519 IOVSS.n1333 IOVSS.n1316 8.501
R1520 IOVSS.n1333 IOVSS.n1317 8.501
R1521 IOVSS.n1333 IOVSS.n1318 8.501
R1522 IOVSS.n1333 IOVSS.n1319 8.501
R1523 IOVSS.n1333 IOVSS.n1320 8.501
R1524 IOVSS.n1333 IOVSS.n1321 8.501
R1525 IOVSS.n1333 IOVSS.n1322 8.501
R1526 IOVSS.n1333 IOVSS.n1323 8.501
R1527 IOVSS.n1333 IOVSS.n1324 8.501
R1528 IOVSS.n1333 IOVSS.n1325 8.501
R1529 IOVSS.n1333 IOVSS.n1326 8.501
R1530 IOVSS.n1333 IOVSS.n1327 8.501
R1531 IOVSS.n1333 IOVSS.n1328 8.501
R1532 IOVSS.n1333 IOVSS.n1329 8.501
R1533 IOVSS.n1333 IOVSS.n1330 8.501
R1534 IOVSS.n1333 IOVSS.n1331 8.501
R1535 IOVSS.n1333 IOVSS.n1242 8.501
R1536 IOVSS.n1334 IOVSS.n1333 8.501
R1537 IOVSS.n1624 IOVSS.n1055 8.501
R1538 IOVSS.n1624 IOVSS.n1056 8.501
R1539 IOVSS.n1624 IOVSS.n1057 8.501
R1540 IOVSS.n1624 IOVSS.n1058 8.501
R1541 IOVSS.n1624 IOVSS.n1059 8.501
R1542 IOVSS.n1625 IOVSS.n1624 8.501
R1543 IOVSS.n1620 IOVSS.n1045 8.501
R1544 IOVSS.n1620 IOVSS.n1098 8.501
R1545 IOVSS.n1620 IOVSS.n1086 8.501
R1546 IOVSS.n1620 IOVSS.n1085 8.501
R1547 IOVSS.n1620 IOVSS.n1084 8.501
R1548 IOVSS.n1620 IOVSS.n1083 8.501
R1549 IOVSS.n1636 IOVSS.n1025 8.501
R1550 IOVSS.n1637 IOVSS.n1636 8.501
R1551 IOVSS.n1636 IOVSS.n1029 8.501
R1552 IOVSS.n1634 IOVSS.n1032 8.501
R1553 IOVSS.n1194 IOVSS.n1101 8.501
R1554 IOVSS.n1196 IOVSS.n1195 8.501
R1555 IOVSS.n821 IOVSS.n724 8.501
R1556 IOVSS.n819 IOVSS.n724 8.501
R1557 IOVSS.n817 IOVSS.n724 8.501
R1558 IOVSS.n815 IOVSS.n724 8.501
R1559 IOVSS.n813 IOVSS.n724 8.501
R1560 IOVSS.n811 IOVSS.n724 8.501
R1561 IOVSS.n1731 IOVSS.n724 8.501
R1562 IOVSS.n1752 IOVSS.n722 8.501
R1563 IOVSS.n1752 IOVSS.n721 8.501
R1564 IOVSS.n1752 IOVSS.n720 8.501
R1565 IOVSS.n1752 IOVSS.n719 8.501
R1566 IOVSS.n1752 IOVSS.n718 8.501
R1567 IOVSS.n1752 IOVSS.n717 8.501
R1568 IOVSS.n1752 IOVSS.n716 8.501
R1569 IOVSS.n1752 IOVSS.n715 8.501
R1570 IOVSS.n1752 IOVSS.n714 8.501
R1571 IOVSS.n1752 IOVSS.n713 8.501
R1572 IOVSS.n1752 IOVSS.n712 8.501
R1573 IOVSS.n1752 IOVSS.n692 8.501
R1574 IOVSS.n1753 IOVSS.n1752 8.501
R1575 IOVSS.n1752 IOVSS.n711 8.501
R1576 IOVSS.n1752 IOVSS.n710 8.501
R1577 IOVSS.n1752 IOVSS.n709 8.501
R1578 IOVSS.n1752 IOVSS.n708 8.501
R1579 IOVSS.n1752 IOVSS.n707 8.501
R1580 IOVSS.n1752 IOVSS.n706 8.501
R1581 IOVSS.n1752 IOVSS.n705 8.501
R1582 IOVSS.n1752 IOVSS.n704 8.501
R1583 IOVSS.n1752 IOVSS.n703 8.501
R1584 IOVSS.n1752 IOVSS.n702 8.501
R1585 IOVSS.n1752 IOVSS.n701 8.501
R1586 IOVSS.n1752 IOVSS.n700 8.501
R1587 IOVSS.n1752 IOVSS.n699 8.501
R1588 IOVSS.n1752 IOVSS.n698 8.501
R1589 IOVSS.n1752 IOVSS.n697 8.501
R1590 IOVSS.n1752 IOVSS.n696 8.501
R1591 IOVSS.n1752 IOVSS.n695 8.501
R1592 IOVSS.n1746 IOVSS.n787 8.501
R1593 IOVSS.n1747 IOVSS.n1746 8.501
R1594 IOVSS.n1746 IOVSS.n726 8.501
R1595 IOVSS.n1021 IOVSS.n882 8.501
R1596 IOVSS.n1021 IOVSS.n883 8.501
R1597 IOVSS.n1021 IOVSS.n884 8.501
R1598 IOVSS.n1021 IOVSS.n885 8.501
R1599 IOVSS.n1021 IOVSS.n886 8.501
R1600 IOVSS.n1021 IOVSS.n887 8.501
R1601 IOVSS.n1021 IOVSS.n888 8.501
R1602 IOVSS.n1021 IOVSS.n889 8.501
R1603 IOVSS.n1021 IOVSS.n890 8.501
R1604 IOVSS.n1021 IOVSS.n891 8.501
R1605 IOVSS.n1015 IOVSS.n910 8.501
R1606 IOVSS.n1015 IOVSS.n909 8.501
R1607 IOVSS.n1015 IOVSS.n908 8.501
R1608 IOVSS.n1015 IOVSS.n907 8.501
R1609 IOVSS.n1015 IOVSS.n906 8.501
R1610 IOVSS.n1015 IOVSS.n905 8.501
R1611 IOVSS.n1015 IOVSS.n904 8.501
R1612 IOVSS.n1015 IOVSS.n903 8.501
R1613 IOVSS.n1014 IOVSS.n105 8.501
R1614 IOVSS.n1014 IOVSS.n912 8.501
R1615 IOVSS.n1014 IOVSS.n913 8.501
R1616 IOVSS.n1014 IOVSS.n914 8.501
R1617 IOVSS.n1014 IOVSS.n915 8.501
R1618 IOVSS.n1014 IOVSS.n916 8.501
R1619 IOVSS.n1014 IOVSS.n917 8.501
R1620 IOVSS.n1014 IOVSS.n918 8.501
R1621 IOVSS.n1014 IOVSS.n919 8.501
R1622 IOVSS.n1014 IOVSS.n920 8.501
R1623 IOVSS.n1014 IOVSS.n921 8.501
R1624 IOVSS.n1014 IOVSS.n922 8.501
R1625 IOVSS.n1014 IOVSS.n1013 8.501
R1626 IOVSS.n1014 IOVSS.n211 8.501
R1627 IOVSS.n2088 IOVSS.n102 8.501
R1628 IOVSS.n2088 IOVSS.n101 8.501
R1629 IOVSS.n2088 IOVSS.n100 8.501
R1630 IOVSS.n2088 IOVSS.n99 8.501
R1631 IOVSS.n2088 IOVSS.n98 8.501
R1632 IOVSS.n2088 IOVSS.n97 8.501
R1633 IOVSS.n2088 IOVSS.n96 8.501
R1634 IOVSS.n2088 IOVSS.n95 8.501
R1635 IOVSS.n2088 IOVSS.n94 8.501
R1636 IOVSS.n2088 IOVSS.n93 8.501
R1637 IOVSS.n2088 IOVSS.n92 8.501
R1638 IOVSS.n2088 IOVSS.n91 8.501
R1639 IOVSS.n2088 IOVSS.n90 8.501
R1640 IOVSS.n2181 IOVSS.n2090 8.501
R1641 IOVSS.n2181 IOVSS.n2091 8.501
R1642 IOVSS.n2181 IOVSS.n2092 8.501
R1643 IOVSS.n2181 IOVSS.n2093 8.501
R1644 IOVSS.n2181 IOVSS.n2094 8.501
R1645 IOVSS.n2181 IOVSS.n2095 8.501
R1646 IOVSS.n2181 IOVSS.n2096 8.501
R1647 IOVSS.n2181 IOVSS.n2097 8.501
R1648 IOVSS.n2181 IOVSS.n2098 8.501
R1649 IOVSS.n2181 IOVSS.n2099 8.501
R1650 IOVSS.n2181 IOVSS.n2180 8.501
R1651 IOVSS.n2229 IOVSS.n35 8.501
R1652 IOVSS.n2229 IOVSS.n34 8.501
R1653 IOVSS.n2229 IOVSS.n15 8.501
R1654 IOVSS.n2230 IOVSS.n2229 8.501
R1655 IOVSS.n2229 IOVSS.n33 8.501
R1656 IOVSS.n2229 IOVSS.n32 8.501
R1657 IOVSS.n2229 IOVSS.n31 8.501
R1658 IOVSS.n2229 IOVSS.n30 8.501
R1659 IOVSS.n2229 IOVSS.n29 8.501
R1660 IOVSS.n2229 IOVSS.n28 8.501
R1661 IOVSS.n2229 IOVSS.n27 8.501
R1662 IOVSS.n2229 IOVSS.n26 8.501
R1663 IOVSS.n2229 IOVSS.n25 8.501
R1664 IOVSS.n2229 IOVSS.n24 8.501
R1665 IOVSS.n2229 IOVSS.n23 8.501
R1666 IOVSS.n2229 IOVSS.n22 8.501
R1667 IOVSS.n2229 IOVSS.n21 8.501
R1668 IOVSS.n2229 IOVSS.n20 8.501
R1669 IOVSS.n2229 IOVSS.n19 8.501
R1670 IOVSS.n2082 IOVSS.n0 8.501
R1671 IOVSS.n1761 IOVSS.n634 8.5005
R1672 IOVSS.n1761 IOVSS.n633 8.5005
R1673 IOVSS.n1761 IOVSS.n636 8.5005
R1674 IOVSS.n1761 IOVSS.n631 8.5005
R1675 IOVSS.n1761 IOVSS.n638 8.5005
R1676 IOVSS.n1761 IOVSS.n629 8.5005
R1677 IOVSS.n1761 IOVSS.n640 8.5005
R1678 IOVSS.n1761 IOVSS.n627 8.5005
R1679 IOVSS.n1761 IOVSS.n642 8.5005
R1680 IOVSS.n1761 IOVSS.n625 8.5005
R1681 IOVSS.n1761 IOVSS.n644 8.5005
R1682 IOVSS.n1761 IOVSS.n623 8.5005
R1683 IOVSS.n1761 IOVSS.n646 8.5005
R1684 IOVSS.n1761 IOVSS.n621 8.5005
R1685 IOVSS.n1761 IOVSS.n648 8.5005
R1686 IOVSS.n1761 IOVSS.n619 8.5005
R1687 IOVSS.n1761 IOVSS.n650 8.5005
R1688 IOVSS.n1761 IOVSS.n617 8.5005
R1689 IOVSS.n1885 IOVSS.n229 8.5005
R1690 IOVSS.n1890 IOVSS.n229 8.5005
R1691 IOVSS.n474 IOVSS.n229 8.5005
R1692 IOVSS.n470 IOVSS.n229 8.5005
R1693 IOVSS.n466 IOVSS.n229 8.5005
R1694 IOVSS.n462 IOVSS.n229 8.5005
R1695 IOVSS.n458 IOVSS.n229 8.5005
R1696 IOVSS.n454 IOVSS.n229 8.5005
R1697 IOVSS.n450 IOVSS.n229 8.5005
R1698 IOVSS.n446 IOVSS.n229 8.5005
R1699 IOVSS.n440 IOVSS.n229 8.5005
R1700 IOVSS.n1801 IOVSS.n229 8.5005
R1701 IOVSS.n481 IOVSS.n229 8.5005
R1702 IOVSS.n476 IOVSS.n229 8.5005
R1703 IOVSS.n472 IOVSS.n229 8.5005
R1704 IOVSS.n468 IOVSS.n229 8.5005
R1705 IOVSS.n464 IOVSS.n229 8.5005
R1706 IOVSS.n460 IOVSS.n229 8.5005
R1707 IOVSS.n456 IOVSS.n229 8.5005
R1708 IOVSS.n452 IOVSS.n229 8.5005
R1709 IOVSS.n448 IOVSS.n229 8.5005
R1710 IOVSS.n444 IOVSS.n229 8.5005
R1711 IOVSS.n1722 IOVSS.n854 8.5005
R1712 IOVSS.n867 IOVSS.n865 8.5005
R1713 IOVSS.n867 IOVSS.n866 8.5005
R1714 IOVSS.n1477 IOVSS.n1335 8.5005
R1715 IOVSS.n1761 IOVSS.n652 8.5005
R1716 IOVSS.n1761 IOVSS.n615 8.5005
R1717 IOVSS.n1761 IOVSS.n654 8.5005
R1718 IOVSS.n1761 IOVSS.n613 8.5005
R1719 IOVSS.n1761 IOVSS.n656 8.5005
R1720 IOVSS.n1761 IOVSS.n612 8.5005
R1721 IOVSS.n1761 IOVSS.n657 8.5005
R1722 IOVSS.n1761 IOVSS.n611 8.5005
R1723 IOVSS.n1761 IOVSS.n659 8.5005
R1724 IOVSS.n1761 IOVSS.n609 8.5005
R1725 IOVSS.n87 IOVSS.n2 8.5005
R1726 IOVSS.n88 IOVSS.n2 8.5005
R1727 IOVSS.n2218 IOVSS.n2 8.5005
R1728 IOVSS.n2216 IOVSS.n2 8.5005
R1729 IOVSS.n2214 IOVSS.n2 8.5005
R1730 IOVSS.n2212 IOVSS.n2 8.5005
R1731 IOVSS.n2210 IOVSS.n2 8.5005
R1732 IOVSS.n2208 IOVSS.n2 8.5005
R1733 IOVSS.n2206 IOVSS.n2 8.5005
R1734 IOVSS.n2204 IOVSS.n2 8.5005
R1735 IOVSS.n2202 IOVSS.n2 8.5005
R1736 IOVSS.n2200 IOVSS.n2 8.5005
R1737 IOVSS.n2198 IOVSS.n2 8.5005
R1738 IOVSS.n2196 IOVSS.n2 8.5005
R1739 IOVSS.n2194 IOVSS.n2 8.5005
R1740 IOVSS.n2192 IOVSS.n2 8.5005
R1741 IOVSS.n2190 IOVSS.n2 8.5005
R1742 IOVSS.n2188 IOVSS.n2 8.5005
R1743 IOVSS.n2186 IOVSS.n2 8.5005
R1744 IOVSS.n2184 IOVSS.n2 8.5005
R1745 IOVSS.n2182 IOVSS.n2 8.5005
R1746 IOVSS.t90 IOVSS.n1338 8.49635
R1747 IOVSS.t90 IOVSS.n1339 8.49635
R1748 IOVSS.t90 IOVSS.n1340 8.49635
R1749 IOVSS.t90 IOVSS.n1341 8.49635
R1750 IOVSS.t90 IOVSS.n1342 8.49635
R1751 IOVSS.t90 IOVSS.n1343 8.49635
R1752 IOVSS.t90 IOVSS.n1344 8.49635
R1753 IOVSS.t90 IOVSS.n1345 8.49635
R1754 IOVSS.t90 IOVSS.n1346 8.49635
R1755 IOVSS.t90 IOVSS.n1347 8.49635
R1756 IOVSS.t90 IOVSS.n1348 8.49635
R1757 IOVSS.t90 IOVSS.n1349 8.49635
R1758 IOVSS.t90 IOVSS.n1350 8.49635
R1759 IOVSS.t90 IOVSS.n1352 8.49635
R1760 IOVSS.t90 IOVSS.n1353 8.49635
R1761 IOVSS.t90 IOVSS.n1354 8.49635
R1762 IOVSS.t90 IOVSS.n1375 8.49635
R1763 IOVSS.t89 IOVSS.n1357 8.49635
R1764 IOVSS.t89 IOVSS.n1358 8.49635
R1765 IOVSS.t89 IOVSS.n1359 8.49635
R1766 IOVSS.t89 IOVSS.n1360 8.49635
R1767 IOVSS.t89 IOVSS.n1362 8.49635
R1768 IOVSS.t89 IOVSS.n1363 8.49635
R1769 IOVSS.t89 IOVSS.n1364 8.49635
R1770 IOVSS.t89 IOVSS.n1365 8.49635
R1771 IOVSS.t89 IOVSS.n1367 8.49635
R1772 IOVSS.t89 IOVSS.n1368 8.49635
R1773 IOVSS.t89 IOVSS.n1369 8.49635
R1774 IOVSS.t89 IOVSS.n1370 8.49635
R1775 IOVSS.t89 IOVSS.n1371 8.49635
R1776 IOVSS.t89 IOVSS.n1372 8.49635
R1777 IOVSS.t89 IOVSS.n1373 8.49635
R1778 IOVSS.n1374 IOVSS.t89 8.49635
R1779 IOVSS.t89 IOVSS.n1336 8.49635
R1780 IOVSS.t101 IOVSS.n1410 8.49635
R1781 IOVSS.t101 IOVSS.n1411 8.49635
R1782 IOVSS.t101 IOVSS.n1412 8.49635
R1783 IOVSS.t101 IOVSS.n1413 8.49635
R1784 IOVSS.t101 IOVSS.n1414 8.49635
R1785 IOVSS.t101 IOVSS.n1415 8.49635
R1786 IOVSS.t101 IOVSS.n1416 8.49635
R1787 IOVSS.t101 IOVSS.n1417 8.49635
R1788 IOVSS.t101 IOVSS.n1418 8.49635
R1789 IOVSS.t101 IOVSS.n1419 8.49635
R1790 IOVSS.t101 IOVSS.n1420 8.49635
R1791 IOVSS.t101 IOVSS.n1421 8.49635
R1792 IOVSS.t101 IOVSS.n1422 8.49635
R1793 IOVSS.t101 IOVSS.n1424 8.49635
R1794 IOVSS.t101 IOVSS.n1425 8.49635
R1795 IOVSS.t101 IOVSS.n1426 8.49635
R1796 IOVSS.n1427 IOVSS.t101 8.49635
R1797 IOVSS.t100 IOVSS.n1391 8.49635
R1798 IOVSS.t100 IOVSS.n1392 8.49635
R1799 IOVSS.t100 IOVSS.n1393 8.49635
R1800 IOVSS.t100 IOVSS.n1394 8.49635
R1801 IOVSS.t100 IOVSS.n1396 8.49635
R1802 IOVSS.t100 IOVSS.n1397 8.49635
R1803 IOVSS.t100 IOVSS.n1398 8.49635
R1804 IOVSS.t100 IOVSS.n1399 8.49635
R1805 IOVSS.t100 IOVSS.n1401 8.49635
R1806 IOVSS.t100 IOVSS.n1402 8.49635
R1807 IOVSS.t100 IOVSS.n1403 8.49635
R1808 IOVSS.t100 IOVSS.n1404 8.49635
R1809 IOVSS.t100 IOVSS.n1405 8.49635
R1810 IOVSS.t100 IOVSS.n1406 8.49635
R1811 IOVSS.t100 IOVSS.n1407 8.49635
R1812 IOVSS.t100 IOVSS.n1408 8.49635
R1813 IOVSS.t100 IOVSS.n1428 8.49635
R1814 IOVSS.t90 IOVSS.n1351 8.49628
R1815 IOVSS.t90 IOVSS.n1337 8.49628
R1816 IOVSS.t89 IOVSS.n1361 8.49628
R1817 IOVSS.t89 IOVSS.n1366 8.49628
R1818 IOVSS.t101 IOVSS.n1423 8.49628
R1819 IOVSS.t101 IOVSS.n1390 8.49628
R1820 IOVSS.t100 IOVSS.n1395 8.49628
R1821 IOVSS.t100 IOVSS.n1400 8.49628
R1822 IOVSS.n951 IOVSS.n950 8.49485
R1823 IOVSS.n971 IOVSS.n970 8.49485
R1824 IOVSS.t55 IOVSS.n1662 8.49334
R1825 IOVSS.t55 IOVSS.n1667 8.49334
R1826 IOVSS.t57 IOVSS.n1665 8.49334
R1827 IOVSS.t57 IOVSS.n1660 8.49334
R1828 IOVSS.t59 IOVSS.n1659 8.49329
R1829 IOVSS.t59 IOVSS.n1672 8.49329
R1830 IOVSS.t61 IOVSS.n1670 8.49329
R1831 IOVSS.t61 IOVSS.n1657 8.49329
R1832 IOVSS.t55 IOVSS.n1661 8.49324
R1833 IOVSS.n1666 IOVSS.t57 8.49324
R1834 IOVSS.t59 IOVSS.n1658 8.49318
R1835 IOVSS.n1671 IOVSS.t61 8.49318
R1836 IOVSS.t69 IOVSS.n872 8.49304
R1837 IOVSS.n873 IOVSS.t69 8.49304
R1838 IOVSS.t68 IOVSS.n859 8.49304
R1839 IOVSS.t68 IOVSS.n874 8.49304
R1840 IOVSS.t80 IOVSS.n878 8.49304
R1841 IOVSS.n879 IOVSS.t80 8.49304
R1842 IOVSS.t79 IOVSS.n856 8.49304
R1843 IOVSS.t79 IOVSS.n880 8.49304
R1844 IOVSS.n187 IOVSS.n155 8.49295
R1845 IOVSS.n185 IOVSS.n156 8.49295
R1846 IOVSS.n183 IOVSS.n157 8.49295
R1847 IOVSS.n181 IOVSS.n158 8.49295
R1848 IOVSS.n176 IOVSS.n160 8.49295
R1849 IOVSS.n174 IOVSS.n161 8.49295
R1850 IOVSS.n172 IOVSS.n162 8.49295
R1851 IOVSS.t69 IOVSS.n858 8.49293
R1852 IOVSS.t68 IOVSS.n860 8.49293
R1853 IOVSS.t80 IOVSS.n855 8.49293
R1854 IOVSS.t79 IOVSS.n857 8.49293
R1855 IOVSS.t97 IOVSS.n667 8.49288
R1856 IOVSS.n668 IOVSS.t97 8.49288
R1857 IOVSS.t96 IOVSS.n664 8.49288
R1858 IOVSS.t96 IOVSS.n669 8.49288
R1859 IOVSS.t115 IOVSS.n673 8.49288
R1860 IOVSS.n674 IOVSS.t115 8.49288
R1861 IOVSS.t114 IOVSS.n661 8.49288
R1862 IOVSS.t114 IOVSS.n675 8.49288
R1863 IOVSS.t97 IOVSS.n663 8.49277
R1864 IOVSS.t96 IOVSS.n665 8.49277
R1865 IOVSS.t115 IOVSS.n660 8.49277
R1866 IOVSS.t114 IOVSS.n662 8.49277
R1867 IOVSS.n1381 IOVSS.n1380 8.49139
R1868 IOVSS.n2036 IOVSS.n233 8.48727
R1869 IOVSS.n1808 IOVSS.n229 8.48653
R1870 IOVSS.n1805 IOVSS.n229 8.48653
R1871 IOVSS.n1802 IOVSS.n229 8.48653
R1872 IOVSS.n1799 IOVSS.n229 8.48653
R1873 IOVSS.n1796 IOVSS.n229 8.48653
R1874 IOVSS.n1793 IOVSS.n229 8.48653
R1875 IOVSS.n1789 IOVSS.n229 8.48653
R1876 IOVSS.n1787 IOVSS.n229 8.48653
R1877 IOVSS.n1894 IOVSS.n229 8.48653
R1878 IOVSS.n2014 IOVSS.n1809 8.48653
R1879 IOVSS.n2014 IOVSS.n1806 8.48653
R1880 IOVSS.n2014 IOVSS.n1803 8.48653
R1881 IOVSS.n2014 IOVSS.n1800 8.48653
R1882 IOVSS.n2014 IOVSS.n1797 8.48653
R1883 IOVSS.n2014 IOVSS.n1794 8.48653
R1884 IOVSS.n2014 IOVSS.n1790 8.48653
R1885 IOVSS.n2014 IOVSS.n1788 8.48653
R1886 IOVSS.n2014 IOVSS.n1785 8.48653
R1887 IOVSS.n2121 IOVSS.n2 8.48653
R1888 IOVSS.n2123 IOVSS.n2 8.48653
R1889 IOVSS.n2125 IOVSS.n2 8.48653
R1890 IOVSS.n2127 IOVSS.n2 8.48653
R1891 IOVSS.n2129 IOVSS.n2 8.48653
R1892 IOVSS.n2131 IOVSS.n2 8.48653
R1893 IOVSS.n2133 IOVSS.n2 8.48653
R1894 IOVSS.n2135 IOVSS.n2 8.48653
R1895 IOVSS.n2137 IOVSS.n2 8.48653
R1896 IOVSS.n2122 IOVSS.n7 8.48653
R1897 IOVSS.n2124 IOVSS.n7 8.48653
R1898 IOVSS.n2126 IOVSS.n7 8.48653
R1899 IOVSS.n2128 IOVSS.n7 8.48653
R1900 IOVSS.n2130 IOVSS.n7 8.48653
R1901 IOVSS.n2132 IOVSS.n7 8.48653
R1902 IOVSS.n2134 IOVSS.n7 8.48653
R1903 IOVSS.n2136 IOVSS.n7 8.48653
R1904 IOVSS.n350 IOVSS.n305 8.48642
R1905 IOVSS.n322 IOVSS.n303 8.48642
R1906 IOVSS.n321 IOVSS.n301 8.48642
R1907 IOVSS.n319 IOVSS.n299 8.48642
R1908 IOVSS.n315 IOVSS.n295 8.48642
R1909 IOVSS.n313 IOVSS.n293 8.48642
R1910 IOVSS.n311 IOVSS.n291 8.48642
R1911 IOVSS.n350 IOVSS.n290 8.48642
R1912 IOVSS.n1019 IOVSS.n1018 8.48642
R1913 IOVSS.n956 IOVSS.n901 8.48642
R1914 IOVSS.n1034 IOVSS.n1033 8.48565
R1915 IOVSS.n317 IOVSS.n297 8.48385
R1916 IOVSS.n1459 IOVSS.n1458 8.48134
R1917 IOVSS.n1464 IOVSS.n1463 8.48088
R1918 IOVSS.n1011 IOVSS.n1010 8.47997
R1919 IOVSS.n189 IOVSS.n154 8.47771
R1920 IOVSS.n2035 IOVSS.n234 8.46995
R1921 IOVSS.n2034 IOVSS.n235 8.46995
R1922 IOVSS.n2033 IOVSS.n236 8.46995
R1923 IOVSS.n2031 IOVSS.n238 8.46995
R1924 IOVSS.n2030 IOVSS.n239 8.46995
R1925 IOVSS.n2029 IOVSS.n240 8.46995
R1926 IOVSS.n2010 IOVSS.n1997 8.46995
R1927 IOVSS.n2009 IOVSS.n1998 8.46995
R1928 IOVSS.n2008 IOVSS.n1999 8.46995
R1929 IOVSS.n2007 IOVSS.n2000 8.46995
R1930 IOVSS.n2006 IOVSS.n2001 8.46995
R1931 IOVSS.n2005 IOVSS.n2002 8.46995
R1932 IOVSS.n2004 IOVSS.n2003 8.46995
R1933 IOVSS.n404 IOVSS.n231 8.46995
R1934 IOVSS.n1902 IOVSS.n229 8.46995
R1935 IOVSS.n1931 IOVSS.n441 8.46995
R1936 IOVSS.n1933 IOVSS.n1932 8.46995
R1937 IOVSS.n1935 IOVSS.n1934 8.46995
R1938 IOVSS.n1937 IOVSS.n1936 8.46995
R1939 IOVSS.n1939 IOVSS.n1938 8.46995
R1940 IOVSS.n1941 IOVSS.n1940 8.46995
R1941 IOVSS.n1943 IOVSS.n1942 8.46995
R1942 IOVSS.n1945 IOVSS.n1944 8.46995
R1943 IOVSS.n1947 IOVSS.n1946 8.46995
R1944 IOVSS.n1949 IOVSS.n1948 8.46995
R1945 IOVSS.n1951 IOVSS.n1950 8.46995
R1946 IOVSS.n1953 IOVSS.n1952 8.46995
R1947 IOVSS.n1955 IOVSS.n1954 8.46995
R1948 IOVSS.n1957 IOVSS.n1956 8.46995
R1949 IOVSS.n1959 IOVSS.n1958 8.46995
R1950 IOVSS.n1961 IOVSS.n1960 8.46995
R1951 IOVSS.n1966 IOVSS.n1965 8.46995
R1952 IOVSS.n1968 IOVSS.n1967 8.46995
R1953 IOVSS.n1970 IOVSS.n1969 8.46995
R1954 IOVSS.n1972 IOVSS.n1971 8.46995
R1955 IOVSS.n1974 IOVSS.n1973 8.46995
R1956 IOVSS.n1976 IOVSS.n1975 8.46995
R1957 IOVSS.n1978 IOVSS.n1977 8.46995
R1958 IOVSS.n1980 IOVSS.n1979 8.46995
R1959 IOVSS.n1982 IOVSS.n1981 8.46995
R1960 IOVSS.n1984 IOVSS.n1983 8.46995
R1961 IOVSS.n1986 IOVSS.n1985 8.46995
R1962 IOVSS.n1988 IOVSS.n1987 8.46995
R1963 IOVSS.n1990 IOVSS.n1989 8.46995
R1964 IOVSS.n1992 IOVSS.n1991 8.46995
R1965 IOVSS.n1994 IOVSS.n1993 8.46995
R1966 IOVSS.n1996 IOVSS.n1995 8.46995
R1967 IOVSS.n1879 IOVSS.n1810 8.46995
R1968 IOVSS.n1878 IOVSS.n1811 8.46995
R1969 IOVSS.n1877 IOVSS.n1812 8.46995
R1970 IOVSS.n1876 IOVSS.n1813 8.46995
R1971 IOVSS.n1875 IOVSS.n1814 8.46995
R1972 IOVSS.n1874 IOVSS.n1815 8.46995
R1973 IOVSS.n1873 IOVSS.n1816 8.46995
R1974 IOVSS.n1872 IOVSS.n1817 8.46995
R1975 IOVSS.n1871 IOVSS.n1818 8.46995
R1976 IOVSS.n1870 IOVSS.n1819 8.46995
R1977 IOVSS.n1869 IOVSS.n1820 8.46995
R1978 IOVSS.n1868 IOVSS.n1821 8.46995
R1979 IOVSS.n1867 IOVSS.n1822 8.46995
R1980 IOVSS.n1866 IOVSS.n1823 8.46995
R1981 IOVSS.n1865 IOVSS.n1824 8.46995
R1982 IOVSS.n1864 IOVSS.n1825 8.46995
R1983 IOVSS.n1860 IOVSS.n1830 8.46995
R1984 IOVSS.n1859 IOVSS.n1831 8.46995
R1985 IOVSS.n1858 IOVSS.n1832 8.46995
R1986 IOVSS.n1857 IOVSS.n1833 8.46995
R1987 IOVSS.n1856 IOVSS.n1834 8.46995
R1988 IOVSS.n1855 IOVSS.n1835 8.46995
R1989 IOVSS.n1854 IOVSS.n1836 8.46995
R1990 IOVSS.n1853 IOVSS.n1837 8.46995
R1991 IOVSS.n1852 IOVSS.n1838 8.46995
R1992 IOVSS.n1851 IOVSS.n1839 8.46995
R1993 IOVSS.n1850 IOVSS.n1840 8.46995
R1994 IOVSS.n1849 IOVSS.n1841 8.46995
R1995 IOVSS.n1848 IOVSS.n1842 8.46995
R1996 IOVSS.n1847 IOVSS.n1843 8.46995
R1997 IOVSS.n1846 IOVSS.n1844 8.46995
R1998 IOVSS.n1845 IOVSS.n489 8.46995
R1999 IOVSS.n1721 IOVSS.n1720 8.46995
R2000 IOVSS.n1589 IOVSS.n1207 8.46995
R2001 IOVSS.n1588 IOVSS.n1208 8.46995
R2002 IOVSS.n1587 IOVSS.n1586 8.46995
R2003 IOVSS.n1383 IOVSS.n1379 8.46995
R2004 IOVSS.n1499 IOVSS.n1219 8.46995
R2005 IOVSS.n1498 IOVSS.n1220 8.46995
R2006 IOVSS.n1497 IOVSS.n1221 8.46995
R2007 IOVSS.n1496 IOVSS.n1222 8.46995
R2008 IOVSS.n1495 IOVSS.n1223 8.46995
R2009 IOVSS.n1494 IOVSS.n1224 8.46995
R2010 IOVSS.n1493 IOVSS.n1225 8.46995
R2011 IOVSS.n1492 IOVSS.n1226 8.46995
R2012 IOVSS.n1491 IOVSS.n1227 8.46995
R2013 IOVSS.n1490 IOVSS.n1228 8.46995
R2014 IOVSS.n1489 IOVSS.n1229 8.46995
R2015 IOVSS.n1487 IOVSS.n1231 8.46995
R2016 IOVSS.n1486 IOVSS.n1232 8.46995
R2017 IOVSS.n1485 IOVSS.n1233 8.46995
R2018 IOVSS.n1484 IOVSS.n1234 8.46995
R2019 IOVSS.n1483 IOVSS.n1235 8.46995
R2020 IOVSS.n1482 IOVSS.n1236 8.46995
R2021 IOVSS.n1481 IOVSS.n1237 8.46995
R2022 IOVSS.n1480 IOVSS.n1238 8.46995
R2023 IOVSS.n1479 IOVSS.n1239 8.46995
R2024 IOVSS.n1478 IOVSS.n1240 8.46995
R2025 IOVSS.n1071 IOVSS.n1061 8.46995
R2026 IOVSS.n1070 IOVSS.n1062 8.46995
R2027 IOVSS.n1069 IOVSS.n1063 8.46995
R2028 IOVSS.n1068 IOVSS.n1064 8.46995
R2029 IOVSS.n1067 IOVSS.n1065 8.46995
R2030 IOVSS.n1066 IOVSS.n1053 8.46995
R2031 IOVSS.n1097 IOVSS.n1096 8.46995
R2032 IOVSS.n1095 IOVSS.n1087 8.46995
R2033 IOVSS.n1094 IOVSS.n1088 8.46995
R2034 IOVSS.n1093 IOVSS.n1089 8.46995
R2035 IOVSS.n1092 IOVSS.n1090 8.46995
R2036 IOVSS.n1091 IOVSS.n1081 8.46995
R2037 IOVSS.n1635 IOVSS.n1030 8.46995
R2038 IOVSS.n1739 IOVSS.n804 8.46995
R2039 IOVSS.n1738 IOVSS.n805 8.46995
R2040 IOVSS.n1737 IOVSS.n806 8.46995
R2041 IOVSS.n1736 IOVSS.n807 8.46995
R2042 IOVSS.n1735 IOVSS.n808 8.46995
R2043 IOVSS.n693 IOVSS.n689 8.46995
R2044 IOVSS.n745 IOVSS.n744 8.46995
R2045 IOVSS.n747 IOVSS.n746 8.46995
R2046 IOVSS.n749 IOVSS.n748 8.46995
R2047 IOVSS.n751 IOVSS.n750 8.46995
R2048 IOVSS.n753 IOVSS.n752 8.46995
R2049 IOVSS.n755 IOVSS.n754 8.46995
R2050 IOVSS.n757 IOVSS.n756 8.46995
R2051 IOVSS.n759 IOVSS.n758 8.46995
R2052 IOVSS.n761 IOVSS.n760 8.46995
R2053 IOVSS.n763 IOVSS.n762 8.46995
R2054 IOVSS.n765 IOVSS.n764 8.46995
R2055 IOVSS.n767 IOVSS.n766 8.46995
R2056 IOVSS.n769 IOVSS.n768 8.46995
R2057 IOVSS.n771 IOVSS.n770 8.46995
R2058 IOVSS.n773 IOVSS.n772 8.46995
R2059 IOVSS.n775 IOVSS.n774 8.46995
R2060 IOVSS.n776 IOVSS.n725 8.46995
R2061 IOVSS.n924 IOVSS.n893 8.46995
R2062 IOVSS.n926 IOVSS.n925 8.46995
R2063 IOVSS.n928 IOVSS.n927 8.46995
R2064 IOVSS.n930 IOVSS.n929 8.46995
R2065 IOVSS.n934 IOVSS.n933 8.46995
R2066 IOVSS.n936 IOVSS.n935 8.46995
R2067 IOVSS.n938 IOVSS.n937 8.46995
R2068 IOVSS.n940 IOVSS.n939 8.46995
R2069 IOVSS.n942 IOVSS.n941 8.46995
R2070 IOVSS.n1012 IOVSS.n213 8.46995
R2071 IOVSS.n190 IOVSS.n153 8.46995
R2072 IOVSS.n165 IOVSS.n103 8.46995
R2073 IOVSS.n2101 IOVSS.n2100 8.46995
R2074 IOVSS.n2103 IOVSS.n2102 8.46995
R2075 IOVSS.n2105 IOVSS.n2104 8.46995
R2076 IOVSS.n2107 IOVSS.n2106 8.46995
R2077 IOVSS.n2109 IOVSS.n2108 8.46995
R2078 IOVSS.n2111 IOVSS.n2110 8.46995
R2079 IOVSS.n2113 IOVSS.n2112 8.46995
R2080 IOVSS.n2115 IOVSS.n2114 8.46995
R2081 IOVSS.n2117 IOVSS.n2116 8.46995
R2082 IOVSS.n2119 IOVSS.n2118 8.46995
R2083 IOVSS.n2179 IOVSS.n2178 8.46995
R2084 IOVSS.n2238 IOVSS.n2 8.46995
R2085 IOVSS.n2235 IOVSS.n8 8.46995
R2086 IOVSS.n2234 IOVSS.n9 8.46995
R2087 IOVSS.n2233 IOVSS.n10 8.46995
R2088 IOVSS.n48 IOVSS.n17 8.46995
R2089 IOVSS.n50 IOVSS.n49 8.46995
R2090 IOVSS.n52 IOVSS.n51 8.46995
R2091 IOVSS.n54 IOVSS.n53 8.46995
R2092 IOVSS.n56 IOVSS.n55 8.46995
R2093 IOVSS.n58 IOVSS.n57 8.46995
R2094 IOVSS.n60 IOVSS.n59 8.46995
R2095 IOVSS.n62 IOVSS.n61 8.46995
R2096 IOVSS.n64 IOVSS.n63 8.46995
R2097 IOVSS.n66 IOVSS.n65 8.46995
R2098 IOVSS.n68 IOVSS.n67 8.46995
R2099 IOVSS.n70 IOVSS.n69 8.46995
R2100 IOVSS.n72 IOVSS.n71 8.46995
R2101 IOVSS.n74 IOVSS.n73 8.46995
R2102 IOVSS.n76 IOVSS.n75 8.46995
R2103 IOVSS.n77 IOVSS.n38 8.46995
R2104 IOVSS.n2032 IOVSS.n237 8.46449
R2105 IOVSS.n1488 IOVSS.n1230 8.46267
R2106 IOVSS.n932 IOVSS.n931 8.44997
R2107 IOVSS.n1206 IOVSS.n1099 8.44296
R2108 IOVSS.n1714 IOVSS.n566 8.35123
R2109 IOVSS.n1261 IOVSS.n1260 8.18545
R2110 IOVSS.n1503 IOVSS.n1112 8.1721
R2111 IOVSS.t129 IOVSS.n1125 8.1721
R2112 IOVSS.n1187 IOVSS.t133 8.1721
R2113 IOVSS.n138 IOVSS.n136 8.11677
R2114 IOVSS.n2073 IOVSS.t1 8.05659
R2115 IOVSS.n2222 IOVSS.n2221 8.05659
R2116 IOVSS.n1502 IOVSS.n1211 8.05278
R2117 IOVSS.n1332 IOVSS.n1215 8.05278
R2118 IOVSS.n999 IOVSS.n896 8.0306
R2119 IOVSS.n1015 IOVSS.n902 8.0306
R2120 IOVSS.n2071 IOVSS.n109 8.0306
R2121 IOVSS.n2076 IOVSS.n114 8.0306
R2122 IOVSS.n193 IOVSS.n123 8.0306
R2123 IOVSS.n209 IOVSS.n130 8.0306
R2124 IOVSS.n202 IOVSS.n135 8.0306
R2125 IOVSS.n208 IOVSS.n141 8.0306
R2126 IOVSS.n206 IOVSS.n146 8.0306
R2127 IOVSS.n192 IOVSS.n151 8.0306
R2128 IOVSS.n2085 IOVSS.n89 8.0306
R2129 IOVSS.n87 IOVSS.n86 8.0306
R2130 IOVSS.n895 IOVSS.n892 8.0306
R2131 IOVSS.n1000 IOVSS.n899 8.0306
R2132 IOVSS.n205 IOVSS.n146 8.0306
R2133 IOVSS.n2078 IOVSS.n117 8.0306
R2134 IOVSS.n2073 IOVSS.n112 8.0306
R2135 IOVSS.n1014 IOVSS.n106 8.0306
R2136 IOVSS.n203 IOVSS.n139 8.0306
R2137 IOVSS.n200 IOVSS.n132 8.0306
R2138 IOVSS.n2080 IOVSS.n119 8.0306
R2139 IOVSS.n195 IOVSS.n126 8.0306
R2140 IOVSS.n230 IOVSS.t106 7.83005
R2141 IOVSS.n3 IOVSS.t116 7.83005
R2142 IOVSS.n228 IOVSS.t81 7.82317
R2143 IOVSS.n4 IOVSS.t102 7.82317
R2144 IOVSS.n1161 IOVSS.n1160 7.66138
R2145 IOVSS.n1161 IOVSS.n1048 7.66138
R2146 IOVSS.n1163 IOVSS.n1162 7.66138
R2147 IOVSS.n1165 IOVSS.n1164 7.66138
R2148 IOVSS.n1165 IOVSS.n1047 7.66138
R2149 IOVSS.n1168 IOVSS.n1167 7.66138
R2150 IOVSS.n1168 IOVSS.n1042 7.66138
R2151 IOVSS.n1170 IOVSS.n1169 7.66138
R2152 IOVSS.n1170 IOVSS.n1046 7.66138
R2153 IOVSS.n1172 IOVSS.n1171 7.66138
R2154 IOVSS.n1122 IOVSS.n1082 7.66138
R2155 IOVSS.n1620 IOVSS.n1082 7.66138
R2156 IOVSS.n1175 IOVSS.n1174 7.66138
R2157 IOVSS.n1178 IOVSS.n1177 7.66138
R2158 IOVSS.n1180 IOVSS.n1179 7.66138
R2159 IOVSS.n1182 IOVSS.n1181 7.66138
R2160 IOVSS.n1184 IOVSS.n1183 7.66138
R2161 IOVSS.n1187 IOVSS.n1186 7.66138
R2162 IOVSS.n1189 IOVSS.n1188 7.66138
R2163 IOVSS.n1191 IOVSS.n1190 7.66138
R2164 IOVSS.n1195 IOVSS.n1192 7.66138
R2165 IOVSS.n1193 IOVSS.n1130 7.66138
R2166 IOVSS.n1616 IOVSS.n1615 7.66138
R2167 IOVSS.n876 IOVSS.t67 7.49359
R2168 IOVSS.n671 IOVSS.t94 7.49344
R2169 IOVSS.n2021 IOVSS.n440 7.33472
R2170 IOVSS.n444 IOVSS.n443 7.33472
R2171 IOVSS.n446 IOVSS.n445 7.33472
R2172 IOVSS.n448 IOVSS.n447 7.33472
R2173 IOVSS.n450 IOVSS.n449 7.33472
R2174 IOVSS.n452 IOVSS.n451 7.33472
R2175 IOVSS.n456 IOVSS.n455 7.33472
R2176 IOVSS.n458 IOVSS.n457 7.33472
R2177 IOVSS.n460 IOVSS.n459 7.33472
R2178 IOVSS.n462 IOVSS.n461 7.33472
R2179 IOVSS.n464 IOVSS.n463 7.33472
R2180 IOVSS.n466 IOVSS.n465 7.33472
R2181 IOVSS.n468 IOVSS.n467 7.33472
R2182 IOVSS.n470 IOVSS.n469 7.33472
R2183 IOVSS.n472 IOVSS.n471 7.33472
R2184 IOVSS.n474 IOVSS.n473 7.33472
R2185 IOVSS.n476 IOVSS.n475 7.33472
R2186 IOVSS.t161 IOVSS.n2210 7.16147
R2187 IOVSS.t41 IOVSS.n1040 7.15065
R2188 IOVSS.n1503 IOVSS.t45 6.7252
R2189 IOVSS.n899 IOVSS.t230 6.71391
R2190 IOVSS.n1262 IOVSS.n1261 6.65533
R2191 IOVSS.n1136 IOVSS.n1135 6.63993
R2192 IOVSS.n1115 IOVSS.n1060 6.63993
R2193 IOVSS.n1148 IOVSS.n1147 6.63993
R2194 IOVSS.n1150 IOVSS.n1149 6.63993
R2195 IOVSS.n1152 IOVSS.n1151 6.63993
R2196 IOVSS.n1155 IOVSS.n1154 6.63993
R2197 IOVSS.n1157 IOVSS.n1156 6.63993
R2198 IOVSS.n1159 IOVSS.n1158 6.63993
R2199 IOVSS.n1108 IOVSS.n1048 6.63993
R2200 IOVSS.n1120 IOVSS.n1041 6.63993
R2201 IOVSS.n1107 IOVSS.n1047 6.63993
R2202 IOVSS.n1121 IOVSS.n1042 6.63993
R2203 IOVSS.n1106 IOVSS.n1046 6.63993
R2204 IOVSS.n1123 IOVSS.n1044 6.63993
R2205 IOVSS.n1620 IOVSS.n1619 6.63993
R2206 IOVSS.n1892 IOVSS.n479 6.44976
R2207 IOVSS.n1890 IOVSS.n480 6.44976
R2208 IOVSS.n1889 IOVSS.n483 6.44976
R2209 IOVSS.n1887 IOVSS.n484 6.44976
R2210 IOVSS.n1885 IOVSS.n485 6.44976
R2211 IOVSS.n1884 IOVSS.n486 6.44976
R2212 IOVSS.n1882 IOVSS.n487 6.44976
R2213 IOVSS.n2015 IOVSS.n488 6.44976
R2214 IOVSS.n1807 IOVSS.n488 6.44976
R2215 IOVSS.n1804 IOVSS.n487 6.44976
R2216 IOVSS.n1801 IOVSS.n486 6.44976
R2217 IOVSS.n1798 IOVSS.n485 6.44976
R2218 IOVSS.n1795 IOVSS.n484 6.44976
R2219 IOVSS.n1792 IOVSS.n483 6.44976
R2220 IOVSS.n1786 IOVSS.n480 6.44976
R2221 IOVSS.n1784 IOVSS.n479 6.44976
R2222 IOVSS.n1728 IOVSS.n1727 6.3805
R2223 IOVSS.t127 IOVSS.n1039 6.1292
R2224 IOVSS.n1178 IOVSS.t129 6.1292
R2225 IOVSS.t133 IOVSS.n1127 6.1292
R2226 IOVSS.n454 IOVSS.t110 6.11235
R2227 IOVSS.n1604 IOVSS.t130 6.07305
R2228 IOVSS.n1603 IOVSS.t132 6.07305
R2229 IOVSS.n1602 IOVSS.t136 6.07305
R2230 IOVSS.n1601 IOVSS.t138 5.99743
R2231 IOVSS.n1605 IOVSS.t134 5.87368
R2232 IOVSS.n2016 IOVSS.n2015 5.86329
R2233 IOVSS.n1650 IOVSS.n681 5.6837
R2234 IOVSS.n1675 IOVSS.n533 5.6829
R2235 IOVSS.n248 IOVSS.n247 5.66778
R2236 IOVSS.n339 IOVSS.n310 5.66778
R2237 IOVSS.n2025 IOVSS.n395 5.66778
R2238 IOVSS.n2023 IOVSS.n406 5.66778
R2239 IOVSS.n1718 IOVSS.n607 5.66778
R2240 IOVSS.n1718 IOVSS.n1644 5.66778
R2241 IOVSS.n1769 IOVSS.n529 5.66778
R2242 IOVSS.n1584 IOVSS.n1113 5.66778
R2243 IOVSS.n1581 IOVSS.n1580 5.66778
R2244 IOVSS.n1461 IOVSS.n1212 5.66778
R2245 IOVSS.n1461 IOVSS.n1460 5.66778
R2246 IOVSS.n1015 IOVSS.n911 5.66778
R2247 IOVSS.n2181 IOVSS.n45 5.66778
R2248 IOVSS.n2229 IOVSS.n36 5.66778
R2249 IOVSS.n340 IOVSS.n339 5.66767
R2250 IOVSS.n338 IOVSS.n250 5.66767
R2251 IOVSS.n2026 IOVSS.n2025 5.66767
R2252 IOVSS.n1674 IOVSS.n572 5.66767
R2253 IOVSS.n2021 IOVSS.n2020 5.66767
R2254 IOVSS.n2018 IOVSS.n2017 5.66767
R2255 IOVSS.n1769 IOVSS.n1768 5.66767
R2256 IOVSS.n1333 IOVSS.n1216 5.66767
R2257 IOVSS.n1624 IOVSS.n1623 5.66767
R2258 IOVSS.n1621 IOVSS.n1620 5.66767
R2259 IOVSS.n724 IOVSS.n687 5.66767
R2260 IOVSS.n1752 IOVSS.n1751 5.66767
R2261 IOVSS.n1021 IOVSS.n1020 5.66767
R2262 IOVSS.n1016 IOVSS.n1015 5.66767
R2263 IOVSS.n2088 IOVSS.n2087 5.66767
R2264 IOVSS.n2229 IOVSS.n2228 5.66767
R2265 IOVSS.n1457 IOVSS.n1023 5.62809
R2266 IOVSS.n336 IOVSS.n307 5.62487
R2267 IOVSS.n1624 IOVSS.n1054 5.61848
R2268 IOVSS.n1116 IOVSS.n1037 5.61848
R2269 IOVSS.n1111 IOVSS.n1051 5.61848
R2270 IOVSS.n1117 IOVSS.n1038 5.61848
R2271 IOVSS.n1110 IOVSS.n1050 5.61848
R2272 IOVSS.n1118 IOVSS.n1039 5.61848
R2273 IOVSS.n1109 IOVSS.n1049 5.61848
R2274 IOVSS.t131 IOVSS.n1041 5.61848
R2275 IOVSS.t199 IOVSS.n1100 5.61848
R2276 IOVSS.n2244 IOVSS.n2 5.61593
R2277 IOVSS.n1599 IOVSS.n1099 5.56542
R2278 IOVSS.n1199 IOVSS.n1099 5.56542
R2279 IOVSS.n1608 IOVSS.n1099 5.53738
R2280 IOVSS.n342 IOVSS.n341 5.45558
R2281 IOVSS.n2224 IOVSS.n2223 5.45558
R2282 IOVSS.n2220 IOVSS.n2219 5.45558
R2283 IOVSS.n81 IOVSS.n80 5.45501
R2284 IOVSS.n2225 IOVSS.n2224 5.45501
R2285 IOVSS.n2221 IOVSS.n2220 5.45501
R2286 IOVSS.t240 IOVSS.n87 5.37123
R2287 IOVSS.n2019 IOVSS.n488 5.27662
R2288 IOVSS.n2019 IOVSS.n487 5.27662
R2289 IOVSS.n2019 IOVSS.n486 5.27662
R2290 IOVSS.n2019 IOVSS.n485 5.27662
R2291 IOVSS.n2019 IOVSS.n484 5.27662
R2292 IOVSS.n2019 IOVSS.n483 5.27662
R2293 IOVSS.n2019 IOVSS.n480 5.27662
R2294 IOVSS.n2019 IOVSS.n479 5.27662
R2295 IOVSS.n1184 IOVSS.t47 5.10775
R2296 IOVSS.n138 IOVSS.n137 5.07336
R2297 IOVSS.t191 IOVSS.n470 4.88998
R2298 IOVSS.n1892 IOVSS.n1891 4.67625
R2299 IOVSS.n1791 IOVSS.n482 4.67625
R2300 IOVSS.n1889 IOVSS.n1888 4.67625
R2301 IOVSS.n1887 IOVSS.n1886 4.67625
R2302 IOVSS.n1884 IOVSS.n1883 4.67625
R2303 IOVSS.n1882 IOVSS.n1881 4.67625
R2304 IOVSS.n1881 IOVSS.n1807 4.67625
R2305 IOVSS.n1883 IOVSS.n1804 4.67625
R2306 IOVSS.n1886 IOVSS.n1798 4.67625
R2307 IOVSS.n1888 IOVSS.n1795 4.67625
R2308 IOVSS.n1792 IOVSS.n1791 4.67625
R2309 IOVSS.n1891 IOVSS.n1786 4.67625
R2310 IOVSS.n1784 IOVSS.n1783 4.67625
R2311 IOVSS.t12 IOVSS.n1749 4.64716
R2312 IOVSS.t15 IOVSS.n733 4.64716
R2313 IOVSS.n1388 IOVSS.n1387 4.60789
R2314 IOVSS.t198 IOVSS.n1144 4.59703
R2315 IOVSS.t135 IOVSS.n1037 4.59703
R2316 IOVSS.n122 IOVSS.n120 4.56612
R2317 IOVSS.n1019 IOVSS.n900 4.4862
R2318 IOVSS.n1019 IOVSS.n895 4.4862
R2319 IOVSS.n1001 IOVSS.n902 4.4862
R2320 IOVSS.n1001 IOVSS.n1000 4.4862
R2321 IOVSS.n1001 IOVSS.n999 4.4862
R2322 IOVSS.n2086 IOVSS.n2085 4.4862
R2323 IOVSS.n2086 IOVSS.n152 4.4862
R2324 IOVSS.n2086 IOVSS.n146 4.4862
R2325 IOVSS.n2086 IOVSS.n141 4.4862
R2326 IOVSS.n2086 IOVSS.n140 4.4862
R2327 IOVSS.n2086 IOVSS.n134 4.4862
R2328 IOVSS.n2086 IOVSS.n133 4.4862
R2329 IOVSS.n2086 IOVSS.n130 4.4862
R2330 IOVSS.n2086 IOVSS.n129 4.4862
R2331 IOVSS.n2086 IOVSS.n125 4.4862
R2332 IOVSS.n2086 IOVSS.n124 4.4862
R2333 IOVSS.n2086 IOVSS.n118 4.4862
R2334 IOVSS.n2086 IOVSS.n117 4.4862
R2335 IOVSS.n2086 IOVSS.n114 4.4862
R2336 IOVSS.n2086 IOVSS.n113 4.4862
R2337 IOVSS.n2086 IOVSS.n112 4.4862
R2338 IOVSS.n2086 IOVSS.n109 4.4862
R2339 IOVSS.n2086 IOVSS.n108 4.4862
R2340 IOVSS.n2086 IOVSS.n106 4.4862
R2341 IOVSS.n345 IOVSS.n7 4.4862
R2342 IOVSS.n343 IOVSS.n7 4.4862
R2343 IOVSS.n82 IOVSS.n7 4.4862
R2344 IOVSS.n84 IOVSS.n7 4.4862
R2345 IOVSS.n86 IOVSS.n7 4.4862
R2346 IOVSS.n2084 IOVSS.n2083 4.4862
R2347 IOVSS.n2083 IOVSS.n192 4.4862
R2348 IOVSS.n2081 IOVSS.n204 4.4862
R2349 IOVSS.n2081 IOVSS.n203 4.4862
R2350 IOVSS.n2081 IOVSS.n202 4.4862
R2351 IOVSS.n2081 IOVSS.n201 4.4862
R2352 IOVSS.n2081 IOVSS.n200 4.4862
R2353 IOVSS.n2081 IOVSS.n198 4.4862
R2354 IOVSS.n2081 IOVSS.n197 4.4862
R2355 IOVSS.n2081 IOVSS.n2080 4.4862
R2356 IOVSS.n2081 IOVSS.n2079 4.4862
R2357 IOVSS.n2081 IOVSS.n2075 4.4862
R2358 IOVSS.n2081 IOVSS.n2074 4.4862
R2359 IOVSS.n2081 IOVSS.n2070 4.4862
R2360 IOVSS.n2081 IOVSS.n212 4.4862
R2361 IOVSS.n2081 IOVSS.n195 4.4862
R2362 IOVSS.n2081 IOVSS.n194 4.4862
R2363 IOVSS.n2081 IOVSS.n193 4.4862
R2364 IOVSS.n209 IOVSS.t7 4.47611
R2365 IOVSS.t103 IOVSS.t71 4.47611
R2366 IOVSS.n1211 IOVSS.n1033 4.47511
R2367 IOVSS.n1214 IOVSS.n1033 4.47511
R2368 IOVSS.n1501 IOVSS.n1215 4.47511
R2369 IOVSS.n1501 IOVSS.n1213 4.47511
R2370 IOVSS.n870 IOVSS.n570 4.251
R2371 IOVSS.n1761 IOVSS.n658 4.2505
R2372 IOVSS.n1639 IOVSS.n1638 4.2059
R2373 IOVSS.n1132 IOVSS.n1026 4.2059
R2374 IOVSS.n2039 IOVSS.n229 4.20466
R2375 IOVSS.n1445 IOVSS.n1023 4.19115
R2376 IOVSS.n1439 IOVSS.n1023 4.19014
R2377 IOVSS.n1476 IOVSS.n1033 4.18965
R2378 IOVSS.n1454 IOVSS.n1023 4.18677
R2379 IOVSS.n1758 IOVSS.n1757 4.18606
R2380 IOVSS.n2011 IOVSS.n229 4.18435
R2381 IOVSS.n2028 IOVSS.n2027 4.18423
R2382 IOVSS.n1614 IOVSS.n1166 4.18288
R2383 IOVSS.n1614 IOVSS.n1146 4.18221
R2384 IOVSS.n1614 IOVSS.n1176 4.17785
R2385 IOVSS.n1626 IOVSS.n1043 4.17435
R2386 IOVSS.n1626 IOVSS.n1052 4.17435
R2387 IOVSS.n1742 IOVSS.n1740 4.17435
R2388 IOVSS.n1597 IOVSS.n1099 4.10883
R2389 IOVSS.n1148 IOVSS.t135 4.0863
R2390 IOVSS.n1172 IOVSS.t140 4.0863
R2391 IOVSS.n1750 IOVSS.n727 3.93315
R2392 IOVSS.n1750 IOVSS.n728 3.93315
R2393 IOVSS.n1750 IOVSS.n729 3.93315
R2394 IOVSS.n1750 IOVSS.n730 3.93315
R2395 IOVSS.n1750 IOVSS.n731 3.93315
R2396 IOVSS.n1750 IOVSS.n732 3.93315
R2397 IOVSS.n1750 IOVSS.n735 3.93315
R2398 IOVSS.n1750 IOVSS.n736 3.93315
R2399 IOVSS.n1750 IOVSS.n737 3.93315
R2400 IOVSS.n1750 IOVSS.n739 3.93315
R2401 IOVSS.n1750 IOVSS.n740 3.93315
R2402 IOVSS.n1750 IOVSS.n741 3.93315
R2403 IOVSS.n1750 IOVSS.n742 3.93315
R2404 IOVSS.n1750 IOVSS.n743 3.93315
R2405 IOVSS.n1758 IOVSS.n686 3.93315
R2406 IOVSS.n1742 IOVSS.n803 3.93315
R2407 IOVSS.n1742 IOVSS.n802 3.93315
R2408 IOVSS.n1742 IOVSS.n801 3.93315
R2409 IOVSS.n1742 IOVSS.n800 3.93315
R2410 IOVSS.n1742 IOVSS.n799 3.93315
R2411 IOVSS.n1742 IOVSS.n798 3.93315
R2412 IOVSS.n1742 IOVSS.n797 3.93315
R2413 IOVSS.n1742 IOVSS.n796 3.93315
R2414 IOVSS.n1742 IOVSS.n795 3.93315
R2415 IOVSS.n1742 IOVSS.n794 3.93315
R2416 IOVSS.n1742 IOVSS.n793 3.93315
R2417 IOVSS.n1742 IOVSS.n792 3.93315
R2418 IOVSS.n1742 IOVSS.n791 3.93315
R2419 IOVSS.n1742 IOVSS.n790 3.93315
R2420 IOVSS.n789 IOVSS.n788 3.93315
R2421 IOVSS.n2086 IOVSS.n128 3.84533
R2422 IOVSS.n2027 IOVSS.n387 3.83793
R2423 IOVSS.n2027 IOVSS.n385 3.83793
R2424 IOVSS.n382 IOVSS.n381 3.83793
R2425 IOVSS.n379 IOVSS.n258 3.83793
R2426 IOVSS.n379 IOVSS.n256 3.83793
R2427 IOVSS.n379 IOVSS.n262 3.83793
R2428 IOVSS.n379 IOVSS.n264 3.83793
R2429 IOVSS.n379 IOVSS.n266 3.83793
R2430 IOVSS.n379 IOVSS.n269 3.83793
R2431 IOVSS.n379 IOVSS.n273 3.83793
R2432 IOVSS.n379 IOVSS.n276 3.83793
R2433 IOVSS.n379 IOVSS.n278 3.83793
R2434 IOVSS.n379 IOVSS.n280 3.83793
R2435 IOVSS.n379 IOVSS.n283 3.83793
R2436 IOVSS.n379 IOVSS.n285 3.83793
R2437 IOVSS.n379 IOVSS.n287 3.83793
R2438 IOVSS.n379 IOVSS.n253 3.83793
R2439 IOVSS.n379 IOVSS.n252 3.83793
R2440 IOVSS.n388 IOVSS.n233 3.83793
R2441 IOVSS.n386 IOVSS.n233 3.83793
R2442 IOVSS.n249 IOVSS.n233 3.83793
R2443 IOVSS.n257 IOVSS.n233 3.83793
R2444 IOVSS.n255 IOVSS.n233 3.83793
R2445 IOVSS.n263 IOVSS.n233 3.83793
R2446 IOVSS.n265 IOVSS.n233 3.83793
R2447 IOVSS.n270 IOVSS.n233 3.83793
R2448 IOVSS.n272 IOVSS.n233 3.83793
R2449 IOVSS.n277 IOVSS.n233 3.83793
R2450 IOVSS.n279 IOVSS.n233 3.83793
R2451 IOVSS.n284 IOVSS.n233 3.83793
R2452 IOVSS.n286 IOVSS.n233 3.83793
R2453 IOVSS.n336 IOVSS.n324 3.83793
R2454 IOVSS.n482 IOVSS.t236 3.66761
R2455 IOVSS.n12 IOVSS.t70 3.60913
R2456 IOVSS.n41 IOVSS.t63 3.60913
R2457 IOVSS.n1928 IOVSS.t109 3.60913
R2458 IOVSS.n1827 IOVSS.t74 3.60913
R2459 IOVSS.t34 IOVSS.n126 3.58099
R2460 IOVSS.n196 IOVSS.t34 3.58099
R2461 IOVSS.t117 IOVSS.n2188 3.58099
R2462 IOVSS.t241 IOVSS.n2202 3.58099
R2463 IOVSS.t238 IOVSS.n2216 3.58099
R2464 IOVSS.t140 IOVSS.n1044 3.57558
R2465 IOVSS.n1469 IOVSS.n1468 3.36437
R2466 IOVSS.n1468 IOVSS.n1467 3.3616
R2467 IOVSS.n1614 IOVSS.n1137 3.32113
R2468 IOVSS.n1442 IOVSS.n1023 3.31923
R2469 IOVSS.n1622 IOVSS.n1072 3.31178
R2470 IOVSS.n1622 IOVSS.n1080 3.31178
R2471 IOVSS.n379 IOVSS.n271 3.30485
R2472 IOVSS.t177 IOVSS.n1772 3.30475
R2473 IOVSS.n379 IOVSS.n260 3.30365
R2474 IOVSS.n1632 IOVSS.n1033 3.30365
R2475 IOVSS.n1614 IOVSS.n1138 3.30348
R2476 IOVSS.n1435 IOVSS.n1434 3.29486
R2477 IOVSS.n1436 IOVSS.n1435 3.29212
R2478 IOVSS.n1905 IOVSS.n1904 3.21456
R2479 IOVSS.n2120 IOVSS.n5 3.21456
R2480 IOVSS.n1715 IOVSS.n525 3.2053
R2481 IOVSS.t82 IOVSS.t75 3.05642
R2482 IOVSS.t58 IOVSS.n591 2.93449
R2483 IOVSS.n2227 IOVSS.n79 2.92723
R2484 IOVSS.n1466 IOVSS.n1378 2.91917
R2485 IOVSS.n1746 IOVSS.n1745 2.86128
R2486 IOVSS.n1764 IOVSS.n525 2.83383
R2487 IOVSS.n1727 IOVSS.t176 2.80329
R2488 IOVSS.n1728 IOVSS.t179 2.80286
R2489 IOVSS.n1614 IOVSS.n1185 2.73288
R2490 IOVSS.n1306 IOVSS.n1283 2.71665
R2491 IOVSS.n1306 IOVSS.n1269 2.71665
R2492 IOVSS.n1626 IOVSS.n1035 2.70648
R2493 IOVSS.n1622 IOVSS.n1076 2.70599
R2494 IOVSS.n1614 IOVSS.n1153 2.69239
R2495 IOVSS.t7 IOVSS.n132 2.68586
R2496 IOVSS.n1750 IOVSS.n738 2.55868
R2497 IOVSS.n782 IOVSS.n781 2.50693
R2498 IOVSS.n1905 IOVSS.t235 2.5026
R2499 IOVSS.n2120 IOVSS.t239 2.5026
R2500 IOVSS.n1904 IOVSS.t83 2.44927
R2501 IOVSS.n5 IOVSS.t104 2.44927
R2502 IOVSS.t107 IOVSS.n448 2.44524
R2503 IOVSS.t237 IOVSS.n462 2.44524
R2504 IOVSS.t234 IOVSS.n476 2.44524
R2505 IOVSS.t143 IOVSS.n254 2.43113
R2506 IOVSS.n11 IOVSS.t72 2.42536
R2507 IOVSS.n13 IOVSS.t73 2.42536
R2508 IOVSS.n42 IOVSS.t65 2.42536
R2509 IOVSS.n40 IOVSS.t66 2.42536
R2510 IOVSS.n1929 IOVSS.t123 2.42536
R2511 IOVSS.n1927 IOVSS.t124 2.42536
R2512 IOVSS.n1826 IOVSS.t76 2.42536
R2513 IOVSS.n1828 IOVSS.t77 2.42536
R2514 IOVSS.n42 IOVSS.t120 2.40075
R2515 IOVSS.n40 IOVSS.t121 2.40075
R2516 IOVSS.n1929 IOVSS.t111 2.40075
R2517 IOVSS.n1927 IOVSS.t112 2.40075
R2518 IOVSS.n11 IOVSS.t86 2.39732
R2519 IOVSS.n13 IOVSS.t87 2.39732
R2520 IOVSS.n1826 IOVSS.t92 2.39732
R2521 IOVSS.n1828 IOVSS.t93 2.39732
R2522 IOVSS.t38 IOVSS.n138 2.38799
R2523 IOVSS.n230 IOVSS.t108 2.37603
R2524 IOVSS.n3 IOVSS.t118 2.37603
R2525 IOVSS.n228 IOVSS.t84 2.37259
R2526 IOVSS.n4 IOVSS.t105 2.37259
R2527 IOVSS.n1217 IOVSS.n1138 2.315
R2528 IOVSS.n1772 IOVSS.n1771 2.28644
R2529 IOVSS.n1306 IOVSS.n1250 2.28535
R2530 IOVSS.n1451 IOVSS.n1023 2.28443
R2531 IOVSS.t148 IOVSS.n122 2.28356
R2532 IOVSS.n1306 IOVSS.n1297 2.28044
R2533 IOVSS.n1744 IOVSS.n222 2.26567
R2534 IOVSS.n2062 IOVSS.n219 2.26567
R2535 IOVSS.n2046 IOVSS.n2045 2.26567
R2536 IOVSS.n2056 IOVSS.n224 2.26567
R2537 IOVSS.n2050 IOVSS.n214 2.26567
R2538 IOVSS.n2066 IOVSS.n2065 2.26567
R2539 IOVSS.n1471 IOVSS.n1470 2.26161
R2540 IOVSS.n2060 IOVSS.n221 2.2505
R2541 IOVSS.n2061 IOVSS.n220 2.2505
R2542 IOVSS.n2054 IOVSS.n226 2.2505
R2543 IOVSS.n2055 IOVSS.n225 2.2505
R2544 IOVSS.n216 IOVSS.n215 2.2505
R2545 IOVSS.n2049 IOVSS.n2048 2.2505
R2546 IOVSS.n2065 IOVSS.n2064 2.2505
R2547 IOVSS.n217 IOVSS.n216 2.2505
R2548 IOVSS.n2049 IOVSS.n2047 2.2505
R2549 IOVSS.n2051 IOVSS.n2050 2.2505
R2550 IOVSS.n2052 IOVSS.n2046 2.2505
R2551 IOVSS.n2054 IOVSS.n2053 2.2505
R2552 IOVSS.n2055 IOVSS.n223 2.2505
R2553 IOVSS.n2057 IOVSS.n2056 2.2505
R2554 IOVSS.n2058 IOVSS.n222 2.2505
R2555 IOVSS.n2060 IOVSS.n2059 2.2505
R2556 IOVSS.n2061 IOVSS.n218 2.2505
R2557 IOVSS.n2063 IOVSS.n2062 2.2505
R2558 IOVSS IOVSS.n0 2.16416
R2559 IOVSS.n1078 IOVSS.t126 2.16415
R2560 IOVSS.n1074 IOVSS.t128 2.16415
R2561 IOVSS.n782 IOVSS.t14 2.15947
R2562 IOVSS.n781 IOVSS.t17 2.15947
R2563 IOVSS.n1904 IOVSS.n1903 2.15925
R2564 IOVSS.n2239 IOVSS.n5 2.15925
R2565 IOVSS.n782 IOVSS.t13 2.15922
R2566 IOVSS.n781 IOVSS.t16 2.15922
R2567 IOVSS.n1432 IOVSS.n1023 2.11519
R2568 IOVSS.n1474 IOVSS.n1033 2.08432
R2569 IOVSS.n1145 IOVSS.t198 2.0434
R2570 IOVSS.n1157 IOVSS.t139 2.0434
R2571 IOVSS.n1173 IOVSS.t199 2.0434
R2572 IOVSS.n2077 IOVSS.n116 2.02994
R2573 IOVSS.n1306 IOVSS.n1257 1.97602
R2574 IOVSS.n1633 IOVSS.n1033 1.97148
R2575 IOVSS.n2083 IOVSS.n191 1.97148
R2576 IOVSS.n1630 IOVSS.n1031 1.96211
R2577 IOVSS.n1437 IOVSS.n1378 1.94872
R2578 IOVSS.n1881 IOVSS.n229 1.91337
R2579 IOVSS.n1883 IOVSS.n229 1.91337
R2580 IOVSS.n1886 IOVSS.n229 1.91337
R2581 IOVSS.n1888 IOVSS.n229 1.91337
R2582 IOVSS.n1791 IOVSS.n229 1.91337
R2583 IOVSS.n1891 IOVSS.n229 1.91337
R2584 IOVSS.n1783 IOVSS.n229 1.91337
R2585 IOVSS.n1603 IOVSS.n1602 1.898
R2586 IOVSS.n1604 IOVSS.n1603 1.898
R2587 IOVSS.n1602 IOVSS.n1601 1.87559
R2588 IOVSS.n1605 IOVSS.n1604 1.86256
R2589 IOVSS.n1501 IOVSS.n1500 1.81609
R2590 IOVSS.n2043 IOVSS.n227 1.802
R2591 IOVSS.t64 IOVSS.n2193 1.79074
R2592 IOVSS.n1306 IOVSS.n1290 1.72146
R2593 IOVSS.n1615 IOVSS.n1614 1.7005
R2594 IOVSS.n1629 IOVSS.n1628 1.66377
R2595 IOVSS.n1448 IOVSS.n1447 1.66023
R2596 IOVSS.n1355 IOVSS.t88 1.65978
R2597 IOVSS.n1430 IOVSS.t98 1.65978
R2598 IOVSS.n1377 IOVSS.t88 1.65919
R2599 IOVSS.t98 IOVSS.n1028 1.65919
R2600 IOVSS.n1448 IOVSS.t50 1.59649
R2601 IOVSS.n1629 IOVSS.t42 1.59551
R2602 IOVSS.n1435 IOVSS.t49 1.58181
R2603 IOVSS.n1436 IOVSS.t48 1.5736
R2604 IOVSS.n1467 IOVSS.t44 1.5736
R2605 IOVSS.n1468 IOVSS.t46 1.57337
R2606 IOVSS.n1434 IOVSS.t53 1.57336
R2607 IOVSS.n1469 IOVSS.t52 1.57336
R2608 IOVSS.n777 IOVSS.n776 1.5533
R2609 IOVSS.n1134 IOVSS.n1099 1.54595
R2610 IOVSS IOVSS.n1243 1.53916
R2611 IOVSS.n1163 IOVSS.t125 1.53268
R2612 IOVSS.n346 IOVSS.n2 1.52448
R2613 IOVSS.n344 IOVSS.n2 1.52448
R2614 IOVSS.n342 IOVSS.n2 1.52448
R2615 IOVSS.n81 IOVSS.n2 1.52448
R2616 IOVSS.n83 IOVSS.n2 1.52448
R2617 IOVSS.n85 IOVSS.n2 1.52448
R2618 IOVSS.n2224 IOVSS.n2 1.52448
R2619 IOVSS.n2220 IOVSS.n2 1.52448
R2620 IOVSS.n207 IOVSS.n142 1.52271
R2621 IOVSS.n150 IOVSS.n149 1.52271
R2622 IOVSS.n1027 IOVSS.n1023 1.52201
R2623 IOVSS.n1079 IOVSS.n1078 1.51638
R2624 IOVSS.n1075 IOVSS.n1074 1.51638
R2625 IOVSS.n1078 IOVSS.n1036 1.51398
R2626 IOVSS.n1074 IOVSS.n1073 1.51398
R2627 IOVSS.n1001 IOVSS.n943 1.51366
R2628 IOVSS.n1019 IOVSS.n894 1.51276
R2629 IOVSS.n1467 IOVSS.n1466 1.50969
R2630 IOVSS.n1437 IOVSS.n1436 1.50549
R2631 IOVSS.n1614 IOVSS.n1143 1.49681
R2632 IOVSS.n1470 IOVSS.n1469 1.49321
R2633 IOVSS.n1434 IOVSS.n1031 1.49298
R2634 IOVSS.n144 IOVSS.n107 1.4813
R2635 IOVSS.n2081 IOVSS.n210 1.47771
R2636 IOVSS IOVSS.n39 1.47145
R2637 IOVSS.n2058 IOVSS.n2057 1.46768
R2638 IOVSS.n1389 IOVSS.n1388 1.43326
R2639 IOVSS.n1726 IOVSS.n1725 1.42031
R2640 IOVSS.n1587 IOVSS.n1129 1.41493
R2641 IOVSS.n1598 IOVSS.n1592 1.41452
R2642 IOVSS.n1598 IOVSS.n1593 1.41252
R2643 IOVSS.n43 IOVSS.n39 1.39872
R2644 IOVSS.t56 IOVSS.n1693 1.39229
R2645 IOVSS.t56 IOVSS.t60 1.39229
R2646 IOVSS.n1656 IOVSS.n396 1.39229
R2647 IOVSS.n1431 IOVSS.n1389 1.37209
R2648 IOVSS.n352 IOVSS.n351 1.36721
R2649 IOVSS.n1734 IOVSS.n809 1.35895
R2650 IOVSS.n1726 IOVSS.n809 1.35801
R2651 IOVSS.n1249 IOVSS.n1243 1.35348
R2652 IOVSS.n1305 IOVSS 1.34843
R2653 IOVSS.n2227 IOVSS.n44 1.34122
R2654 IOVSS.n783 IOVSS.n777 1.32997
R2655 IOVSS.n1282 IOVSS.n1276 1.32471
R2656 IOVSS.n2064 IOVSS.n2063 1.3238
R2657 IOVSS.n2236 IOVSS.n2235 1.32222
R2658 IOVSS.n1743 IOVSS.n1742 1.32053
R2659 IOVSS.n1017 IOVSS.n107 1.31961
R2660 IOVSS.n2242 IOVSS.n2241 1.31548
R2661 IOVSS.t182 IOVSS.n2077 1.31385
R2662 IOVSS.n1725 IOVSS.n1724 1.31354
R2663 IOVSS.n2243 IOVSS.n2242 1.3121
R2664 IOVSS.n1276 IOVSS.n1275 1.30283
R2665 IOVSS.n2041 IOVSS.n2040 1.30244
R2666 IOVSS.n1202 IOVSS.n1129 1.29744
R2667 IOVSS.n1707 IOVSS.t178 1.26686
R2668 IOVSS.n2037 IOVSS.n232 1.25716
R2669 IOVSS.n259 IOVSS.n251 1.24868
R2670 IOVSS.n353 IOVSS.n352 1.23385
R2671 IOVSS.n334 IOVSS.n232 1.23329
R2672 IOVSS.t110 IOVSS.n453 1.22287
R2673 IOVSS.n282 IOVSS.t40 1.21581
R2674 IOVSS.n2237 IOVSS.n2236 1.21512
R2675 IOVSS.n2086 IOVSS.n145 1.20665
R2676 IOVSS.n1614 IOVSS.n1613 1.19574
R2677 IOVSS.n2069 IOVSS.n213 1.17373
R2678 IOVSS.n680 IOVSS.t95 1.16217
R2679 IOVSS.t56 IOVSS.t60 1.16217
R2680 IOVSS.n1721 IOVSS.n608 1.13893
R2681 IOVSS.n351 IOVSS.n251 1.12868
R2682 IOVSS.n1931 IOVSS.n442 1.12808
R2683 IOVSS.n1723 IOVSS.n1722 1.11958
R2684 IOVSS.n1745 IOVSS.n1744 1.11866
R2685 IOVSS.n1745 IOVSS.n219 1.11866
R2686 IOVSS.n2045 IOVSS.n2044 1.11866
R2687 IOVSS.n2044 IOVSS.n224 1.11866
R2688 IOVSS.n2067 IOVSS.n2066 1.11866
R2689 IOVSS.n2067 IOVSS.n214 1.11866
R2690 IOVSS.n688 IOVSS.n678 1.10967
R2691 IOVSS.n677 IOVSS.n606 1.10425
R2692 IOVSS.n1746 IOVSS.n780 1.09203
R2693 IOVSS IOVSS.n442 1.08785
R2694 IOVSS.n1724 IOVSS.n1723 1.07259
R2695 IOVSS.n1845 IOVSS.n478 1.06552
R2696 IOVSS.n78 IOVSS.n77 1.06462
R2697 IOVSS.n1305 IOVSS.n1241 1.05583
R2698 IOVSS.n1387 IOVSS.n780 1.04278
R2699 IOVSS.n2245 IOVSS.n1 1.0376
R2700 IOVSS.t19 IOVSS.n207 1.03039
R2701 IOVSS.t4 IOVSS.n150 1.03039
R2702 IOVSS.n1609 IOVSS.n1200 1.02586
R2703 IOVSS.n2177 IOVSS.n1 1.02504
R2704 IOVSS.n2241 IOVSS.n2240 1.01837
R2705 IOVSS.n78 IOVSS 1.01502
R2706 IOVSS.n478 IOVSS 1.01457
R2707 IOVSS.n199 IOVSS.n0 1.00973
R2708 IOVSS.n1663 IOVSS.n606 1.00414
R2709 IOVSS.n2240 IOVSS.n2239 0.995462
R2710 IOVSS IOVSS.n199 0.981659
R2711 IOVSS.n2069 IOVSS.n2068 0.980983
R2712 IOVSS.n1387 IOVSS.n784 0.976318
R2713 IOVSS.n784 IOVSS.n783 0.969482
R2714 IOVSS.n1742 IOVSS.n1741 0.96926
R2715 IOVSS.n1472 IOVSS.n1033 0.968642
R2716 IOVSS.n1610 IOVSS.n1609 0.968595
R2717 IOVSS.n1304 IOVSS.n1303 0.964824
R2718 IOVSS.n1304 IOVSS.n1241 0.963107
R2719 IOVSS.n1663 IOVSS.n608 0.9544
R2720 IOVSS.n1903 IOVSS.n227 0.928903
R2721 IOVSS.n341 IOVSS.t71 0.895622
R2722 IOVSS.n678 IOVSS.n677 0.862093
R2723 IOVSS.n350 IOVSS.n308 0.85077
R2724 IOVSS.n348 IOVSS.n2 0.8505
R2725 IOVSS.n1471 IOVSS 0.8475
R2726 IOVSS.n1741 IOVSS 0.846327
R2727 IOVSS.n1741 IOVSS 0.825337
R2728 IOVSS.n1472 IOVSS.n1471 0.822136
R2729 IOVSS.n13 IOVSS.n12 0.818099
R2730 IOVSS.n41 IOVSS.n40 0.818099
R2731 IOVSS.n1928 IOVSS.n1927 0.818099
R2732 IOVSS.n1828 IOVSS.n1827 0.818099
R2733 IOVSS.n12 IOVSS.n11 0.804349
R2734 IOVSS.n42 IOVSS.n41 0.804349
R2735 IOVSS.n1929 IOVSS.n1928 0.804349
R2736 IOVSS.n1827 IOVSS.n1826 0.804349
R2737 IOVSS.n2101 IOVSS.n44 0.77053
R2738 IOVSS.n165 IOVSS.n145 0.766385
R2739 IOVSS.n44 IOVSS.n43 0.746137
R2740 IOVSS.n1761 IOVSS.n1760 0.73963
R2741 IOVSS.n2022 IOVSS.n229 0.733879
R2742 IOVSS.n2042 IOVSS.n2041 0.71209
R2743 IOVSS.n1473 IOVSS.n1472 0.706038
R2744 IOVSS.n924 IOVSS.n894 0.674968
R2745 IOVSS.n1743 IOVSS 0.669978
R2746 IOVSS.n943 IOVSS.n942 0.66235
R2747 IOVSS.n1306 IOVSS.n1304 0.655112
R2748 IOVSS.n1598 IOVSS.n1597 0.644206
R2749 IOVSS.n229 IOVSS.n227 0.642982
R2750 IOVSS.n1282 IOVSS.n1281 0.63921
R2751 IOVSS.n1289 IOVSS.n1288 0.63921
R2752 IOVSS.n1303 IOVSS.n1302 0.63921
R2753 IOVSS.n1268 IOVSS.n1267 0.635661
R2754 IOVSS.n1275 IOVSS.n1274 0.635661
R2755 IOVSS.n1217 IOVSS.n1143 0.622638
R2756 IOVSS.n1613 IOVSS.n1612 0.613287
R2757 IOVSS.t75 IOVSS.n1801 0.611685
R2758 IOVSS.n1296 IOVSS.n1295 0.6055
R2759 IOVSS.n1017 IOVSS.n894 0.603599
R2760 IOVSS.n2227 IOVSS.n78 0.598996
R2761 IOVSS.n2019 IOVSS.n478 0.598982
R2762 IOVSS.n2081 IOVSS.n199 0.598873
R2763 IOVSS.n1746 IOVSS.n1743 0.598474
R2764 IOVSS.n1249 IOVSS.n1248 0.597167
R2765 IOVSS.n1750 IOVSS.n784 0.596982
R2766 IOVSS.n2017 IOVSS.n2016 0.587229
R2767 IOVSS.n1636 IOVSS.n1027 0.577167
R2768 IOVSS.n1388 IOVSS.n1027 0.562809
R2769 IOVSS.n1613 IOVSS.n1197 0.56202
R2770 IOVSS.n191 IOVSS.n190 0.555543
R2771 IOVSS.n1761 IOVSS.n608 0.548272
R2772 IOVSS.n145 IOVSS.n144 0.54648
R2773 IOVSS.n1633 IOVSS 0.539655
R2774 IOVSS.n1257 IOVSS.n1256 0.538225
R2775 IOVSS.n1296 IOVSS.n1290 0.537851
R2776 IOVSS.n2240 IOVSS.n2 0.536783
R2777 IOVSS.n1595 IOVSS.n1143 0.526636
R2778 IOVSS.n1634 IOVSS.n1633 0.525937
R2779 IOVSS.n1256 IOVSS.n1255 0.525567
R2780 IOVSS.t139 IOVSS.t127 0.511225
R2781 IOVSS.t125 IOVSS.t131 0.511225
R2782 IOVSS.n2072 IOVSS.n110 0.508236
R2783 IOVSS.n191 IOVSS.n0 0.504822
R2784 IOVSS.n1750 IOVSS.n780 0.504498
R2785 IOVSS.n2019 IOVSS.n442 0.496877
R2786 IOVSS.n43 IOVSS.n42 0.4955
R2787 IOVSS.n1930 IOVSS.n1929 0.4955
R2788 IOVSS.n2 IOVSS.n1 0.491967
R2789 IOVSS.n1006 IOVSS.n943 0.491696
R2790 IOVSS.n14 IOVSS.n13 0.488625
R2791 IOVSS.n1829 IOVSS.n1828 0.488625
R2792 IOVSS.n1297 IOVSS.n1296 0.485204
R2793 IOVSS.n1597 IOVSS.n1596 0.474983
R2794 IOVSS.n1500 IOVSS.n1499 0.469477
R2795 IOVSS.n1729 IOVSS.n1728 0.4605
R2796 IOVSS.n1453 IOVSS.n1451 0.447437
R2797 IOVSS.n1204 IOVSS.n1200 0.444429
R2798 IOVSS.n1250 IOVSS.n1249 0.436007
R2799 IOVSS.n1290 IOVSS.n1289 0.431801
R2800 IOVSS.n348 IOVSS.n347 0.431128
R2801 IOVSS.n1076 IOVSS.n1075 0.428885
R2802 IOVSS.n1073 IOVSS.n1035 0.428215
R2803 IOVSS.n1446 IOVSS.n1153 0.426321
R2804 IOVSS.n1761 IOVSS.n606 0.418547
R2805 IOVSS.n2081 IOVSS.n2069 0.417947
R2806 IOVSS.n210 IOVSS 0.416666
R2807 IOVSS.n1628 IOVSS.n1035 0.409683
R2808 IOVSS.n1447 IOVSS.n1076 0.408973
R2809 IOVSS.n1275 IOVSS.n1269 0.407821
R2810 IOVSS.n1283 IOVSS.n1282 0.407463
R2811 IOVSS.n1609 IOVSS.n1608 0.406123
R2812 IOVSS.n1716 IOVSS.t58 0.40548
R2813 IOVSS.n2042 IOVSS.n228 0.401267
R2814 IOVSS.n2241 IOVSS.n4 0.395812
R2815 IOVSS.n2040 IOVSS.n230 0.392375
R2816 IOVSS.n2243 IOVSS.n3 0.392375
R2817 IOVSS.n1072 IOVSS.n1071 0.391583
R2818 IOVSS.n1091 IOVSS.n1080 0.391574
R2819 IOVSS.n1204 IOVSS.n1201 0.389167
R2820 IOVSS.n1452 IOVSS.n1153 0.381341
R2821 IOVSS.n1268 IOVSS.n1257 0.377549
R2822 IOVSS.n1609 IOVSS.n1199 0.376275
R2823 IOVSS.n1601 IOVSS.n1600 0.375315
R2824 IOVSS.t1 IOVSS.n2072 0.373967
R2825 IOVSS.n1289 IOVSS.n1283 0.371155
R2826 IOVSS.n1269 IOVSS.n1268 0.370796
R2827 IOVSS.n1611 IOVSS.n1199 0.362871
R2828 IOVSS.n2068 IOVSS.n2067 0.357514
R2829 IOVSS.n1451 IOVSS.n1450 0.356063
R2830 IOVSS.n1632 IOVSS.n1631 0.3512
R2831 IOVSS.n1723 IOVSS.n852 0.347113
R2832 IOVSS.n1727 IOVSS.n1726 0.34425
R2833 IOVSS.n1197 IOVSS.n1185 0.344081
R2834 IOVSS.n1263 IOVSS.n1262 0.342328
R2835 IOVSS.n260 IOVSS.n247 0.339606
R2836 IOVSS.n2007 IOVSS.n2006 0.338378
R2837 IOVSS.n1303 IOVSS.n1297 0.3366
R2838 IOVSS.n2011 IOVSS.n2010 0.333578
R2839 IOVSS.n2029 IOVSS.n2028 0.333448
R2840 IOVSS.n1608 IOVSS.n1607 0.328861
R2841 IOVSS.n1906 IOVSS.n1905 0.327167
R2842 IOVSS.n2149 IOVSS.n2120 0.327167
R2843 IOVSS.n260 IOVSS.n259 0.3237
R2844 IOVSS.n350 IOVSS.n309 0.322242
R2845 IOVSS.n1740 IOVSS.n1739 0.319387
R2846 IOVSS.n1096 IOVSS.n1043 0.319387
R2847 IOVSS.n1066 IOVSS.n1052 0.318618
R2848 IOVSS.n1600 IOVSS.n1206 0.313014
R2849 IOVSS.n1292 IOVSS.n1291 0.312167
R2850 IOVSS.n1293 IOVSS.n1292 0.312167
R2851 IOVSS.n1294 IOVSS.n1293 0.312167
R2852 IOVSS.n1295 IOVSS.n1294 0.312167
R2853 IOVSS.n1256 IOVSS.n1250 0.309528
R2854 IOVSS.n1444 IOVSS.n1442 0.305542
R2855 IOVSS.n1385 IOVSS.n1138 0.304457
R2856 IOVSS.n1440 IOVSS.n1176 0.302828
R2857 IOVSS.n1631 IOVSS.n1630 0.302336
R2858 IOVSS.n1267 IOVSS.n1266 0.302113
R2859 IOVSS.n1266 IOVSS.n1265 0.302113
R2860 IOVSS.n1259 IOVSS.n1258 0.302113
R2861 IOVSS.n1274 IOVSS.n1273 0.302113
R2862 IOVSS.n1273 IOVSS.n1272 0.302113
R2863 IOVSS.n1272 IOVSS.n1271 0.302113
R2864 IOVSS.n1271 IOVSS.n1270 0.302113
R2865 IOVSS.n1278 IOVSS.n1277 0.302113
R2866 IOVSS.n1279 IOVSS.n1278 0.302113
R2867 IOVSS.n1280 IOVSS.n1279 0.302113
R2868 IOVSS.n1281 IOVSS.n1280 0.302113
R2869 IOVSS.n1285 IOVSS.n1284 0.302113
R2870 IOVSS.n1286 IOVSS.n1285 0.302113
R2871 IOVSS.n1287 IOVSS.n1286 0.302113
R2872 IOVSS.n1288 IOVSS.n1287 0.302113
R2873 IOVSS.n1299 IOVSS.n1298 0.302113
R2874 IOVSS.n1300 IOVSS.n1299 0.302113
R2875 IOVSS.n1301 IOVSS.n1300 0.302113
R2876 IOVSS.n1302 IOVSS.n1301 0.302113
R2877 IOVSS.t54 IOVSS.n1716 0.30168
R2878 IOVSS IOVSS.n2245 0.297907
R2879 IOVSS.n1599 IOVSS.n1598 0.297213
R2880 IOVSS.n2236 IOVSS.n7 0.295682
R2881 IOVSS.n749 IOVSS.n747 0.294378
R2882 IOVSS.n932 IOVSS.n930 0.290323
R2883 IOVSS.n934 IOVSS.n932 0.290323
R2884 IOVSS.n1248 IOVSS.n1247 0.283833
R2885 IOVSS.n1247 IOVSS.n1246 0.283833
R2886 IOVSS.n1246 IOVSS.n1245 0.283833
R2887 IOVSS.n1245 IOVSS.n1244 0.283833
R2888 IOVSS.n1761 IOVSS.n678 0.280008
R2889 IOVSS.n1069 IOVSS.n1068 0.279711
R2890 IOVSS.n1094 IOVSS.n1093 0.279711
R2891 IOVSS.n1441 IOVSS.n1440 0.273109
R2892 IOVSS.n1600 IOVSS.n1599 0.270058
R2893 IOVSS.n1458 IOVSS.n1457 0.267026
R2894 IOVSS.n1453 IOVSS.n1452 0.26543
R2895 IOVSS.n1456 IOVSS.n1455 0.26543
R2896 IOVSS.n1441 IOVSS.n1439 0.265113
R2897 IOVSS.n1489 IOVSS.n1488 0.264925
R2898 IOVSS.n1488 IOVSS.n1487 0.264925
R2899 IOVSS.n2032 IOVSS.n2031 0.261291
R2900 IOVSS.n2033 IOVSS.n2032 0.261291
R2901 IOVSS IOVSS.n2037 0.258761
R2902 IOVSS.n1080 IOVSS.n1079 0.255091
R2903 IOVSS.n1075 IOVSS.n1072 0.255082
R2904 IOVSS IOVSS.n1632 0.253439
R2905 IOVSS.n1386 IOVSS.n1385 0.2513
R2906 IOVSS.n926 IOVSS.n924 0.250378
R2907 IOVSS.n928 IOVSS.n926 0.250378
R2908 IOVSS.n930 IOVSS.n928 0.250378
R2909 IOVSS.n936 IOVSS.n934 0.250378
R2910 IOVSS.n938 IOVSS.n936 0.250378
R2911 IOVSS.n940 IOVSS.n938 0.250378
R2912 IOVSS.n942 IOVSS.n940 0.250378
R2913 IOVSS.n2103 IOVSS.n2101 0.250378
R2914 IOVSS.n2105 IOVSS.n2103 0.250378
R2915 IOVSS.n2107 IOVSS.n2105 0.250378
R2916 IOVSS.n2109 IOVSS.n2107 0.250378
R2917 IOVSS.n2111 IOVSS.n2109 0.250378
R2918 IOVSS.n2113 IOVSS.n2111 0.250378
R2919 IOVSS.n2115 IOVSS.n2113 0.250378
R2920 IOVSS.n2117 IOVSS.n2115 0.250378
R2921 IOVSS.n2119 IOVSS.n2117 0.250378
R2922 IOVSS.n2178 IOVSS.n2119 0.250378
R2923 IOVSS.n1736 IOVSS.n1735 0.250378
R2924 IOVSS.n1737 IOVSS.n1736 0.250378
R2925 IOVSS.n1738 IOVSS.n1737 0.250378
R2926 IOVSS.n1739 IOVSS.n1738 0.250378
R2927 IOVSS.n1071 IOVSS.n1070 0.250378
R2928 IOVSS.n1070 IOVSS.n1069 0.250378
R2929 IOVSS.n1068 IOVSS.n1067 0.250378
R2930 IOVSS.n1067 IOVSS.n1066 0.250378
R2931 IOVSS.n1092 IOVSS.n1091 0.250378
R2932 IOVSS.n1093 IOVSS.n1092 0.250378
R2933 IOVSS.n1095 IOVSS.n1094 0.250378
R2934 IOVSS.n1096 IOVSS.n1095 0.250378
R2935 IOVSS.n1933 IOVSS.n1931 0.250378
R2936 IOVSS.n1935 IOVSS.n1933 0.250378
R2937 IOVSS.n1937 IOVSS.n1935 0.250378
R2938 IOVSS.n1939 IOVSS.n1937 0.250378
R2939 IOVSS.n1941 IOVSS.n1939 0.250378
R2940 IOVSS.n1943 IOVSS.n1941 0.250378
R2941 IOVSS.n1945 IOVSS.n1943 0.250378
R2942 IOVSS.n1947 IOVSS.n1945 0.250378
R2943 IOVSS.n1949 IOVSS.n1947 0.250378
R2944 IOVSS.n1951 IOVSS.n1949 0.250378
R2945 IOVSS.n1953 IOVSS.n1951 0.250378
R2946 IOVSS.n1955 IOVSS.n1953 0.250378
R2947 IOVSS.n1957 IOVSS.n1955 0.250378
R2948 IOVSS.n1959 IOVSS.n1957 0.250378
R2949 IOVSS.n1961 IOVSS.n1959 0.250378
R2950 IOVSS.n1968 IOVSS.n1966 0.250378
R2951 IOVSS.n1970 IOVSS.n1968 0.250378
R2952 IOVSS.n1972 IOVSS.n1970 0.250378
R2953 IOVSS.n1974 IOVSS.n1972 0.250378
R2954 IOVSS.n1976 IOVSS.n1974 0.250378
R2955 IOVSS.n1978 IOVSS.n1976 0.250378
R2956 IOVSS.n1980 IOVSS.n1978 0.250378
R2957 IOVSS.n1982 IOVSS.n1980 0.250378
R2958 IOVSS.n1984 IOVSS.n1982 0.250378
R2959 IOVSS.n1986 IOVSS.n1984 0.250378
R2960 IOVSS.n1988 IOVSS.n1986 0.250378
R2961 IOVSS.n1990 IOVSS.n1988 0.250378
R2962 IOVSS.n1992 IOVSS.n1990 0.250378
R2963 IOVSS.n1994 IOVSS.n1992 0.250378
R2964 IOVSS.n1996 IOVSS.n1994 0.250378
R2965 IOVSS.n2010 IOVSS.n2009 0.250378
R2966 IOVSS.n2009 IOVSS.n2008 0.250378
R2967 IOVSS.n2008 IOVSS.n2007 0.250378
R2968 IOVSS.n2006 IOVSS.n2005 0.250378
R2969 IOVSS.n2005 IOVSS.n2004 0.250378
R2970 IOVSS.n2004 IOVSS.n231 0.250378
R2971 IOVSS.n1846 IOVSS.n1845 0.250378
R2972 IOVSS.n1847 IOVSS.n1846 0.250378
R2973 IOVSS.n1848 IOVSS.n1847 0.250378
R2974 IOVSS.n1849 IOVSS.n1848 0.250378
R2975 IOVSS.n1850 IOVSS.n1849 0.250378
R2976 IOVSS.n1851 IOVSS.n1850 0.250378
R2977 IOVSS.n1852 IOVSS.n1851 0.250378
R2978 IOVSS.n1853 IOVSS.n1852 0.250378
R2979 IOVSS.n1854 IOVSS.n1853 0.250378
R2980 IOVSS.n1855 IOVSS.n1854 0.250378
R2981 IOVSS.n1856 IOVSS.n1855 0.250378
R2982 IOVSS.n1857 IOVSS.n1856 0.250378
R2983 IOVSS.n1858 IOVSS.n1857 0.250378
R2984 IOVSS.n1859 IOVSS.n1858 0.250378
R2985 IOVSS.n1860 IOVSS.n1859 0.250378
R2986 IOVSS.n1865 IOVSS.n1864 0.250378
R2987 IOVSS.n1866 IOVSS.n1865 0.250378
R2988 IOVSS.n1867 IOVSS.n1866 0.250378
R2989 IOVSS.n1868 IOVSS.n1867 0.250378
R2990 IOVSS.n1869 IOVSS.n1868 0.250378
R2991 IOVSS.n1870 IOVSS.n1869 0.250378
R2992 IOVSS.n1871 IOVSS.n1870 0.250378
R2993 IOVSS.n1872 IOVSS.n1871 0.250378
R2994 IOVSS.n1873 IOVSS.n1872 0.250378
R2995 IOVSS.n1874 IOVSS.n1873 0.250378
R2996 IOVSS.n1875 IOVSS.n1874 0.250378
R2997 IOVSS.n1876 IOVSS.n1875 0.250378
R2998 IOVSS.n1877 IOVSS.n1876 0.250378
R2999 IOVSS.n1878 IOVSS.n1877 0.250378
R3000 IOVSS.n1879 IOVSS.n1878 0.250378
R3001 IOVSS.n2030 IOVSS.n2029 0.250378
R3002 IOVSS.n2031 IOVSS.n2030 0.250378
R3003 IOVSS.n2034 IOVSS.n2033 0.250378
R3004 IOVSS.n2035 IOVSS.n2034 0.250378
R3005 IOVSS.n776 IOVSS.n775 0.250378
R3006 IOVSS.n775 IOVSS.n773 0.250378
R3007 IOVSS.n773 IOVSS.n771 0.250378
R3008 IOVSS.n771 IOVSS.n769 0.250378
R3009 IOVSS.n769 IOVSS.n767 0.250378
R3010 IOVSS.n767 IOVSS.n765 0.250378
R3011 IOVSS.n765 IOVSS.n763 0.250378
R3012 IOVSS.n763 IOVSS.n761 0.250378
R3013 IOVSS.n761 IOVSS.n759 0.250378
R3014 IOVSS.n759 IOVSS.n757 0.250378
R3015 IOVSS.n757 IOVSS.n755 0.250378
R3016 IOVSS.n755 IOVSS.n753 0.250378
R3017 IOVSS.n753 IOVSS.n751 0.250378
R3018 IOVSS.n751 IOVSS.n749 0.250378
R3019 IOVSS.n747 IOVSS.n745 0.250378
R3020 IOVSS.n745 IOVSS.n689 0.250378
R3021 IOVSS.n1499 IOVSS.n1498 0.250378
R3022 IOVSS.n1498 IOVSS.n1497 0.250378
R3023 IOVSS.n1497 IOVSS.n1496 0.250378
R3024 IOVSS.n1496 IOVSS.n1495 0.250378
R3025 IOVSS.n1495 IOVSS.n1494 0.250378
R3026 IOVSS.n1494 IOVSS.n1493 0.250378
R3027 IOVSS.n1493 IOVSS.n1492 0.250378
R3028 IOVSS.n1492 IOVSS.n1491 0.250378
R3029 IOVSS.n1491 IOVSS.n1490 0.250378
R3030 IOVSS.n1490 IOVSS.n1489 0.250378
R3031 IOVSS.n1487 IOVSS.n1486 0.250378
R3032 IOVSS.n1486 IOVSS.n1485 0.250378
R3033 IOVSS.n1485 IOVSS.n1484 0.250378
R3034 IOVSS.n1484 IOVSS.n1483 0.250378
R3035 IOVSS.n1483 IOVSS.n1482 0.250378
R3036 IOVSS.n1482 IOVSS.n1481 0.250378
R3037 IOVSS.n1481 IOVSS.n1480 0.250378
R3038 IOVSS.n1480 IOVSS.n1479 0.250378
R3039 IOVSS.n1479 IOVSS.n1478 0.250378
R3040 IOVSS.n1589 IOVSS.n1588 0.250378
R3041 IOVSS.n1588 IOVSS.n1587 0.250378
R3042 IOVSS.n77 IOVSS.n76 0.250378
R3043 IOVSS.n76 IOVSS.n74 0.250378
R3044 IOVSS.n74 IOVSS.n72 0.250378
R3045 IOVSS.n72 IOVSS.n70 0.250378
R3046 IOVSS.n70 IOVSS.n68 0.250378
R3047 IOVSS.n68 IOVSS.n66 0.250378
R3048 IOVSS.n66 IOVSS.n64 0.250378
R3049 IOVSS.n64 IOVSS.n62 0.250378
R3050 IOVSS.n62 IOVSS.n60 0.250378
R3051 IOVSS.n60 IOVSS.n58 0.250378
R3052 IOVSS.n58 IOVSS.n56 0.250378
R3053 IOVSS.n56 IOVSS.n54 0.250378
R3054 IOVSS.n54 IOVSS.n52 0.250378
R3055 IOVSS.n52 IOVSS.n50 0.250378
R3056 IOVSS.n50 IOVSS.n48 0.250378
R3057 IOVSS.n2234 IOVSS.n2233 0.250378
R3058 IOVSS.n2235 IOVSS.n2234 0.250378
R3059 IOVSS.n783 IOVSS.n782 0.249964
R3060 IOVSS.n1255 IOVSS.n1254 0.249833
R3061 IOVSS.n1254 IOVSS.n1253 0.249833
R3062 IOVSS.n1253 IOVSS.n1252 0.249833
R3063 IOVSS.n1252 IOVSS.n1251 0.249833
R3064 IOVSS.n1444 IOVSS.n1443 0.248
R3065 IOVSS.n379 IOVSS.n251 0.247827
R3066 IOVSS.n1591 IOVSS.n1206 0.247702
R3067 IOVSS.n1607 IOVSS.n1605 0.244944
R3068 IOVSS.n347 IOVSS.n7 0.241262
R3069 IOVSS.n2016 IOVSS.n229 0.240792
R3070 IOVSS.n1433 IOVSS.n1197 0.238601
R3071 IOVSS.n190 IOVSS.n189 0.234847
R3072 IOVSS.n1456 IOVSS.n1454 0.234761
R3073 IOVSS.n1264 IOVSS.n1259 0.232919
R3074 IOVSS.n1466 IOVSS.n1465 0.230812
R3075 IOVSS.n1010 IOVSS.n213 0.230335
R3076 IOVSS.n1450 IOVSS 0.225283
R3077 IOVSS.n2013 IOVSS.n2011 0.224458
R3078 IOVSS.n1618 IOVSS.n1129 0.223227
R3079 IOVSS.n1450 IOVSS.n1449 0.219993
R3080 IOVSS.n2040 IOVSS.n2039 0.217847
R3081 IOVSS.n1455 IOVSS.n1146 0.216358
R3082 IOVSS.n2036 IOVSS.n2035 0.215728
R3083 IOVSS.n1450 IOVSS.n1445 0.214267
R3084 IOVSS.n1440 IOVSS.n1185 0.207196
R3085 IOVSS.n1073 IOVSS.n1052 0.205448
R3086 IOVSS.n1438 IOVSS.n1437 0.205222
R3087 IOVSS.n1043 IOVSS.n1036 0.204679
R3088 IOVSS.n1455 IOVSS.n1137 0.198078
R3089 IOVSS.n1477 IOVSS.n1241 0.197924
R3090 IOVSS.n2244 IOVSS.n2243 0.19741
R3091 IOVSS.n1631 IOVSS 0.196844
R3092 IOVSS IOVSS.n1740 0.193679
R3093 IOVSS.n1474 IOVSS.n1473 0.190923
R3094 IOVSS.n1962 IOVSS.n1961 0.187772
R3095 IOVSS.n1966 IOVSS.n1964 0.187772
R3096 IOVSS.n1861 IOVSS.n1860 0.187772
R3097 IOVSS.n1864 IOVSS.n1863 0.187772
R3098 IOVSS.n1880 IOVSS.n1879 0.187772
R3099 IOVSS.n1590 IOVSS.n1589 0.187772
R3100 IOVSS.n48 IOVSS.n16 0.187772
R3101 IOVSS.n2233 IOVSS.n2232 0.187772
R3102 IOVSS.n1464 IOVSS.n1380 0.185633
R3103 IOVSS.n1385 IOVSS.n1137 0.183969
R3104 IOVSS.n1757 IOVSS.n688 0.182643
R3105 IOVSS.n1443 IOVSS.n1166 0.180631
R3106 IOVSS.n2028 IOVSS.n247 0.177009
R3107 IOVSS.n2038 IOVSS 0.175065
R3108 IOVSS.n166 IOVSS.n165 0.17418
R3109 IOVSS.n1903 IOVSS.n1902 0.173106
R3110 IOVSS.n1722 IOVSS.n1721 0.173106
R3111 IOVSS.n2239 IOVSS.n2238 0.173106
R3112 IOVSS.n1443 IOVSS.n1176 0.171882
R3113 IOVSS.n1442 IOVSS.n1441 0.167696
R3114 IOVSS.n1964 IOVSS.n1930 0.1655
R3115 IOVSS.n1863 IOVSS.n1829 0.1655
R3116 IOVSS.n2232 IOVSS.n14 0.1655
R3117 IOVSS.n352 IOVSS.n350 0.161429
R3118 IOVSS.n1452 IOVSS.n1146 0.154302
R3119 IOVSS.n2041 IOVSS.n229 0.152086
R3120 IOVSS.n1446 IOVSS.n1166 0.151594
R3121 IOVSS.n233 IOVSS.n232 0.149755
R3122 IOVSS.n2242 IOVSS.n2 0.14639
R3123 IOVSS.n1477 IOVSS.n1476 0.146091
R3124 IOVSS.n1476 IOVSS.n1475 0.144405
R3125 IOVSS.n1757 IOVSS.n1756 0.143739
R3126 IOVSS.n1635 IOVSS.n1634 0.141939
R3127 IOVSS.n1473 IOVSS.n1470 0.141173
R3128 IOVSS.n1669 IOVSS.n1668 0.140442
R3129 IOVSS.n1634 IOVSS.n1031 0.139833
R3130 IOVSS.n1454 IOVSS.n1453 0.136306
R3131 IOVSS.n2178 IOVSS.n2177 0.132772
R3132 IOVSS.n2013 IOVSS.n1996 0.132772
R3133 IOVSS.n1203 IOVSS.n1202 0.131125
R3134 IOVSS.n1205 IOVSS.n1204 0.131125
R3135 IOVSS.n1902 IOVSS.n1901 0.125439
R3136 IOVSS.n2238 IOVSS.n2237 0.125439
R3137 IOVSS.n1439 IOVSS.n1438 0.12273
R3138 IOVSS.n1445 IOVSS.n1444 0.118653
R3139 IOVSS.n2052 IOVSS 0.11842
R3140 IOVSS.n2038 IOVSS.n231 0.118106
R3141 IOVSS.n2245 IOVSS.n2244 0.116041
R3142 IOVSS.n1465 IOVSS.n1379 0.114439
R3143 IOVSS.n1218 IOVSS.n1217 0.112977
R3144 IOVSS.n334 IOVSS.n307 0.112863
R3145 IOVSS.n1500 IOVSS.n1218 0.111743
R3146 IOVSS.n1636 IOVSS.n1635 0.108939
R3147 IOVSS.n1627 IOVSS.n1036 0.106833
R3148 IOVSS.n1079 IOVSS.n1077 0.106833
R3149 IOVSS.n1204 IOVSS.n1203 0.103625
R3150 IOVSS.n1607 IOVSS.n1205 0.103625
R3151 IOVSS.n1446 IOVSS 0.101333
R3152 IOVSS.n1591 IOVSS.n1590 0.0995
R3153 IOVSS.n1725 IOVSS.n523 0.097901
R3154 IOVSS.n1386 IOVSS.n1379 0.0961056
R3155 IOVSS.n1306 IOVSS.n1305 0.092959
R3156 IOVSS.n2068 IOVSS.n210 0.0919761
R3157 IOVSS.n2043 IOVSS.n2042 0.0903182
R3158 IOVSS.n809 IOVSS.n523 0.089974
R3159 IOVSS.n353 IOVSS.n307 0.0888312
R3160 IOVSS.n1636 IOVSS 0.0832696
R3161 IOVSS.n1457 IOVSS.n1456 0.079137
R3162 IOVSS.n2039 IOVSS.n2038 0.0785198
R3163 IOVSS.n671 IOVSS.n670 0.0784746
R3164 IOVSS.n1389 IOVSS.n1023 0.0780035
R3165 IOVSS.n1756 IOVSS.n689 0.0777723
R3166 IOVSS.n1552 IOVSS.n1551 0.0771667
R3167 IOVSS.n677 IOVSS.n676 0.0766538
R3168 IOVSS.n1722 IOVSS.n881 0.0751429
R3169 IOVSS.n877 IOVSS.n876 0.0734456
R3170 IOVSS.n876 IOVSS.n875 0.0730091
R3171 IOVSS.n1478 IOVSS.n1477 0.0722723
R3172 IOVSS.n672 IOVSS.n671 0.0709038
R3173 IOVSS.n666 IOVSS.n658 0.0708644
R3174 IOVSS.n1265 IOVSS.n1264 0.0696935
R3175 IOVSS.n871 IOVSS.n870 0.0694683
R3176 IOVSS.n1895 IOVSS.n1894 0.0674623
R3177 IOVSS.n1674 IOVSS.n1673 0.0673462
R3178 IOVSS.n1901 IOVSS.n1880 0.0646667
R3179 IOVSS.n1009 IOVSS.n1008 0.0641842
R3180 IOVSS.n1735 IOVSS.n1734 0.0631056
R3181 IOVSS.n2044 IOVSS.n2043 0.0612273
R3182 IOVSS.n1787 IOVSS.n1785 0.0593858
R3183 IOVSS.n1789 IOVSS.n1788 0.0593858
R3184 IOVSS.n1793 IOVSS.n1790 0.0593858
R3185 IOVSS.n1796 IOVSS.n1794 0.0593858
R3186 IOVSS.n1799 IOVSS.n1797 0.0593858
R3187 IOVSS.n1802 IOVSS.n1800 0.0593858
R3188 IOVSS.n1805 IOVSS.n1803 0.0593858
R3189 IOVSS.n1808 IOVSS.n1806 0.0593858
R3190 IOVSS.n1809 IOVSS.n1808 0.0593858
R3191 IOVSS.n1806 IOVSS.n1805 0.0593858
R3192 IOVSS.n1803 IOVSS.n1802 0.0593858
R3193 IOVSS.n1800 IOVSS.n1799 0.0593858
R3194 IOVSS.n1797 IOVSS.n1796 0.0593858
R3195 IOVSS.n1794 IOVSS.n1793 0.0593858
R3196 IOVSS.n1790 IOVSS.n1789 0.0593858
R3197 IOVSS.n1788 IOVSS.n1787 0.0593858
R3198 IOVSS.n1894 IOVSS.n1785 0.0593858
R3199 IOVSS.n2137 IOVSS.n2136 0.0593858
R3200 IOVSS.n2135 IOVSS.n2134 0.0593858
R3201 IOVSS.n2133 IOVSS.n2132 0.0593858
R3202 IOVSS.n2131 IOVSS.n2130 0.0593858
R3203 IOVSS.n2129 IOVSS.n2128 0.0593858
R3204 IOVSS.n2127 IOVSS.n2126 0.0593858
R3205 IOVSS.n2125 IOVSS.n2124 0.0593858
R3206 IOVSS.n2123 IOVSS.n2122 0.0593858
R3207 IOVSS.n2122 IOVSS.n2121 0.0593858
R3208 IOVSS.n2124 IOVSS.n2123 0.0593858
R3209 IOVSS.n2126 IOVSS.n2125 0.0593858
R3210 IOVSS.n2128 IOVSS.n2127 0.0593858
R3211 IOVSS.n2130 IOVSS.n2129 0.0593858
R3212 IOVSS.n2132 IOVSS.n2131 0.0593858
R3213 IOVSS.n2134 IOVSS.n2133 0.0593858
R3214 IOVSS.n2136 IOVSS.n2135 0.0593858
R3215 IOVSS.n189 IOVSS.n188 0.0589539
R3216 IOVSS.n957 IOVSS.n104 0.0589375
R3217 IOVSS.n378 IOVSS.n377 0.0589375
R3218 IOVSS.n375 IOVSS.n374 0.0589375
R3219 IOVSS.n372 IOVSS.n371 0.0589375
R3220 IOVSS.n369 IOVSS.n368 0.0589375
R3221 IOVSS.n366 IOVSS.n365 0.0589375
R3222 IOVSS.n363 IOVSS.n362 0.0589375
R3223 IOVSS.n360 IOVSS.n359 0.0589375
R3224 IOVSS.n357 IOVSS.n356 0.0589375
R3225 IOVSS.n354 IOVSS.n353 0.0589375
R3226 IOVSS.n334 IOVSS.n332 0.0588989
R3227 IOVSS.n247 IOVSS.n246 0.0585899
R3228 IOVSS.n1475 IOVSS.n1474 0.0585625
R3229 IOVSS.n2139 IOVSS.n2138 0.0584845
R3230 IOVSS.n1628 IOVSS.n1627 0.0555
R3231 IOVSS.n1447 IOVSS.n1077 0.0555
R3232 IOVSS.n960 IOVSS.n959 0.0539622
R3233 IOVSS.n1433 IOVSS.n1432 0.0536701
R3234 IOVSS.n328 IOVSS.n327 0.0536461
R3235 IOVSS.n329 IOVSS.n328 0.0536461
R3236 IOVSS.n331 IOVSS.n330 0.0536461
R3237 IOVSS.n332 IOVSS.n331 0.0536461
R3238 IOVSS.n246 IOVSS.n245 0.0536461
R3239 IOVSS.n245 IOVSS.n244 0.0536461
R3240 IOVSS.n243 IOVSS.n242 0.0536461
R3241 IOVSS.n242 IOVSS.n241 0.0536461
R3242 IOVSS.n330 IOVSS.n329 0.0533371
R3243 IOVSS.n244 IOVSS.n243 0.0533371
R3244 IOVSS.n1475 IOVSS.n1377 0.0501645
R3245 IOVSS.n1636 IOVSS.n1028 0.0501645
R3246 IOVSS.n172 IOVSS.n171 0.0493468
R3247 IOVSS.n181 IOVSS.n180 0.0493468
R3248 IOVSS.n1355 IOVSS.n1218 0.0489367
R3249 IOVSS.n1431 IOVSS.n1430 0.0489367
R3250 IOVSS.n1770 IOVSS.n523 0.0485714
R3251 IOVSS IOVSS.n1446 0.0483261
R3252 IOVSS.n174 IOVSS.n173 0.0474502
R3253 IOVSS.n176 IOVSS.n175 0.0474502
R3254 IOVSS.n178 IOVSS.n177 0.0460172
R3255 IOVSS.n183 IOVSS.n182 0.0455537
R3256 IOVSS.n185 IOVSS.n184 0.0455537
R3257 IOVSS.n1356 IOVSS.n1355 0.0450734
R3258 IOVSS.n1430 IOVSS.n1429 0.0450734
R3259 IOVSS.n1377 IOVSS.n1376 0.0448389
R3260 IOVSS.n1409 IOVSS.n1028 0.0448389
R3261 IOVSS.n1010 IOVSS.n1009 0.0430623
R3262 IOVSS.n1465 IOVSS.n1464 0.0412379
R3263 IOVSS.n1471 IOVSS.n1034 0.0405681
R3264 IOVSS.n1648 IOVSS.n655 0.0405
R3265 IOVSS.n1653 IOVSS.n614 0.0405
R3266 IOVSS.n1646 IOVSS.n653 0.0405
R3267 IOVSS.n1710 IOVSS.n616 0.0405
R3268 IOVSS.n1709 IOVSS.n651 0.0405
R3269 IOVSS.n1706 IOVSS.n618 0.0405
R3270 IOVSS.n1704 IOVSS.n649 0.0405
R3271 IOVSS.n1702 IOVSS.n620 0.0405
R3272 IOVSS.n1700 IOVSS.n647 0.0405
R3273 IOVSS.n1698 IOVSS.n622 0.0405
R3274 IOVSS.n1696 IOVSS.n645 0.0405
R3275 IOVSS.n1694 IOVSS.n624 0.0405
R3276 IOVSS.n1692 IOVSS.n643 0.0405
R3277 IOVSS.n1690 IOVSS.n626 0.0405
R3278 IOVSS.n1688 IOVSS.n641 0.0405
R3279 IOVSS.n1686 IOVSS.n628 0.0405
R3280 IOVSS.n1684 IOVSS.n639 0.0405
R3281 IOVSS.n1682 IOVSS.n630 0.0405
R3282 IOVSS.n1680 IOVSS.n637 0.0405
R3283 IOVSS.n1678 IOVSS.n632 0.0405
R3284 IOVSS.n1676 IOVSS.n635 0.0405
R3285 IOVSS.n688 IOVSS.n685 0.0405
R3286 IOVSS.n684 IOVSS.n610 0.0405
R3287 IOVSS.n1458 IOVSS.n1386 0.0403255
R3288 IOVSS.n1438 IOVSS.n1433 0.039
R3289 IOVSS.n1631 IOVSS.n1034 0.0382025
R3290 IOVSS.n2012 IOVSS.n1774 0.0380194
R3291 IOVSS.n1926 IOVSS.n1924 0.0380194
R3292 IOVSS.n1925 IOVSS.n1775 0.0380194
R3293 IOVSS.n1923 IOVSS.n1921 0.0380194
R3294 IOVSS.n1922 IOVSS.n1776 0.0380194
R3295 IOVSS.n1920 IOVSS.n1918 0.0380194
R3296 IOVSS.n1919 IOVSS.n1777 0.0380194
R3297 IOVSS.n1917 IOVSS.n1915 0.0380194
R3298 IOVSS.n1916 IOVSS.n1778 0.0380194
R3299 IOVSS.n1914 IOVSS.n1912 0.0380194
R3300 IOVSS.n1913 IOVSS.n1779 0.0380194
R3301 IOVSS.n1911 IOVSS.n1909 0.0380194
R3302 IOVSS.n1910 IOVSS.n1780 0.0380194
R3303 IOVSS.n1907 IOVSS.n1781 0.0380194
R3304 IOVSS.n1898 IOVSS.n1896 0.0380194
R3305 IOVSS.n1897 IOVSS.n1782 0.0380194
R3306 IOVSS.n1895 IOVSS.n1893 0.0380194
R3307 IOVSS.n2176 IOVSS.n2175 0.0380194
R3308 IOVSS.n2174 IOVSS.n2173 0.0380194
R3309 IOVSS.n2172 IOVSS.n2171 0.0380194
R3310 IOVSS.n2170 IOVSS.n2169 0.0380194
R3311 IOVSS.n2168 IOVSS.n2167 0.0380194
R3312 IOVSS.n2166 IOVSS.n2165 0.0380194
R3313 IOVSS.n2164 IOVSS.n2163 0.0380194
R3314 IOVSS.n2162 IOVSS.n2161 0.0380194
R3315 IOVSS.n2160 IOVSS.n2159 0.0380194
R3316 IOVSS.n2158 IOVSS.n2157 0.0380194
R3317 IOVSS.n2156 IOVSS.n2155 0.0380194
R3318 IOVSS.n2154 IOVSS.n2153 0.0380194
R3319 IOVSS.n2152 IOVSS.n2151 0.0380194
R3320 IOVSS.n2147 IOVSS.n2146 0.0380194
R3321 IOVSS.n2145 IOVSS.n2144 0.0380194
R3322 IOVSS.n2143 IOVSS.n2142 0.0380194
R3323 IOVSS.n2141 IOVSS.n2140 0.0380194
R3324 IOVSS.n2140 IOVSS.n2139 0.0380194
R3325 IOVSS.n186 IOVSS.n185 0.0379675
R3326 IOVSS.n188 IOVSS.n187 0.0379675
R3327 IOVSS.n1906 IOVSS.n1899 0.0371667
R3328 IOVSS.n863 IOVSS.n861 0.0371667
R3329 IOVSS.n1724 IOVSS.n851 0.0371667
R3330 IOVSS.n576 IOVSS.n565 0.0371667
R3331 IOVSS.n577 IOVSS.n564 0.0371667
R3332 IOVSS.n580 IOVSS.n562 0.0371667
R3333 IOVSS.n581 IOVSS.n560 0.0371667
R3334 IOVSS.n584 IOVSS.n558 0.0371667
R3335 IOVSS.n585 IOVSS.n556 0.0371667
R3336 IOVSS.n588 IOVSS.n554 0.0371667
R3337 IOVSS.n589 IOVSS.n552 0.0371667
R3338 IOVSS.n592 IOVSS.n550 0.0371667
R3339 IOVSS.n593 IOVSS.n548 0.0371667
R3340 IOVSS.n596 IOVSS.n546 0.0371667
R3341 IOVSS.n597 IOVSS.n544 0.0371667
R3342 IOVSS.n600 IOVSS.n542 0.0371667
R3343 IOVSS.n601 IOVSS.n540 0.0371667
R3344 IOVSS.n604 IOVSS.n538 0.0371667
R3345 IOVSS.n605 IOVSS.n536 0.0371667
R3346 IOVSS.n1763 IOVSS.n534 0.0371667
R3347 IOVSS.n567 IOVSS.n531 0.0371667
R3348 IOVSS.n1766 IOVSS.n1765 0.0371667
R3349 IOVSS.n569 IOVSS.n568 0.0371667
R3350 IOVSS.n2150 IOVSS.n2149 0.0371667
R3351 IOVSS.n2086 IOVSS.n107 0.0367446
R3352 IOVSS.n177 IOVSS.n176 0.0360709
R3353 IOVSS.n366 IOVSS.n297 0.0353056
R3354 IOVSS.n368 IOVSS.n297 0.0353056
R3355 IOVSS.n2089 IOVSS.n2 0.0349
R3356 IOVSS.n674 IOVSS.n662 0.0342013
R3357 IOVSS.n668 IOVSS.n665 0.0342013
R3358 IOVSS.n664 IOVSS.n663 0.0342013
R3359 IOVSS.n667 IOVSS.n665 0.0342013
R3360 IOVSS.n661 IOVSS.n660 0.0342013
R3361 IOVSS.n673 IOVSS.n662 0.0342013
R3362 IOVSS.n673 IOVSS.n661 0.0339791
R3363 IOVSS.n667 IOVSS.n664 0.0339791
R3364 IOVSS.n669 IOVSS.n668 0.0339791
R3365 IOVSS.n675 IOVSS.n674 0.0339791
R3366 IOVSS.n1595 IOVSS.n1594 0.0338333
R3367 IOVSS.n1523 IOVSS.n1141 0.0338333
R3368 IOVSS.n1524 IOVSS.n1522 0.0338333
R3369 IOVSS.n1527 IOVSS.n1526 0.0338333
R3370 IOVSS.n1528 IOVSS.n1521 0.0338333
R3371 IOVSS.n1531 IOVSS.n1530 0.0338333
R3372 IOVSS.n1533 IOVSS.n1532 0.0338333
R3373 IOVSS.n1535 IOVSS.n1534 0.0338333
R3374 IOVSS.n1537 IOVSS.n1536 0.0338333
R3375 IOVSS.n1538 IOVSS.n1520 0.0338333
R3376 IOVSS.n1540 IOVSS.n1539 0.0338333
R3377 IOVSS.n1541 IOVSS.n1519 0.0338333
R3378 IOVSS.n1543 IOVSS.n1542 0.0338333
R3379 IOVSS.n1544 IOVSS.n1518 0.0338333
R3380 IOVSS.n1546 IOVSS.n1545 0.0338333
R3381 IOVSS.n1547 IOVSS.n1517 0.0338333
R3382 IOVSS.n1549 IOVSS.n1548 0.0338333
R3383 IOVSS.n1550 IOVSS.n1516 0.0338333
R3384 IOVSS.n1551 IOVSS.n1515 0.0338333
R3385 IOVSS.n1555 IOVSS.n1553 0.0338333
R3386 IOVSS.n1554 IOVSS.n1514 0.0338333
R3387 IOVSS.n1558 IOVSS.n1556 0.0338333
R3388 IOVSS.n1557 IOVSS.n1513 0.0338333
R3389 IOVSS.n1561 IOVSS.n1559 0.0338333
R3390 IOVSS.n1560 IOVSS.n1512 0.0338333
R3391 IOVSS.n1564 IOVSS.n1562 0.0338333
R3392 IOVSS.n1563 IOVSS.n1511 0.0338333
R3393 IOVSS.n1567 IOVSS.n1565 0.0338333
R3394 IOVSS.n1566 IOVSS.n1510 0.0338333
R3395 IOVSS.n1570 IOVSS.n1568 0.0338333
R3396 IOVSS.n1569 IOVSS.n1509 0.0338333
R3397 IOVSS.n1573 IOVSS.n1571 0.0338333
R3398 IOVSS.n1572 IOVSS.n1508 0.0338333
R3399 IOVSS.n1576 IOVSS.n1574 0.0338333
R3400 IOVSS.n1575 IOVSS.n1507 0.0338333
R3401 IOVSS.n1578 IOVSS.n1577 0.0338333
R3402 IOVSS.n1612 IOVSS.n1198 0.0338333
R3403 IOVSS.n879 IOVSS.n857 0.0335531
R3404 IOVSS.n873 IOVSS.n860 0.0335531
R3405 IOVSS.n859 IOVSS.n858 0.0335531
R3406 IOVSS.n872 IOVSS.n860 0.0335531
R3407 IOVSS.n856 IOVSS.n855 0.0335531
R3408 IOVSS.n878 IOVSS.n857 0.0335531
R3409 IOVSS.n878 IOVSS.n856 0.0333352
R3410 IOVSS.n872 IOVSS.n859 0.0333352
R3411 IOVSS.n874 IOVSS.n873 0.0333352
R3412 IOVSS.n880 IOVSS.n879 0.0333352
R3413 IOVSS.n1901 IOVSS.n1900 0.0329031
R3414 IOVSS.n2237 IOVSS.n6 0.0329031
R3415 IOVSS.n169 IOVSS.n168 0.0327414
R3416 IOVSS.n1672 IOVSS.n1671 0.0325677
R3417 IOVSS.n1670 IOVSS.n1658 0.0325677
R3418 IOVSS.n1671 IOVSS.n1659 0.0325677
R3419 IOVSS.n1670 IOVSS.n1659 0.0323566
R3420 IOVSS.n1672 IOVSS.n1657 0.0323566
R3421 IOVSS.n1667 IOVSS.n1666 0.0323308
R3422 IOVSS.n1665 IOVSS.n1661 0.0323308
R3423 IOVSS.n1666 IOVSS.n1662 0.0323308
R3424 IOVSS.n1665 IOVSS.n1662 0.0321213
R3425 IOVSS.n1667 IOVSS.n1660 0.0321213
R3426 IOVSS.n2227 IOVSS.n39 0.0306771
R3427 IOVSS.n869 IOVSS.n868 0.0305
R3428 IOVSS.n1018 IOVSS.n1017 0.0301686
R3429 IOVSS.n959 IOVSS.n956 0.0301686
R3430 IOVSS.n378 IOVSS.n290 0.0301686
R3431 IOVSS.n375 IOVSS.n291 0.0301686
R3432 IOVSS.n372 IOVSS.n293 0.0301686
R3433 IOVSS.n369 IOVSS.n295 0.0301686
R3434 IOVSS.n363 IOVSS.n299 0.0301686
R3435 IOVSS.n360 IOVSS.n301 0.0301686
R3436 IOVSS.n357 IOVSS.n303 0.0301686
R3437 IOVSS.n356 IOVSS.n305 0.0301686
R3438 IOVSS.n351 IOVSS.n290 0.0301686
R3439 IOVSS.n354 IOVSS.n305 0.0301686
R3440 IOVSS.n359 IOVSS.n303 0.0301686
R3441 IOVSS.n362 IOVSS.n301 0.0301686
R3442 IOVSS.n365 IOVSS.n299 0.0301686
R3443 IOVSS.n371 IOVSS.n295 0.0301686
R3444 IOVSS.n374 IOVSS.n293 0.0301686
R3445 IOVSS.n377 IOVSS.n291 0.0301686
R3446 IOVSS.n957 IOVSS.n956 0.0301686
R3447 IOVSS.n1018 IOVSS.n104 0.0301686
R3448 IOVSS.n2062 IOVSS.n2061 0.0300385
R3449 IOVSS.n2061 IOVSS.n2060 0.0300385
R3450 IOVSS.n2060 IOVSS.n222 0.0300385
R3451 IOVSS.n221 IOVSS.n220 0.0300385
R3452 IOVSS.n2056 IOVSS.n2055 0.0300385
R3453 IOVSS.n2055 IOVSS.n2054 0.0300385
R3454 IOVSS.n2054 IOVSS.n2046 0.0300385
R3455 IOVSS.n226 IOVSS.n225 0.0300385
R3456 IOVSS.n2048 IOVSS.n215 0.0300385
R3457 IOVSS.n2050 IOVSS.n2049 0.0300385
R3458 IOVSS.n2049 IOVSS.n216 0.0300385
R3459 IOVSS.n2065 IOVSS.n216 0.0300385
R3460 IOVSS.n1900 IOVSS.n1809 0.0299429
R3461 IOVSS.n2121 IOVSS.n6 0.0299429
R3462 IOVSS.n2138 IOVSS.n2137 0.0299429
R3463 IOVSS.n187 IOVSS.n186 0.0284847
R3464 IOVSS.n2037 IOVSS.n2036 0.0284556
R3465 IOVSS.n1756 IOVSS.n1755 0.0263824
R3466 IOVSS.n691 IOVSS.n690 0.0263824
R3467 IOVSS.n825 IOVSS.n823 0.0263824
R3468 IOVSS.n826 IOVSS.n820 0.0263824
R3469 IOVSS.n830 IOVSS.n828 0.0263824
R3470 IOVSS.n831 IOVSS.n818 0.0263824
R3471 IOVSS.n835 IOVSS.n833 0.0263824
R3472 IOVSS.n1962 IOVSS.n1930 0.0261667
R3473 IOVSS.n1861 IOVSS.n1829 0.0261667
R3474 IOVSS.n1592 IOVSS.n1591 0.0261667
R3475 IOVSS.n1202 IOVSS.n1201 0.0261667
R3476 IOVSS.n16 IOVSS.n14 0.0261667
R3477 IOVSS.n963 IOVSS.n962 0.0251053
R3478 IOVSS.n966 IOVSS.n965 0.0251053
R3479 IOVSS.n982 IOVSS.n980 0.0251053
R3480 IOVSS.n869 IOVSS.n864 0.0238333
R3481 IOVSS.n1594 IOVSS.n1141 0.0238333
R3482 IOVSS.n1524 IOVSS.n1523 0.0238333
R3483 IOVSS.n1526 IOVSS.n1522 0.0238333
R3484 IOVSS.n1528 IOVSS.n1527 0.0238333
R3485 IOVSS.n1530 IOVSS.n1521 0.0238333
R3486 IOVSS.n1532 IOVSS.n1531 0.0238333
R3487 IOVSS.n1534 IOVSS.n1533 0.0238333
R3488 IOVSS.n1537 IOVSS.n1535 0.0238333
R3489 IOVSS.n1536 IOVSS.n1520 0.0238333
R3490 IOVSS.n1540 IOVSS.n1538 0.0238333
R3491 IOVSS.n1539 IOVSS.n1519 0.0238333
R3492 IOVSS.n1543 IOVSS.n1541 0.0238333
R3493 IOVSS.n1542 IOVSS.n1518 0.0238333
R3494 IOVSS.n1546 IOVSS.n1544 0.0238333
R3495 IOVSS.n1545 IOVSS.n1517 0.0238333
R3496 IOVSS.n1549 IOVSS.n1547 0.0238333
R3497 IOVSS.n1548 IOVSS.n1516 0.0238333
R3498 IOVSS.n1552 IOVSS.n1550 0.0238333
R3499 IOVSS.n1553 IOVSS.n1515 0.0238333
R3500 IOVSS.n1555 IOVSS.n1554 0.0238333
R3501 IOVSS.n1556 IOVSS.n1514 0.0238333
R3502 IOVSS.n1558 IOVSS.n1557 0.0238333
R3503 IOVSS.n1559 IOVSS.n1513 0.0238333
R3504 IOVSS.n1561 IOVSS.n1560 0.0238333
R3505 IOVSS.n1562 IOVSS.n1512 0.0238333
R3506 IOVSS.n1564 IOVSS.n1563 0.0238333
R3507 IOVSS.n1565 IOVSS.n1511 0.0238333
R3508 IOVSS.n1567 IOVSS.n1566 0.0238333
R3509 IOVSS.n1568 IOVSS.n1510 0.0238333
R3510 IOVSS.n1570 IOVSS.n1569 0.0238333
R3511 IOVSS.n1571 IOVSS.n1509 0.0238333
R3512 IOVSS.n1573 IOVSS.n1572 0.0238333
R3513 IOVSS.n1574 IOVSS.n1508 0.0238333
R3514 IOVSS.n1576 IOVSS.n1575 0.0238333
R3515 IOVSS.n1577 IOVSS.n1507 0.0238333
R3516 IOVSS.n1578 IOVSS.n1198 0.0238333
R3517 IOVSS.n836 IOVSS.n835 0.0237941
R3518 IOVSS.n838 IOVSS.n816 0.0237941
R3519 IOVSS.n841 IOVSS.n840 0.0237941
R3520 IOVSS.n843 IOVSS.n814 0.0237941
R3521 IOVSS.n846 IOVSS.n845 0.0237941
R3522 IOVSS.n848 IOVSS.n812 0.0237941
R3523 IOVSS.n1733 IOVSS.n810 0.0237941
R3524 IOVSS.n972 IOVSS.n969 0.0236579
R3525 IOVSS.n1310 IOVSS.n1306 0.0229637
R3526 IOVSS.n2051 IOVSS.n2047 0.02162
R3527 IOVSS.n2047 IOVSS.n217 0.02162
R3528 IOVSS.n2064 IOVSS.n217 0.02162
R3529 IOVSS.n2063 IOVSS.n218 0.02162
R3530 IOVSS.n2059 IOVSS.n218 0.02162
R3531 IOVSS.n2059 IOVSS.n2058 0.02162
R3532 IOVSS.n2057 IOVSS.n223 0.02162
R3533 IOVSS.n2053 IOVSS.n223 0.02162
R3534 IOVSS.n2053 IOVSS.n2052 0.02162
R3535 IOVSS.n2013 IOVSS.n2012 0.0209651
R3536 IOVSS.n1924 IOVSS.n1774 0.0209651
R3537 IOVSS.n1926 IOVSS.n1925 0.0209651
R3538 IOVSS.n1921 IOVSS.n1775 0.0209651
R3539 IOVSS.n1923 IOVSS.n1922 0.0209651
R3540 IOVSS.n1918 IOVSS.n1776 0.0209651
R3541 IOVSS.n1920 IOVSS.n1919 0.0209651
R3542 IOVSS.n1915 IOVSS.n1777 0.0209651
R3543 IOVSS.n1917 IOVSS.n1916 0.0209651
R3544 IOVSS.n1912 IOVSS.n1778 0.0209651
R3545 IOVSS.n1914 IOVSS.n1913 0.0209651
R3546 IOVSS.n1909 IOVSS.n1779 0.0209651
R3547 IOVSS.n1911 IOVSS.n1910 0.0209651
R3548 IOVSS.n1899 IOVSS.n1780 0.0209651
R3549 IOVSS.n1908 IOVSS.n1907 0.0209651
R3550 IOVSS.n1898 IOVSS.n1897 0.0209651
R3551 IOVSS.n1893 IOVSS.n1782 0.0209651
R3552 IOVSS.n2177 IOVSS.n2176 0.0209651
R3553 IOVSS.n2175 IOVSS.n2174 0.0209651
R3554 IOVSS.n2173 IOVSS.n2172 0.0209651
R3555 IOVSS.n2171 IOVSS.n2170 0.0209651
R3556 IOVSS.n2169 IOVSS.n2168 0.0209651
R3557 IOVSS.n2167 IOVSS.n2166 0.0209651
R3558 IOVSS.n2165 IOVSS.n2164 0.0209651
R3559 IOVSS.n2163 IOVSS.n2162 0.0209651
R3560 IOVSS.n2161 IOVSS.n2160 0.0209651
R3561 IOVSS.n2159 IOVSS.n2158 0.0209651
R3562 IOVSS.n2157 IOVSS.n2156 0.0209651
R3563 IOVSS.n2155 IOVSS.n2154 0.0209651
R3564 IOVSS.n2153 IOVSS.n2152 0.0209651
R3565 IOVSS.n2151 IOVSS.n2150 0.0209651
R3566 IOVSS.n2148 IOVSS.n2147 0.0209651
R3567 IOVSS.n2144 IOVSS.n2143 0.0209651
R3568 IOVSS.n2142 IOVSS.n2141 0.0209651
R3569 IOVSS.n182 IOVSS.n181 0.0208985
R3570 IOVSS.n184 IOVSS.n183 0.0208985
R3571 IOVSS.n864 IOVSS.n863 0.0205
R3572 IOVSS.n861 IOVSS.n851 0.0205
R3573 IOVSS.n573 IOVSS.n565 0.0205
R3574 IOVSS.n576 IOVSS.n564 0.0205
R3575 IOVSS.n577 IOVSS.n562 0.0205
R3576 IOVSS.n580 IOVSS.n560 0.0205
R3577 IOVSS.n581 IOVSS.n558 0.0205
R3578 IOVSS.n584 IOVSS.n556 0.0205
R3579 IOVSS.n585 IOVSS.n554 0.0205
R3580 IOVSS.n588 IOVSS.n552 0.0205
R3581 IOVSS.n589 IOVSS.n550 0.0205
R3582 IOVSS.n592 IOVSS.n548 0.0205
R3583 IOVSS.n593 IOVSS.n546 0.0205
R3584 IOVSS.n596 IOVSS.n544 0.0205
R3585 IOVSS.n597 IOVSS.n542 0.0205
R3586 IOVSS.n600 IOVSS.n540 0.0205
R3587 IOVSS.n601 IOVSS.n538 0.0205
R3588 IOVSS.n604 IOVSS.n536 0.0205
R3589 IOVSS.n605 IOVSS.n534 0.0205
R3590 IOVSS.n1763 IOVSS.n531 0.0205
R3591 IOVSS.n1766 IOVSS.n567 0.0205
R3592 IOVSS.n1765 IOVSS.n568 0.0205
R3593 IOVSS.n868 IOVSS.n569 0.0205
R3594 IOVSS.n1380 IOVSS.n1218 0.0202282
R3595 IOVSS.n1361 IOVSS.n1342 0.0202274
R3596 IOVSS.n1366 IOVSS.n1347 0.0202274
R3597 IOVSS.n1370 IOVSS.n1351 0.0202274
R3598 IOVSS.n1357 IOVSS.n1337 0.0202274
R3599 IOVSS.n1361 IOVSS.n1341 0.0202274
R3600 IOVSS.n1366 IOVSS.n1346 0.0202274
R3601 IOVSS.n1371 IOVSS.n1351 0.0202274
R3602 IOVSS.n1414 IOVSS.n1395 0.0202274
R3603 IOVSS.n1419 IOVSS.n1400 0.0202274
R3604 IOVSS.n1423 IOVSS.n1404 0.0202274
R3605 IOVSS.n1391 IOVSS.n1390 0.0202274
R3606 IOVSS.n1413 IOVSS.n1395 0.0202274
R3607 IOVSS.n1418 IOVSS.n1400 0.0202274
R3608 IOVSS.n1423 IOVSS.n1405 0.0202274
R3609 IOVSS.n1357 IOVSS.n1338 0.0200928
R3610 IOVSS.n1358 IOVSS.n1339 0.0200928
R3611 IOVSS.n1359 IOVSS.n1340 0.0200928
R3612 IOVSS.n1360 IOVSS.n1341 0.0200928
R3613 IOVSS.n1362 IOVSS.n1343 0.0200928
R3614 IOVSS.n1363 IOVSS.n1344 0.0200928
R3615 IOVSS.n1364 IOVSS.n1345 0.0200928
R3616 IOVSS.n1365 IOVSS.n1346 0.0200928
R3617 IOVSS.n1367 IOVSS.n1348 0.0200928
R3618 IOVSS.n1368 IOVSS.n1349 0.0200928
R3619 IOVSS.n1369 IOVSS.n1350 0.0200928
R3620 IOVSS.n1371 IOVSS.n1352 0.0200928
R3621 IOVSS.n1372 IOVSS.n1353 0.0200928
R3622 IOVSS.n1373 IOVSS.n1354 0.0200928
R3623 IOVSS.n1375 IOVSS.n1374 0.0200928
R3624 IOVSS.n1358 IOVSS.n1338 0.0200928
R3625 IOVSS.n1359 IOVSS.n1339 0.0200928
R3626 IOVSS.n1360 IOVSS.n1340 0.0200928
R3627 IOVSS.n1362 IOVSS.n1342 0.0200928
R3628 IOVSS.n1363 IOVSS.n1343 0.0200928
R3629 IOVSS.n1364 IOVSS.n1344 0.0200928
R3630 IOVSS.n1365 IOVSS.n1345 0.0200928
R3631 IOVSS.n1367 IOVSS.n1347 0.0200928
R3632 IOVSS.n1368 IOVSS.n1348 0.0200928
R3633 IOVSS.n1369 IOVSS.n1349 0.0200928
R3634 IOVSS.n1370 IOVSS.n1350 0.0200928
R3635 IOVSS.n1372 IOVSS.n1352 0.0200928
R3636 IOVSS.n1373 IOVSS.n1353 0.0200928
R3637 IOVSS.n1374 IOVSS.n1354 0.0200928
R3638 IOVSS.n1375 IOVSS.n1336 0.0200928
R3639 IOVSS.n1410 IOVSS.n1391 0.0200928
R3640 IOVSS.n1411 IOVSS.n1392 0.0200928
R3641 IOVSS.n1412 IOVSS.n1393 0.0200928
R3642 IOVSS.n1413 IOVSS.n1394 0.0200928
R3643 IOVSS.n1415 IOVSS.n1396 0.0200928
R3644 IOVSS.n1416 IOVSS.n1397 0.0200928
R3645 IOVSS.n1417 IOVSS.n1398 0.0200928
R3646 IOVSS.n1418 IOVSS.n1399 0.0200928
R3647 IOVSS.n1420 IOVSS.n1401 0.0200928
R3648 IOVSS.n1421 IOVSS.n1402 0.0200928
R3649 IOVSS.n1422 IOVSS.n1403 0.0200928
R3650 IOVSS.n1424 IOVSS.n1405 0.0200928
R3651 IOVSS.n1425 IOVSS.n1406 0.0200928
R3652 IOVSS.n1426 IOVSS.n1407 0.0200928
R3653 IOVSS.n1427 IOVSS.n1408 0.0200928
R3654 IOVSS.n1410 IOVSS.n1392 0.0200928
R3655 IOVSS.n1411 IOVSS.n1393 0.0200928
R3656 IOVSS.n1412 IOVSS.n1394 0.0200928
R3657 IOVSS.n1414 IOVSS.n1396 0.0200928
R3658 IOVSS.n1415 IOVSS.n1397 0.0200928
R3659 IOVSS.n1416 IOVSS.n1398 0.0200928
R3660 IOVSS.n1417 IOVSS.n1399 0.0200928
R3661 IOVSS.n1419 IOVSS.n1401 0.0200928
R3662 IOVSS.n1420 IOVSS.n1402 0.0200928
R3663 IOVSS.n1421 IOVSS.n1403 0.0200928
R3664 IOVSS.n1422 IOVSS.n1404 0.0200928
R3665 IOVSS.n1424 IOVSS.n1406 0.0200928
R3666 IOVSS.n1425 IOVSS.n1407 0.0200928
R3667 IOVSS.n1426 IOVSS.n1408 0.0200928
R3668 IOVSS.n1428 IOVSS.n1427 0.0200928
R3669 IOVSS.n178 IOVSS.n159 0.0194655
R3670 IOVSS.n173 IOVSS.n172 0.019002
R3671 IOVSS.n175 IOVSS.n174 0.019002
R3672 IOVSS.n1607 IOVSS.n1606 0.0176111
R3673 IOVSS.n166 IOVSS.n164 0.017569
R3674 IOVSS.n169 IOVSS.n163 0.017569
R3675 IOVSS.n676 IOVSS.n660 0.0174618
R3676 IOVSS.n670 IOVSS.n663 0.0174618
R3677 IOVSS.n675 IOVSS.n672 0.0172395
R3678 IOVSS.n669 IOVSS.n666 0.0172395
R3679 IOVSS.n1651 IOVSS.n655 0.0171667
R3680 IOVSS.n1648 IOVSS.n614 0.0171667
R3681 IOVSS.n1653 IOVSS.n653 0.0171667
R3682 IOVSS.n1646 IOVSS.n616 0.0171667
R3683 IOVSS.n1710 IOVSS.n651 0.0171667
R3684 IOVSS.n1709 IOVSS.n618 0.0171667
R3685 IOVSS.n1706 IOVSS.n649 0.0171667
R3686 IOVSS.n1704 IOVSS.n620 0.0171667
R3687 IOVSS.n1702 IOVSS.n647 0.0171667
R3688 IOVSS.n1700 IOVSS.n622 0.0171667
R3689 IOVSS.n1698 IOVSS.n645 0.0171667
R3690 IOVSS.n1696 IOVSS.n624 0.0171667
R3691 IOVSS.n1694 IOVSS.n643 0.0171667
R3692 IOVSS.n1692 IOVSS.n626 0.0171667
R3693 IOVSS.n1690 IOVSS.n641 0.0171667
R3694 IOVSS.n1688 IOVSS.n628 0.0171667
R3695 IOVSS.n1686 IOVSS.n639 0.0171667
R3696 IOVSS.n1684 IOVSS.n630 0.0171667
R3697 IOVSS.n1682 IOVSS.n637 0.0171667
R3698 IOVSS.n1680 IOVSS.n632 0.0171667
R3699 IOVSS.n1678 IOVSS.n635 0.0171667
R3700 IOVSS.n685 IOVSS.n610 0.0171667
R3701 IOVSS.n881 IOVSS.n855 0.0171355
R3702 IOVSS.n875 IOVSS.n858 0.0171355
R3703 IOVSS.n880 IOVSS.n877 0.0169176
R3704 IOVSS.n874 IOVSS.n871 0.0169176
R3705 IOVSS.n1729 IOVSS.n850 0.0168922
R3706 IOVSS.n1669 IOVSS.n1658 0.0166394
R3707 IOVSS.n1650 IOVSS.n658 0.0165324
R3708 IOVSS.n1664 IOVSS.n1661 0.0165202
R3709 IOVSS.n1673 IOVSS.n1657 0.0164283
R3710 IOVSS.n978 IOVSS.n975 0.0164211
R3711 IOVSS.n988 IOVSS.n986 0.0164211
R3712 IOVSS.n989 IOVSS.n946 0.0164211
R3713 IOVSS.n995 IOVSS.n945 0.0164211
R3714 IOVSS.n1003 IOVSS.n944 0.0164211
R3715 IOVSS.n1006 IOVSS.n1005 0.0164211
R3716 IOVSS.n1668 IOVSS.n1660 0.0163106
R3717 IOVSS.n870 IOVSS.n869 0.0162143
R3718 IOVSS.n869 IOVSS.n867 0.0162143
R3719 IOVSS.n1675 IOVSS.n1674 0.0157308
R3720 IOVSS.n220 IOVSS.n219 0.0156729
R3721 IOVSS.n1744 IOVSS.n221 0.0156729
R3722 IOVSS.n225 IOVSS.n224 0.0156729
R3723 IOVSS.n2045 IOVSS.n226 0.0156729
R3724 IOVSS.n2066 IOVSS.n215 0.0156729
R3725 IOVSS.n2048 IOVSS.n214 0.0156729
R3726 IOVSS.n168 IOVSS.n164 0.0156724
R3727 IOVSS.n171 IOVSS.n163 0.0156724
R3728 IOVSS.n1432 IOVSS.n1431 0.0150384
R3729 IOVSS.n974 IOVSS.n949 0.0149737
R3730 IOVSS.n977 IOVSS.n948 0.0149737
R3731 IOVSS.n984 IOVSS.n983 0.0149737
R3732 IOVSS.n971 IOVSS.n949 0.0147411
R3733 IOVSS.n1896 IOVSS 0.0141434
R3734 IOVSS IOVSS.n2145 0.0141434
R3735 IOVSS.n180 IOVSS.n159 0.0137759
R3736 IOVSS.n960 IOVSS.n954 0.0135263
R3737 IOVSS.n963 IOVSS.n952 0.0135263
R3738 IOVSS.n994 IOVSS.n992 0.0135263
R3739 IOVSS.n1002 IOVSS.n998 0.0135263
R3740 IOVSS.n968 IOVSS.n951 0.0132937
R3741 IOVSS.n966 IOVSS.n951 0.0132937
R3742 IOVSS.n972 IOVSS.n971 0.0132937
R3743 IOVSS.n1664 IOVSS.n1663 0.0130954
R3744 IOVSS.n1676 IOVSS.n1675 0.0121667
R3745 IOVSS.n1675 IOVSS.n573 0.0121667
R3746 IOVSS.n1596 IOVSS.n1593 0.0121667
R3747 IOVSS.n1596 IOVSS.n1595 0.0121667
R3748 IOVSS.n1612 IOVSS.n1611 0.0121667
R3749 IOVSS.n1611 IOVSS.n1610 0.0121667
R3750 IOVSS.n1717 IOVSS.n852 0.0121153
R3751 IOVSS.n962 IOVSS.n954 0.0120789
R3752 IOVSS.n965 IOVSS.n952 0.0120789
R3753 IOVSS.n1650 IOVSS.n684 0.0113333
R3754 IOVSS.n1651 IOVSS.n1650 0.0105
R3755 IOVSS.n1356 IOVSS.n1337 0.010431
R3756 IOVSS.n1429 IOVSS.n1390 0.010431
R3757 IOVSS.n1376 IOVSS.n1336 0.0102964
R3758 IOVSS.n1428 IOVSS.n1409 0.0102964
R3759 IOVSS.n975 IOVSS.n974 0.00918421
R3760 IOVSS.n978 IOVSS.n977 0.00918421
R3761 IOVSS.n984 IOVSS.n982 0.00918421
R3762 IOVSS.n986 IOVSS.n947 0.00918421
R3763 IOVSS.n989 IOVSS.n988 0.00918421
R3764 IOVSS.n991 IOVSS.n946 0.00918421
R3765 IOVSS.n995 IOVSS.n994 0.00918421
R3766 IOVSS.n997 IOVSS.n945 0.00918421
R3767 IOVSS.n1003 IOVSS.n1002 0.00918421
R3768 IOVSS.n1005 IOVSS.n944 0.00918421
R3769 IOVSS.n1007 IOVSS.n1006 0.00918421
R3770 IOVSS.n1750 IOVSS.n778 0.00911426
R3771 IOVSS.n1306 IOVSS.n1243 0.00864893
R3772 IOVSS.n1730 IOVSS.n1729 0.00740196
R3773 IOVSS IOVSS.n1781 0.00732171
R3774 IOVSS.n2146 IOVSS 0.00732171
R3775 IOVSS.n836 IOVSS.n816 0.00653922
R3776 IOVSS.n840 IOVSS.n838 0.00653922
R3777 IOVSS.n841 IOVSS.n814 0.00653922
R3778 IOVSS.n845 IOVSS.n843 0.00653922
R3779 IOVSS.n846 IOVSS.n812 0.00653922
R3780 IOVSS.n850 IOVSS.n848 0.00653922
R3781 IOVSS.n1730 IOVSS.n810 0.00653922
R3782 IOVSS.n1734 IOVSS.n1733 0.00653922
R3783 IOVSS.n1750 IOVSS.n777 0.00506818
R3784 IOVSS.n350 IOVSS.n349 0.00435043
R3785 IOVSS.n1755 IOVSS.n690 0.00395098
R3786 IOVSS.n823 IOVSS.n691 0.00395098
R3787 IOVSS.n826 IOVSS.n825 0.00395098
R3788 IOVSS.n828 IOVSS.n820 0.00395098
R3789 IOVSS.n831 IOVSS.n830 0.00395098
R3790 IOVSS.n833 IOVSS.n818 0.00395098
R3791 IOVSS.n2227 IOVSS.n18 0.0039227
R3792 IOVSS.n1306 IOVSS.n1276 0.0038593
R3793 IOVSS.n1715 IOVSS.n852 0.00375453
R3794 IOVSS.n992 IOVSS.n991 0.00339474
R3795 IOVSS.n998 IOVSS.n997 0.00339474
R3796 IOVSS.n2227 IOVSS.n47 0.00301363
R3797 IOVSS.n1606 IOVSS.n1200 0.00294444
R3798 IOVSS.n1008 IOVSS.n1007 0.00267105
R3799 IOVSS.n1644 IOVSS.n853 0.00216667
R3800 IOVSS.n1449 IOVSS.n1378 0.00216667
R3801 IOVSS.n969 IOVSS.n968 0.00194737
R3802 IOVSS.n980 IOVSS.n948 0.00194737
R3803 IOVSS.n983 IOVSS.n947 0.00194737
R3804 IOVSS.n1640 IOVSS.n1023 0.00170773
R3805 IOVSS.n993 IOVSS.n911 0.00166667
R3806 IOVSS.n2100 IOVSS.n45 0.00166667
R3807 IOVSS.n322 IOVSS.n310 0.00166667
R3808 IOVSS.n395 IOVSS.n234 0.00166667
R3809 IOVSS.n381 IOVSS.n248 0.00166667
R3810 IOVSS.n862 IOVSS.n529 0.00166667
R3811 IOVSS.n1720 IOVSS.n607 0.00166667
R3812 IOVSS.n1997 IOVSS.n406 0.00166667
R3813 IOVSS.n1381 IOVSS.n1212 0.00166667
R3814 IOVSS.n1460 IOVSS.n1459 0.00166667
R3815 IOVSS.n1580 IOVSS.n1506 0.00166667
R3816 IOVSS.n1586 IOVSS.n1113 0.00166667
R3817 IOVSS.n36 IOVSS.n8 0.00166667
R3818 IOVSS.n1643 IOVSS.n853 0.0015
R3819 IOVSS.n1307 IOVSS.n1306 0.00149476
R3820 IOVSS.n1309 IOVSS.n1306 0.00149428
R3821 IOVSS.n1308 IOVSS.n1306 0.00140751
R3822 IOVSS.n1908 IOVSS.n1906 0.00135271
R3823 IOVSS.n2149 IOVSS.n2148 0.00135271
R3824 IOVSS.n406 IOVSS.n229 0.00133332
R3825 IOVSS.n2027 IOVSS.n248 0.00133332
R3826 IOVSS.n350 IOVSS.n310 0.00133332
R3827 IOVSS.n395 IOVSS.n233 0.00133332
R3828 IOVSS.n1761 IOVSS.n607 0.00133332
R3829 IOVSS.n1644 IOVSS.n852 0.00133332
R3830 IOVSS.n529 IOVSS.n523 0.00133332
R3831 IOVSS.n1618 IOVSS.n1113 0.00133332
R3832 IOVSS.n1580 IOVSS.n1579 0.00133332
R3833 IOVSS.n1501 IOVSS.n1212 0.00133332
R3834 IOVSS.n1460 IOVSS.n1023 0.00133332
R3835 IOVSS.n1001 IOVSS.n911 0.00133332
R3836 IOVSS.n2227 IOVSS.n45 0.00133332
R3837 IOVSS.n36 IOVSS.n7 0.00133332
R3838 IOVSS.n1614 IOVSS.n1140 0.00120806
R3839 IOVSS.n1582 IOVSS.n1099 0.00117701
R3840 IOVSS.n1614 IOVSS.n1139 0.00117701
R3841 IOVSS.n2227 IOVSS.n46 0.00111372
R3842 IOVSS.n1750 IOVSS.n779 0.00111362
R3843 IOVSS.n2227 IOVSS.n2226 0.00109266
R3844 IOVSS.n1773 IOVSS.n523 0.00104109
R3845 IOVSS.n1583 IOVSS.n1099 0.0010403
R3846 IOVSS.n2086 IOVSS.n105 0.001
R3847 IOVSS.n958 IOVSS.n912 0.001
R3848 IOVSS.n961 IOVSS.n913 0.001
R3849 IOVSS.n964 IOVSS.n914 0.001
R3850 IOVSS.n967 IOVSS.n915 0.001
R3851 IOVSS.n970 IOVSS.n916 0.001
R3852 IOVSS.n976 IOVSS.n917 0.001
R3853 IOVSS.n985 IOVSS.n918 0.001
R3854 IOVSS.n990 IOVSS.n919 0.001
R3855 IOVSS.n996 IOVSS.n920 0.001
R3856 IOVSS.n1004 IOVSS.n921 0.001
R3857 IOVSS.n923 IOVSS.n922 0.001
R3858 IOVSS.n1013 IOVSS.n1011 0.001
R3859 IOVSS.n1012 IOVSS.n211 0.001
R3860 IOVSS.n2087 IOVSS.n103 0.001
R3861 IOVSS.n103 IOVSS.n90 0.001
R3862 IOVSS.n167 IOVSS.n91 0.001
R3863 IOVSS.n170 IOVSS.n92 0.001
R3864 IOVSS.n162 IOVSS.n93 0.001
R3865 IOVSS.n161 IOVSS.n94 0.001
R3866 IOVSS.n160 IOVSS.n95 0.001
R3867 IOVSS.n179 IOVSS.n96 0.001
R3868 IOVSS.n158 IOVSS.n97 0.001
R3869 IOVSS.n157 IOVSS.n98 0.001
R3870 IOVSS.n156 IOVSS.n99 0.001
R3871 IOVSS.n155 IOVSS.n100 0.001
R3872 IOVSS.n154 IOVSS.n101 0.001
R3873 IOVSS.n153 IOVSS.n102 0.001
R3874 IOVSS.n1020 IOVSS.n893 0.001
R3875 IOVSS.n893 IOVSS.n882 0.001
R3876 IOVSS.n925 IOVSS.n883 0.001
R3877 IOVSS.n927 IOVSS.n884 0.001
R3878 IOVSS.n929 IOVSS.n885 0.001
R3879 IOVSS.n931 IOVSS.n886 0.001
R3880 IOVSS.n933 IOVSS.n887 0.001
R3881 IOVSS.n935 IOVSS.n888 0.001
R3882 IOVSS.n937 IOVSS.n889 0.001
R3883 IOVSS.n939 IOVSS.n890 0.001
R3884 IOVSS.n941 IOVSS.n891 0.001
R3885 IOVSS.n1016 IOVSS.n901 0.001
R3886 IOVSS.n903 IOVSS.n901 0.001
R3887 IOVSS.n955 IOVSS.n904 0.001
R3888 IOVSS.n953 IOVSS.n905 0.001
R3889 IOVSS.n950 IOVSS.n906 0.001
R3890 IOVSS.n973 IOVSS.n907 0.001
R3891 IOVSS.n979 IOVSS.n908 0.001
R3892 IOVSS.n981 IOVSS.n909 0.001
R3893 IOVSS.n987 IOVSS.n910 0.001
R3894 IOVSS.n2100 IOVSS.n2090 0.001
R3895 IOVSS.n2102 IOVSS.n2091 0.001
R3896 IOVSS.n2104 IOVSS.n2092 0.001
R3897 IOVSS.n2106 IOVSS.n2093 0.001
R3898 IOVSS.n2108 IOVSS.n2094 0.001
R3899 IOVSS.n2110 IOVSS.n2095 0.001
R3900 IOVSS.n2112 IOVSS.n2096 0.001
R3901 IOVSS.n2114 IOVSS.n2097 0.001
R3902 IOVSS.n2116 IOVSS.n2098 0.001
R3903 IOVSS.n2118 IOVSS.n2099 0.001
R3904 IOVSS.n2180 IOVSS.n2179 0.001
R3905 IOVSS.n822 IOVSS.n687 0.001
R3906 IOVSS.n822 IOVSS.n821 0.001
R3907 IOVSS.n827 IOVSS.n819 0.001
R3908 IOVSS.n832 IOVSS.n817 0.001
R3909 IOVSS.n837 IOVSS.n815 0.001
R3910 IOVSS.n842 IOVSS.n813 0.001
R3911 IOVSS.n847 IOVSS.n811 0.001
R3912 IOVSS.n1732 IOVSS.n1731 0.001
R3913 IOVSS.n1751 IOVSS.n725 0.001
R3914 IOVSS.n725 IOVSS.n695 0.001
R3915 IOVSS.n774 IOVSS.n696 0.001
R3916 IOVSS.n772 IOVSS.n697 0.001
R3917 IOVSS.n770 IOVSS.n698 0.001
R3918 IOVSS.n768 IOVSS.n699 0.001
R3919 IOVSS.n766 IOVSS.n700 0.001
R3920 IOVSS.n764 IOVSS.n701 0.001
R3921 IOVSS.n762 IOVSS.n702 0.001
R3922 IOVSS.n760 IOVSS.n703 0.001
R3923 IOVSS.n758 IOVSS.n704 0.001
R3924 IOVSS.n756 IOVSS.n705 0.001
R3925 IOVSS.n754 IOVSS.n706 0.001
R3926 IOVSS.n752 IOVSS.n707 0.001
R3927 IOVSS.n750 IOVSS.n708 0.001
R3928 IOVSS.n748 IOVSS.n709 0.001
R3929 IOVSS.n746 IOVSS.n710 0.001
R3930 IOVSS.n744 IOVSS.n711 0.001
R3931 IOVSS.n1753 IOVSS.n693 0.001
R3932 IOVSS.n1754 IOVSS.n692 0.001
R3933 IOVSS.n824 IOVSS.n712 0.001
R3934 IOVSS.n829 IOVSS.n713 0.001
R3935 IOVSS.n834 IOVSS.n714 0.001
R3936 IOVSS.n839 IOVSS.n715 0.001
R3937 IOVSS.n844 IOVSS.n716 0.001
R3938 IOVSS.n849 IOVSS.n717 0.001
R3939 IOVSS.n808 IOVSS.n718 0.001
R3940 IOVSS.n807 IOVSS.n719 0.001
R3941 IOVSS.n806 IOVSS.n720 0.001
R3942 IOVSS.n805 IOVSS.n721 0.001
R3943 IOVSS.n804 IOVSS.n722 0.001
R3944 IOVSS.n1750 IOVSS.n726 0.001
R3945 IOVSS.n1747 IOVSS.n789 0.001
R3946 IOVSS.n1748 IOVSS.n787 0.001
R3947 IOVSS.n1623 IOVSS.n1061 0.001
R3948 IOVSS.n1061 IOVSS.n1055 0.001
R3949 IOVSS.n1062 IOVSS.n1056 0.001
R3950 IOVSS.n1063 IOVSS.n1057 0.001
R3951 IOVSS.n1064 IOVSS.n1058 0.001
R3952 IOVSS.n1065 IOVSS.n1059 0.001
R3953 IOVSS.n1625 IOVSS.n1053 0.001
R3954 IOVSS.n1621 IOVSS.n1081 0.001
R3955 IOVSS.n1083 IOVSS.n1081 0.001
R3956 IOVSS.n1090 IOVSS.n1084 0.001
R3957 IOVSS.n1089 IOVSS.n1085 0.001
R3958 IOVSS.n1088 IOVSS.n1086 0.001
R3959 IOVSS.n1098 IOVSS.n1087 0.001
R3960 IOVSS.n1097 IOVSS.n1045 0.001
R3961 IOVSS.n2020 IOVSS.n441 0.001
R3962 IOVSS.n441 IOVSS.n407 0.001
R3963 IOVSS.n1932 IOVSS.n408 0.001
R3964 IOVSS.n1934 IOVSS.n409 0.001
R3965 IOVSS.n1936 IOVSS.n410 0.001
R3966 IOVSS.n1938 IOVSS.n411 0.001
R3967 IOVSS.n1940 IOVSS.n412 0.001
R3968 IOVSS.n1942 IOVSS.n413 0.001
R3969 IOVSS.n1944 IOVSS.n414 0.001
R3970 IOVSS.n1946 IOVSS.n415 0.001
R3971 IOVSS.n1948 IOVSS.n416 0.001
R3972 IOVSS.n1950 IOVSS.n417 0.001
R3973 IOVSS.n1952 IOVSS.n418 0.001
R3974 IOVSS.n1954 IOVSS.n419 0.001
R3975 IOVSS.n1956 IOVSS.n420 0.001
R3976 IOVSS.n1958 IOVSS.n421 0.001
R3977 IOVSS.n1960 IOVSS.n422 0.001
R3978 IOVSS.n1963 IOVSS.n423 0.001
R3979 IOVSS.n1965 IOVSS.n424 0.001
R3980 IOVSS.n1967 IOVSS.n425 0.001
R3981 IOVSS.n1969 IOVSS.n426 0.001
R3982 IOVSS.n1971 IOVSS.n427 0.001
R3983 IOVSS.n1973 IOVSS.n428 0.001
R3984 IOVSS.n1975 IOVSS.n429 0.001
R3985 IOVSS.n1977 IOVSS.n430 0.001
R3986 IOVSS.n1979 IOVSS.n431 0.001
R3987 IOVSS.n1981 IOVSS.n432 0.001
R3988 IOVSS.n1983 IOVSS.n433 0.001
R3989 IOVSS.n1985 IOVSS.n434 0.001
R3990 IOVSS.n1987 IOVSS.n435 0.001
R3991 IOVSS.n1989 IOVSS.n436 0.001
R3992 IOVSS.n1991 IOVSS.n437 0.001
R3993 IOVSS.n1993 IOVSS.n438 0.001
R3994 IOVSS.n1995 IOVSS.n439 0.001
R3995 IOVSS.n2018 IOVSS.n489 0.001
R3996 IOVSS.n490 IOVSS.n489 0.001
R3997 IOVSS.n1844 IOVSS.n491 0.001
R3998 IOVSS.n1843 IOVSS.n492 0.001
R3999 IOVSS.n1842 IOVSS.n493 0.001
R4000 IOVSS.n1841 IOVSS.n494 0.001
R4001 IOVSS.n1840 IOVSS.n495 0.001
R4002 IOVSS.n1839 IOVSS.n496 0.001
R4003 IOVSS.n1838 IOVSS.n497 0.001
R4004 IOVSS.n1837 IOVSS.n498 0.001
R4005 IOVSS.n1836 IOVSS.n499 0.001
R4006 IOVSS.n1835 IOVSS.n500 0.001
R4007 IOVSS.n1834 IOVSS.n501 0.001
R4008 IOVSS.n1833 IOVSS.n502 0.001
R4009 IOVSS.n1832 IOVSS.n503 0.001
R4010 IOVSS.n1831 IOVSS.n504 0.001
R4011 IOVSS.n1830 IOVSS.n505 0.001
R4012 IOVSS.n1862 IOVSS.n506 0.001
R4013 IOVSS.n1825 IOVSS.n507 0.001
R4014 IOVSS.n1824 IOVSS.n508 0.001
R4015 IOVSS.n1823 IOVSS.n509 0.001
R4016 IOVSS.n1822 IOVSS.n510 0.001
R4017 IOVSS.n1821 IOVSS.n511 0.001
R4018 IOVSS.n1820 IOVSS.n512 0.001
R4019 IOVSS.n1819 IOVSS.n513 0.001
R4020 IOVSS.n1818 IOVSS.n514 0.001
R4021 IOVSS.n1817 IOVSS.n515 0.001
R4022 IOVSS.n1816 IOVSS.n516 0.001
R4023 IOVSS.n1815 IOVSS.n517 0.001
R4024 IOVSS.n1814 IOVSS.n518 0.001
R4025 IOVSS.n1813 IOVSS.n519 0.001
R4026 IOVSS.n1812 IOVSS.n520 0.001
R4027 IOVSS.n1811 IOVSS.n521 0.001
R4028 IOVSS.n1810 IOVSS.n522 0.001
R4029 IOVSS.n1997 IOVSS.n397 0.001
R4030 IOVSS.n1998 IOVSS.n398 0.001
R4031 IOVSS.n1999 IOVSS.n399 0.001
R4032 IOVSS.n2000 IOVSS.n400 0.001
R4033 IOVSS.n2001 IOVSS.n401 0.001
R4034 IOVSS.n2002 IOVSS.n402 0.001
R4035 IOVSS.n2003 IOVSS.n403 0.001
R4036 IOVSS.n405 IOVSS.n404 0.001
R4037 IOVSS.n376 IOVSS.n250 0.001
R4038 IOVSS.n376 IOVSS.n292 0.001
R4039 IOVSS.n373 IOVSS.n294 0.001
R4040 IOVSS.n370 IOVSS.n296 0.001
R4041 IOVSS.n367 IOVSS.n298 0.001
R4042 IOVSS.n364 IOVSS.n300 0.001
R4043 IOVSS.n361 IOVSS.n302 0.001
R4044 IOVSS.n358 IOVSS.n304 0.001
R4045 IOVSS.n355 IOVSS.n306 0.001
R4046 IOVSS.n340 IOVSS.n311 0.001
R4047 IOVSS.n312 IOVSS.n311 0.001
R4048 IOVSS.n314 IOVSS.n313 0.001
R4049 IOVSS.n316 IOVSS.n315 0.001
R4050 IOVSS.n318 IOVSS.n317 0.001
R4051 IOVSS.n320 IOVSS.n319 0.001
R4052 IOVSS.n323 IOVSS.n321 0.001
R4053 IOVSS.n336 IOVSS.n335 0.001
R4054 IOVSS.n333 IOVSS.n326 0.001
R4055 IOVSS.n2026 IOVSS.n240 0.001
R4056 IOVSS.n389 IOVSS.n240 0.001
R4057 IOVSS.n390 IOVSS.n239 0.001
R4058 IOVSS.n391 IOVSS.n238 0.001
R4059 IOVSS.n392 IOVSS.n237 0.001
R4060 IOVSS.n393 IOVSS.n236 0.001
R4061 IOVSS.n394 IOVSS.n235 0.001
R4062 IOVSS.n380 IOVSS.n379 0.001
R4063 IOVSS.n2027 IOVSS.n2026 0.001
R4064 IOVSS.n381 IOVSS.n380 0.001
R4065 IOVSS.n350 IOVSS.n340 0.001
R4066 IOVSS.n323 IOVSS.n322 0.001
R4067 IOVSS.n321 IOVSS.n320 0.001
R4068 IOVSS.n319 IOVSS.n318 0.001
R4069 IOVSS.n317 IOVSS.n316 0.001
R4070 IOVSS.n315 IOVSS.n314 0.001
R4071 IOVSS.n313 IOVSS.n312 0.001
R4072 IOVSS.n379 IOVSS.n250 0.001
R4073 IOVSS.n373 IOVSS.n292 0.001
R4074 IOVSS.n370 IOVSS.n294 0.001
R4075 IOVSS.n367 IOVSS.n296 0.001
R4076 IOVSS.n364 IOVSS.n298 0.001
R4077 IOVSS.n361 IOVSS.n300 0.001
R4078 IOVSS.n358 IOVSS.n302 0.001
R4079 IOVSS.n355 IOVSS.n304 0.001
R4080 IOVSS.n394 IOVSS.n234 0.001
R4081 IOVSS.n393 IOVSS.n235 0.001
R4082 IOVSS.n392 IOVSS.n236 0.001
R4083 IOVSS.n391 IOVSS.n237 0.001
R4084 IOVSS.n390 IOVSS.n238 0.001
R4085 IOVSS.n389 IOVSS.n239 0.001
R4086 IOVSS.n333 IOVSS.n233 0.001
R4087 IOVSS.n335 IOVSS.n326 0.001
R4088 IOVSS.n336 IOVSS.n306 0.001
R4089 IOVSS.n1758 IOVSS.n681 0.001
R4090 IOVSS.n1712 IOVSS.n533 0.001
R4091 IOVSS.n1768 IOVSS.n530 0.001
R4092 IOVSS.n530 IOVSS.n526 0.001
R4093 IOVSS.n865 IOVSS.n527 0.001
R4094 IOVSS.n866 IOVSS.n528 0.001
R4095 IOVSS.n1720 IOVSS.n1719 0.001
R4096 IOVSS.n1643 IOVSS.n854 0.001
R4097 IOVSS.n1764 IOVSS.n572 0.001
R4098 IOVSS.n852 IOVSS.n570 0.001
R4099 IOVSS.n1761 IOVSS.n572 0.001
R4100 IOVSS.n1767 IOVSS.n533 0.001
R4101 IOVSS.n1998 IOVSS.n397 0.001
R4102 IOVSS.n1999 IOVSS.n398 0.001
R4103 IOVSS.n2000 IOVSS.n399 0.001
R4104 IOVSS.n2001 IOVSS.n400 0.001
R4105 IOVSS.n2002 IOVSS.n401 0.001
R4106 IOVSS.n2003 IOVSS.n402 0.001
R4107 IOVSS.n404 IOVSS.n403 0.001
R4108 IOVSS.n405 IOVSS.n229 0.001
R4109 IOVSS.n2019 IOVSS.n2018 0.001
R4110 IOVSS.n2020 IOVSS.n2019 0.001
R4111 IOVSS.n1932 IOVSS.n407 0.001
R4112 IOVSS.n1934 IOVSS.n408 0.001
R4113 IOVSS.n1936 IOVSS.n409 0.001
R4114 IOVSS.n1938 IOVSS.n410 0.001
R4115 IOVSS.n1940 IOVSS.n411 0.001
R4116 IOVSS.n1942 IOVSS.n412 0.001
R4117 IOVSS.n1944 IOVSS.n413 0.001
R4118 IOVSS.n1946 IOVSS.n414 0.001
R4119 IOVSS.n1948 IOVSS.n415 0.001
R4120 IOVSS.n1950 IOVSS.n416 0.001
R4121 IOVSS.n1952 IOVSS.n417 0.001
R4122 IOVSS.n1954 IOVSS.n418 0.001
R4123 IOVSS.n1956 IOVSS.n419 0.001
R4124 IOVSS.n1958 IOVSS.n420 0.001
R4125 IOVSS.n1960 IOVSS.n421 0.001
R4126 IOVSS.n1963 IOVSS.n422 0.001
R4127 IOVSS.n1965 IOVSS.n423 0.001
R4128 IOVSS.n1967 IOVSS.n424 0.001
R4129 IOVSS.n1969 IOVSS.n425 0.001
R4130 IOVSS.n1971 IOVSS.n426 0.001
R4131 IOVSS.n1973 IOVSS.n427 0.001
R4132 IOVSS.n1975 IOVSS.n428 0.001
R4133 IOVSS.n1977 IOVSS.n429 0.001
R4134 IOVSS.n1979 IOVSS.n430 0.001
R4135 IOVSS.n1981 IOVSS.n431 0.001
R4136 IOVSS.n1983 IOVSS.n432 0.001
R4137 IOVSS.n1985 IOVSS.n433 0.001
R4138 IOVSS.n1987 IOVSS.n434 0.001
R4139 IOVSS.n1989 IOVSS.n435 0.001
R4140 IOVSS.n1991 IOVSS.n436 0.001
R4141 IOVSS.n1993 IOVSS.n437 0.001
R4142 IOVSS.n1995 IOVSS.n438 0.001
R4143 IOVSS.n1810 IOVSS.n521 0.001
R4144 IOVSS.n1811 IOVSS.n520 0.001
R4145 IOVSS.n1812 IOVSS.n519 0.001
R4146 IOVSS.n1813 IOVSS.n518 0.001
R4147 IOVSS.n1814 IOVSS.n517 0.001
R4148 IOVSS.n1815 IOVSS.n516 0.001
R4149 IOVSS.n1816 IOVSS.n515 0.001
R4150 IOVSS.n1817 IOVSS.n514 0.001
R4151 IOVSS.n1818 IOVSS.n513 0.001
R4152 IOVSS.n1819 IOVSS.n512 0.001
R4153 IOVSS.n1820 IOVSS.n511 0.001
R4154 IOVSS.n1821 IOVSS.n510 0.001
R4155 IOVSS.n1822 IOVSS.n509 0.001
R4156 IOVSS.n1823 IOVSS.n508 0.001
R4157 IOVSS.n1824 IOVSS.n507 0.001
R4158 IOVSS.n1825 IOVSS.n506 0.001
R4159 IOVSS.n1862 IOVSS.n505 0.001
R4160 IOVSS.n1830 IOVSS.n504 0.001
R4161 IOVSS.n1831 IOVSS.n503 0.001
R4162 IOVSS.n1832 IOVSS.n502 0.001
R4163 IOVSS.n1833 IOVSS.n501 0.001
R4164 IOVSS.n1834 IOVSS.n500 0.001
R4165 IOVSS.n1835 IOVSS.n499 0.001
R4166 IOVSS.n1836 IOVSS.n498 0.001
R4167 IOVSS.n1837 IOVSS.n497 0.001
R4168 IOVSS.n1838 IOVSS.n496 0.001
R4169 IOVSS.n1839 IOVSS.n495 0.001
R4170 IOVSS.n1840 IOVSS.n494 0.001
R4171 IOVSS.n1841 IOVSS.n493 0.001
R4172 IOVSS.n1842 IOVSS.n492 0.001
R4173 IOVSS.n1843 IOVSS.n491 0.001
R4174 IOVSS.n1844 IOVSS.n490 0.001
R4175 IOVSS.n2014 IOVSS.n522 0.001
R4176 IOVSS.n2014 IOVSS.n439 0.001
R4177 IOVSS.n1764 IOVSS.n570 0.001
R4178 IOVSS.n1719 IOVSS.n854 0.001
R4179 IOVSS.n1768 IOVSS.n1767 0.001
R4180 IOVSS.n865 IOVSS.n526 0.001
R4181 IOVSS.n866 IOVSS.n527 0.001
R4182 IOVSS.n862 IOVSS.n528 0.001
R4183 IOVSS.n1219 IOVSS.n1216 0.001
R4184 IOVSS.n1311 IOVSS.n1219 0.001
R4185 IOVSS.n1312 IOVSS.n1220 0.001
R4186 IOVSS.n1313 IOVSS.n1221 0.001
R4187 IOVSS.n1314 IOVSS.n1222 0.001
R4188 IOVSS.n1315 IOVSS.n1223 0.001
R4189 IOVSS.n1316 IOVSS.n1224 0.001
R4190 IOVSS.n1317 IOVSS.n1225 0.001
R4191 IOVSS.n1318 IOVSS.n1226 0.001
R4192 IOVSS.n1319 IOVSS.n1227 0.001
R4193 IOVSS.n1320 IOVSS.n1228 0.001
R4194 IOVSS.n1321 IOVSS.n1229 0.001
R4195 IOVSS.n1322 IOVSS.n1230 0.001
R4196 IOVSS.n1323 IOVSS.n1231 0.001
R4197 IOVSS.n1324 IOVSS.n1232 0.001
R4198 IOVSS.n1325 IOVSS.n1233 0.001
R4199 IOVSS.n1326 IOVSS.n1234 0.001
R4200 IOVSS.n1327 IOVSS.n1235 0.001
R4201 IOVSS.n1328 IOVSS.n1236 0.001
R4202 IOVSS.n1329 IOVSS.n1237 0.001
R4203 IOVSS.n1330 IOVSS.n1238 0.001
R4204 IOVSS.n1331 IOVSS.n1239 0.001
R4205 IOVSS.n1242 IOVSS.n1240 0.001
R4206 IOVSS.n1335 IOVSS.n1334 0.001
R4207 IOVSS.n1382 IOVSS.n1381 0.001
R4208 IOVSS.n1463 IOVSS.n1462 0.001
R4209 IOVSS.n1384 IOVSS.n1383 0.001
R4210 IOVSS.n1614 IOVSS.n1142 0.001
R4211 IOVSS.n1525 IOVSS.n1504 0.001
R4212 IOVSS.n1529 IOVSS.n1505 0.001
R4213 IOVSS.n1614 IOVSS.n1196 0.001
R4214 IOVSS.n1209 IOVSS.n1099 0.001
R4215 IOVSS.n1210 IOVSS.n1207 0.001
R4216 IOVSS.n1585 IOVSS.n1208 0.001
R4217 IOVSS.n1101 IOVSS.n1099 0.001
R4218 IOVSS.n1033 IOVSS.n1032 0.001
R4219 IOVSS.n1030 IOVSS.n1029 0.001
R4220 IOVSS.n1637 IOVSS.n1026 0.001
R4221 IOVSS.n1638 IOVSS.n1025 0.001
R4222 IOVSS.n1209 IOVSS.n1207 0.001
R4223 IOVSS.n1210 IOVSS.n1208 0.001
R4224 IOVSS.n1586 IOVSS.n1585 0.001
R4225 IOVSS.n1525 IOVSS.n1142 0.001
R4226 IOVSS.n1529 IOVSS.n1504 0.001
R4227 IOVSS.n1506 IOVSS.n1505 0.001
R4228 IOVSS.n1463 IOVSS.n1382 0.001
R4229 IOVSS.n1462 IOVSS.n1383 0.001
R4230 IOVSS.n1459 IOVSS.n1384 0.001
R4231 IOVSS.n1501 IOVSS.n1216 0.001
R4232 IOVSS.n1311 IOVSS.n1220 0.001
R4233 IOVSS.n1312 IOVSS.n1221 0.001
R4234 IOVSS.n1313 IOVSS.n1222 0.001
R4235 IOVSS.n1314 IOVSS.n1223 0.001
R4236 IOVSS.n1315 IOVSS.n1224 0.001
R4237 IOVSS.n1316 IOVSS.n1225 0.001
R4238 IOVSS.n1317 IOVSS.n1226 0.001
R4239 IOVSS.n1318 IOVSS.n1227 0.001
R4240 IOVSS.n1319 IOVSS.n1228 0.001
R4241 IOVSS.n1320 IOVSS.n1229 0.001
R4242 IOVSS.n1321 IOVSS.n1230 0.001
R4243 IOVSS.n1322 IOVSS.n1231 0.001
R4244 IOVSS.n1323 IOVSS.n1232 0.001
R4245 IOVSS.n1324 IOVSS.n1233 0.001
R4246 IOVSS.n1325 IOVSS.n1234 0.001
R4247 IOVSS.n1326 IOVSS.n1235 0.001
R4248 IOVSS.n1327 IOVSS.n1236 0.001
R4249 IOVSS.n1328 IOVSS.n1237 0.001
R4250 IOVSS.n1329 IOVSS.n1238 0.001
R4251 IOVSS.n1330 IOVSS.n1239 0.001
R4252 IOVSS.n1331 IOVSS.n1240 0.001
R4253 IOVSS.n1335 IOVSS.n1242 0.001
R4254 IOVSS.n1334 IOVSS.n1033 0.001
R4255 IOVSS.n1622 IOVSS.n1621 0.001
R4256 IOVSS.n1623 IOVSS.n1622 0.001
R4257 IOVSS.n1062 IOVSS.n1055 0.001
R4258 IOVSS.n1063 IOVSS.n1056 0.001
R4259 IOVSS.n1064 IOVSS.n1057 0.001
R4260 IOVSS.n1065 IOVSS.n1058 0.001
R4261 IOVSS.n1059 IOVSS.n1053 0.001
R4262 IOVSS.n1098 IOVSS.n1097 0.001
R4263 IOVSS.n1087 IOVSS.n1086 0.001
R4264 IOVSS.n1088 IOVSS.n1085 0.001
R4265 IOVSS.n1089 IOVSS.n1084 0.001
R4266 IOVSS.n1090 IOVSS.n1083 0.001
R4267 IOVSS.n1626 IOVSS.n1045 0.001
R4268 IOVSS.n1626 IOVSS.n1625 0.001
R4269 IOVSS.n1025 IOVSS.n1023 0.001
R4270 IOVSS.n1638 IOVSS.n1637 0.001
R4271 IOVSS.n1029 IOVSS.n1026 0.001
R4272 IOVSS.n1032 IOVSS.n1030 0.001
R4273 IOVSS.n1618 IOVSS.n1101 0.001
R4274 IOVSS.n1579 IOVSS.n1196 0.001
R4275 IOVSS.n1751 IOVSS.n1750 0.001
R4276 IOVSS.n1758 IOVSS.n687 0.001
R4277 IOVSS.n1712 IOVSS.n681 0.001
R4278 IOVSS.n827 IOVSS.n821 0.001
R4279 IOVSS.n832 IOVSS.n819 0.001
R4280 IOVSS.n837 IOVSS.n817 0.001
R4281 IOVSS.n842 IOVSS.n815 0.001
R4282 IOVSS.n847 IOVSS.n813 0.001
R4283 IOVSS.n1732 IOVSS.n811 0.001
R4284 IOVSS.n1731 IOVSS.n523 0.001
R4285 IOVSS.n804 IOVSS.n721 0.001
R4286 IOVSS.n805 IOVSS.n720 0.001
R4287 IOVSS.n806 IOVSS.n719 0.001
R4288 IOVSS.n807 IOVSS.n718 0.001
R4289 IOVSS.n808 IOVSS.n717 0.001
R4290 IOVSS.n849 IOVSS.n716 0.001
R4291 IOVSS.n844 IOVSS.n715 0.001
R4292 IOVSS.n839 IOVSS.n714 0.001
R4293 IOVSS.n834 IOVSS.n713 0.001
R4294 IOVSS.n829 IOVSS.n712 0.001
R4295 IOVSS.n824 IOVSS.n692 0.001
R4296 IOVSS.n1754 IOVSS.n1753 0.001
R4297 IOVSS.n711 IOVSS.n693 0.001
R4298 IOVSS.n744 IOVSS.n710 0.001
R4299 IOVSS.n746 IOVSS.n709 0.001
R4300 IOVSS.n748 IOVSS.n708 0.001
R4301 IOVSS.n750 IOVSS.n707 0.001
R4302 IOVSS.n752 IOVSS.n706 0.001
R4303 IOVSS.n754 IOVSS.n705 0.001
R4304 IOVSS.n756 IOVSS.n704 0.001
R4305 IOVSS.n758 IOVSS.n703 0.001
R4306 IOVSS.n760 IOVSS.n702 0.001
R4307 IOVSS.n762 IOVSS.n701 0.001
R4308 IOVSS.n764 IOVSS.n700 0.001
R4309 IOVSS.n766 IOVSS.n699 0.001
R4310 IOVSS.n768 IOVSS.n698 0.001
R4311 IOVSS.n770 IOVSS.n697 0.001
R4312 IOVSS.n772 IOVSS.n696 0.001
R4313 IOVSS.n774 IOVSS.n695 0.001
R4314 IOVSS.n1742 IOVSS.n722 0.001
R4315 IOVSS.n1742 IOVSS.n787 0.001
R4316 IOVSS.n1748 IOVSS.n1747 0.001
R4317 IOVSS.n789 IOVSS.n726 0.001
R4318 IOVSS.n1019 IOVSS.n1016 0.001
R4319 IOVSS.n1020 IOVSS.n1019 0.001
R4320 IOVSS.n925 IOVSS.n882 0.001
R4321 IOVSS.n927 IOVSS.n883 0.001
R4322 IOVSS.n929 IOVSS.n884 0.001
R4323 IOVSS.n931 IOVSS.n885 0.001
R4324 IOVSS.n933 IOVSS.n886 0.001
R4325 IOVSS.n935 IOVSS.n887 0.001
R4326 IOVSS.n937 IOVSS.n888 0.001
R4327 IOVSS.n939 IOVSS.n889 0.001
R4328 IOVSS.n941 IOVSS.n890 0.001
R4329 IOVSS.n993 IOVSS.n910 0.001
R4330 IOVSS.n987 IOVSS.n909 0.001
R4331 IOVSS.n981 IOVSS.n908 0.001
R4332 IOVSS.n979 IOVSS.n907 0.001
R4333 IOVSS.n973 IOVSS.n906 0.001
R4334 IOVSS.n950 IOVSS.n905 0.001
R4335 IOVSS.n953 IOVSS.n904 0.001
R4336 IOVSS.n955 IOVSS.n903 0.001
R4337 IOVSS.n1001 IOVSS.n891 0.001
R4338 IOVSS.n2087 IOVSS.n2086 0.001
R4339 IOVSS.n958 IOVSS.n105 0.001
R4340 IOVSS.n961 IOVSS.n912 0.001
R4341 IOVSS.n964 IOVSS.n913 0.001
R4342 IOVSS.n967 IOVSS.n914 0.001
R4343 IOVSS.n970 IOVSS.n915 0.001
R4344 IOVSS.n976 IOVSS.n916 0.001
R4345 IOVSS.n985 IOVSS.n917 0.001
R4346 IOVSS.n990 IOVSS.n918 0.001
R4347 IOVSS.n996 IOVSS.n919 0.001
R4348 IOVSS.n1004 IOVSS.n920 0.001
R4349 IOVSS.n923 IOVSS.n921 0.001
R4350 IOVSS.n1011 IOVSS.n922 0.001
R4351 IOVSS.n1013 IOVSS.n1012 0.001
R4352 IOVSS.n153 IOVSS.n101 0.001
R4353 IOVSS.n154 IOVSS.n100 0.001
R4354 IOVSS.n155 IOVSS.n99 0.001
R4355 IOVSS.n156 IOVSS.n98 0.001
R4356 IOVSS.n157 IOVSS.n97 0.001
R4357 IOVSS.n158 IOVSS.n96 0.001
R4358 IOVSS.n179 IOVSS.n95 0.001
R4359 IOVSS.n160 IOVSS.n94 0.001
R4360 IOVSS.n161 IOVSS.n93 0.001
R4361 IOVSS.n162 IOVSS.n92 0.001
R4362 IOVSS.n170 IOVSS.n91 0.001
R4363 IOVSS.n167 IOVSS.n90 0.001
R4364 IOVSS.n2102 IOVSS.n2090 0.001
R4365 IOVSS.n2104 IOVSS.n2091 0.001
R4366 IOVSS.n2106 IOVSS.n2092 0.001
R4367 IOVSS.n2108 IOVSS.n2093 0.001
R4368 IOVSS.n2110 IOVSS.n2094 0.001
R4369 IOVSS.n2112 IOVSS.n2095 0.001
R4370 IOVSS.n2114 IOVSS.n2096 0.001
R4371 IOVSS.n2116 IOVSS.n2097 0.001
R4372 IOVSS.n2118 IOVSS.n2098 0.001
R4373 IOVSS.n2179 IOVSS.n2099 0.001
R4374 IOVSS.n2180 IOVSS.n7 0.001
R4375 IOVSS.n2228 IOVSS.n38 0.001
R4376 IOVSS.n38 IOVSS.n19 0.001
R4377 IOVSS.n75 IOVSS.n20 0.001
R4378 IOVSS.n73 IOVSS.n21 0.001
R4379 IOVSS.n71 IOVSS.n22 0.001
R4380 IOVSS.n69 IOVSS.n23 0.001
R4381 IOVSS.n67 IOVSS.n24 0.001
R4382 IOVSS.n65 IOVSS.n25 0.001
R4383 IOVSS.n63 IOVSS.n26 0.001
R4384 IOVSS.n61 IOVSS.n27 0.001
R4385 IOVSS.n59 IOVSS.n28 0.001
R4386 IOVSS.n57 IOVSS.n29 0.001
R4387 IOVSS.n55 IOVSS.n30 0.001
R4388 IOVSS.n53 IOVSS.n31 0.001
R4389 IOVSS.n51 IOVSS.n32 0.001
R4390 IOVSS.n49 IOVSS.n33 0.001
R4391 IOVSS.n2230 IOVSS.n17 0.001
R4392 IOVSS.n2231 IOVSS.n15 0.001
R4393 IOVSS.n34 IOVSS.n10 0.001
R4394 IOVSS.n35 IOVSS.n9 0.001
R4395 IOVSS.n2228 IOVSS.n2227 0.001
R4396 IOVSS.n35 IOVSS.n8 0.001
R4397 IOVSS.n34 IOVSS.n9 0.001
R4398 IOVSS.n15 IOVSS.n10 0.001
R4399 IOVSS.n2231 IOVSS.n2230 0.001
R4400 IOVSS.n33 IOVSS.n17 0.001
R4401 IOVSS.n49 IOVSS.n32 0.001
R4402 IOVSS.n51 IOVSS.n31 0.001
R4403 IOVSS.n53 IOVSS.n30 0.001
R4404 IOVSS.n55 IOVSS.n29 0.001
R4405 IOVSS.n57 IOVSS.n28 0.001
R4406 IOVSS.n59 IOVSS.n27 0.001
R4407 IOVSS.n61 IOVSS.n26 0.001
R4408 IOVSS.n63 IOVSS.n25 0.001
R4409 IOVSS.n65 IOVSS.n24 0.001
R4410 IOVSS.n67 IOVSS.n23 0.001
R4411 IOVSS.n69 IOVSS.n22 0.001
R4412 IOVSS.n71 IOVSS.n21 0.001
R4413 IOVSS.n73 IOVSS.n20 0.001
R4414 IOVSS.n75 IOVSS.n19 0.001
R4415 IOVSS.n2082 IOVSS.n2081 0.001
R4416 IOVSS.n2083 IOVSS.n102 0.001
R4417 IOVSS.n2083 IOVSS.n2082 0.001
R4418 IOVSS.n2081 IOVSS.n211 0.001
R4419 ldo_1v5_y_0.second_stage_1v5_0.dmv.n4 ldo_1v5_y_0.second_stage_1v5_0.dmv.t0 22.6054
R4420 ldo_1v5_y_0.second_stage_1v5_0.dmv.n3 ldo_1v5_y_0.second_stage_1v5_0.dmv.n2 19.0792
R4421 ldo_1v5_y_0.second_stage_1v5_0.dmv.n0 ldo_1v5_y_0.second_stage_1v5_0.dmv.t3 10.9662
R4422 ldo_1v5_y_0.second_stage_1v5_0.dmv.n2 ldo_1v5_y_0.second_stage_1v5_0.dmv.n0 8.89206
R4423 ldo_1v5_y_0.second_stage_1v5_0.dmv.n1 ldo_1v5_y_0.second_stage_1v5_0.dmv.t1 7.84467
R4424 ldo_1v5_y_0.second_stage_1v5_0.dmv.n1 ldo_1v5_y_0.second_stage_1v5_0.dmv.t2 4.58706
R4425 ldo_1v5_y_0.second_stage_1v5_0.dmv ldo_1v5_y_0.second_stage_1v5_0.dmv.n1 2.99419
R4426 ldo_1v5_y_0.second_stage_1v5_0.dmv.n4 ldo_1v5_y_0.second_stage_1v5_0.dmv.n3 1.30968
R4427 ldo_1v5_y_0.second_stage_1v5_0.dmv.n0 ldo_1v5_y_0.second_stage_1v5_0.dmv.t4 0.998067
R4428 ldo_1v5_y_0.second_stage_1v5_0.dmv.n2 ldo_1v5_y_0.second_stage_1v5_0.dmv 0.442192
R4429 ldo_1v5_y_0.second_stage_1v5_0.dmv.n3 ldo_1v5_y_0.second_stage_1v5_0.dmv.t5 0.24566
R4430 ldo_1v5_y_0.second_stage_1v5_0.dmv ldo_1v5_y_0.second_stage_1v5_0.dmv.n4 0.0319286
R4431 ldo_1v2_a_0.VDD.n1000 ldo_1v2_a_0.VDD.t149 17.2009
R4432 ldo_1v2_a_0.VDD.n397 ldo_1v2_a_0.VDD.t136 17.1682
R4433 ldo_1v2_a_0.VDD.n722 ldo_1v2_a_0.VDD.t34 17.0005
R4434 ldo_1v2_a_0.VDD.n493 ldo_1v2_a_0.VDD.t80 17.0005
R4435 ldo_1v2_a_0.VDD.t81 ldo_1v2_a_0.VDD.n491 17.0005
R4436 ldo_1v2_a_0.VDD.n497 ldo_1v2_a_0.VDD.t95 17.0005
R4437 ldo_1v2_a_0.VDD.t96 ldo_1v2_a_0.VDD.n495 17.0005
R4438 ldo_1v2_a_0.VDD.n530 ldo_1v2_a_0.VDD.t102 17.0005
R4439 ldo_1v2_a_0.VDD.t103 ldo_1v2_a_0.VDD.n528 17.0005
R4440 ldo_1v2_a_0.VDD.n534 ldo_1v2_a_0.VDD.t127 17.0005
R4441 ldo_1v2_a_0.VDD.t128 ldo_1v2_a_0.VDD.n532 17.0005
R4442 ldo_1v2_a_0.VDD.t130 ldo_1v2_a_0.VDD.n382 17.0005
R4443 ldo_1v2_a_0.VDD.n605 ldo_1v2_a_0.VDD.t130 17.0005
R4444 ldo_1v2_a_0.VDD.t152 ldo_1v2_a_0.VDD.n415 17.0005
R4445 ldo_1v2_a_0.VDD.n416 ldo_1v2_a_0.VDD.t152 17.0005
R4446 ldo_1v2_a_0.VDD.n456 ldo_1v2_a_0.VDD.n391 17.0005
R4447 ldo_1v2_a_0.VDD.t83 ldo_1v2_a_0.VDD.n631 17.0005
R4448 ldo_1v2_a_0.VDD.n632 ldo_1v2_a_0.VDD.t83 17.0005
R4449 ldo_1v2_a_0.VDD.n571 ldo_1v2_a_0.VDD.n567 17.0005
R4450 ldo_1v2_a_0.VDD.n587 ldo_1v2_a_0.VDD.n541 17.0005
R4451 ldo_1v2_a_0.VDD.n642 ldo_1v2_a_0.VDD.n330 17.0005
R4452 ldo_1v2_a_0.VDD.n379 ldo_1v2_a_0.VDD.n330 17.0005
R4453 ldo_1v2_a_0.VDD.n377 ldo_1v2_a_0.VDD.n330 17.0005
R4454 ldo_1v2_a_0.VDD.n375 ldo_1v2_a_0.VDD.n330 17.0005
R4455 ldo_1v2_a_0.VDD.n373 ldo_1v2_a_0.VDD.n330 17.0005
R4456 ldo_1v2_a_0.VDD.n371 ldo_1v2_a_0.VDD.n330 17.0005
R4457 ldo_1v2_a_0.VDD.n369 ldo_1v2_a_0.VDD.n330 17.0005
R4458 ldo_1v2_a_0.VDD.n367 ldo_1v2_a_0.VDD.n330 17.0005
R4459 ldo_1v2_a_0.VDD.n365 ldo_1v2_a_0.VDD.n330 17.0005
R4460 ldo_1v2_a_0.VDD.n363 ldo_1v2_a_0.VDD.n330 17.0005
R4461 ldo_1v2_a_0.VDD.n589 ldo_1v2_a_0.VDD.n330 17.0005
R4462 ldo_1v2_a_0.VDD.n665 ldo_1v2_a_0.VDD.n362 17.0005
R4463 ldo_1v2_a_0.VDD.n665 ldo_1v2_a_0.VDD.n364 17.0005
R4464 ldo_1v2_a_0.VDD.n665 ldo_1v2_a_0.VDD.n368 17.0005
R4465 ldo_1v2_a_0.VDD.n665 ldo_1v2_a_0.VDD.n370 17.0005
R4466 ldo_1v2_a_0.VDD.n665 ldo_1v2_a_0.VDD.n372 17.0005
R4467 ldo_1v2_a_0.VDD.n665 ldo_1v2_a_0.VDD.n374 17.0005
R4468 ldo_1v2_a_0.VDD.n665 ldo_1v2_a_0.VDD.n376 17.0005
R4469 ldo_1v2_a_0.VDD.n665 ldo_1v2_a_0.VDD.n378 17.0005
R4470 ldo_1v2_a_0.VDD.n665 ldo_1v2_a_0.VDD.n380 17.0005
R4471 ldo_1v2_a_0.VDD.n665 ldo_1v2_a_0.VDD.n643 17.0005
R4472 ldo_1v2_a_0.VDD.n712 ldo_1v2_a_0.VDD.n236 17.0005
R4473 ldo_1v2_a_0.VDD.t33 ldo_1v2_a_0.VDD.n235 17.0005
R4474 ldo_1v2_a_0.VDD.n250 ldo_1v2_a_0.VDD.n235 17.0005
R4475 ldo_1v2_a_0.VDD.t125 ldo_1v2_a_0.VDD.n200 17.0005
R4476 ldo_1v2_a_0.VDD.t125 ldo_1v2_a_0.VDD.n206 17.0005
R4477 ldo_1v2_a_0.VDD.n207 ldo_1v2_a_0.VDD.t125 17.0005
R4478 ldo_1v2_a_0.VDD.t124 ldo_1v2_a_0.VDD.n193 17.0005
R4479 ldo_1v2_a_0.VDD.n745 ldo_1v2_a_0.VDD.n233 17.0005
R4480 ldo_1v2_a_0.VDD.n745 ldo_1v2_a_0.VDD.n190 17.0005
R4481 ldo_1v2_a_0.VDD.n745 ldo_1v2_a_0.VDD.n232 17.0005
R4482 ldo_1v2_a_0.VDD.n745 ldo_1v2_a_0.VDD.n225 17.0005
R4483 ldo_1v2_a_0.VDD.n745 ldo_1v2_a_0.VDD.n224 17.0005
R4484 ldo_1v2_a_0.VDD.n745 ldo_1v2_a_0.VDD.n223 17.0005
R4485 ldo_1v2_a_0.VDD.n745 ldo_1v2_a_0.VDD.n222 17.0005
R4486 ldo_1v2_a_0.VDD.n745 ldo_1v2_a_0.VDD.n221 17.0005
R4487 ldo_1v2_a_0.VDD.n745 ldo_1v2_a_0.VDD.n188 17.0005
R4488 ldo_1v2_a_0.VDD.t89 ldo_1v2_a_0.VDD.n189 17.0005
R4489 ldo_1v2_a_0.VDD.t89 ldo_1v2_a_0.VDD.n226 17.0005
R4490 ldo_1v2_a_0.VDD.n231 ldo_1v2_a_0.VDD.t89 17.0005
R4491 ldo_1v2_a_0.VDD.n227 ldo_1v2_a_0.VDD.t89 17.0005
R4492 ldo_1v2_a_0.VDD.n230 ldo_1v2_a_0.VDD.t89 17.0005
R4493 ldo_1v2_a_0.VDD.n228 ldo_1v2_a_0.VDD.t89 17.0005
R4494 ldo_1v2_a_0.VDD.n229 ldo_1v2_a_0.VDD.t89 17.0005
R4495 ldo_1v2_a_0.VDD.t89 ldo_1v2_a_0.VDD.n187 17.0005
R4496 ldo_1v2_a_0.VDD.t89 ldo_1v2_a_0.VDD.n194 17.0005
R4497 ldo_1v2_a_0.VDD.t88 ldo_1v2_a_0.VDD.n189 17.0005
R4498 ldo_1v2_a_0.VDD.t88 ldo_1v2_a_0.VDD.n226 17.0005
R4499 ldo_1v2_a_0.VDD.n231 ldo_1v2_a_0.VDD.t88 17.0005
R4500 ldo_1v2_a_0.VDD.t88 ldo_1v2_a_0.VDD.n227 17.0005
R4501 ldo_1v2_a_0.VDD.t88 ldo_1v2_a_0.VDD.n230 17.0005
R4502 ldo_1v2_a_0.VDD.t88 ldo_1v2_a_0.VDD.n228 17.0005
R4503 ldo_1v2_a_0.VDD.t88 ldo_1v2_a_0.VDD.n229 17.0005
R4504 ldo_1v2_a_0.VDD.t88 ldo_1v2_a_0.VDD.n187 17.0005
R4505 ldo_1v2_a_0.VDD.t88 ldo_1v2_a_0.VDD.n194 17.0005
R4506 ldo_1v2_a_0.VDD.t147 ldo_1v2_a_0.VDD.n27 17.0005
R4507 ldo_1v2_a_0.VDD.n28 ldo_1v2_a_0.VDD.t147 17.0005
R4508 ldo_1v2_a_0.VDD.n185 ldo_1v2_a_0.VDD.n184 17.0005
R4509 ldo_1v2_a_0.VDD.n120 ldo_1v2_a_0.VDD.n36 17.0005
R4510 ldo_1v2_a_0.VDD.n972 ldo_1v2_a_0.VDD.n37 17.0005
R4511 ldo_1v2_a_0.VDD.n973 ldo_1v2_a_0.VDD.n972 17.0005
R4512 ldo_1v2_a_0.VDD.n606 ldo_1v2_a_0.VDD.t129 15.0005
R4513 ldo_1v2_a_0.VDD.n633 ldo_1v2_a_0.VDD.t82 15.0005
R4514 ldo_1v2_a_0.VDD.n208 ldo_1v2_a_0.VDD.t123 15.0005
R4515 ldo_1v2_a_0.VDD.n219 ldo_1v2_a_0.VDD.t87 15.0005
R4516 ldo_1v2_a_0.VDD.n725 ldo_1v2_a_0.VDD.n719 13.3701
R4517 ldo_1v2_a_0.VDD.n719 ldo_1v2_a_0.VDD.t134 12.9908
R4518 ldo_1v2_a_0.VDD.n669 ldo_1v2_a_0.VDD.n668 9.5213
R4519 ldo_1v2_a_0.VDD.n673 ldo_1v2_a_0.VDD.n672 9.5189
R4520 ldo_1v2_a_0.VDD.n976 ldo_1v2_a_0.VDD.n975 9.0005
R4521 ldo_1v2_a_0.VDD.n980 ldo_1v2_a_0.VDD.n979 9.0005
R4522 ldo_1v2_a_0.VDD.n982 ldo_1v2_a_0.VDD.n981 9.0005
R4523 ldo_1v2_a_0.VDD.n984 ldo_1v2_a_0.VDD.n983 9.0005
R4524 ldo_1v2_a_0.VDD.n986 ldo_1v2_a_0.VDD.n985 9.0005
R4525 ldo_1v2_a_0.VDD.n988 ldo_1v2_a_0.VDD.n987 9.0005
R4526 ldo_1v2_a_0.VDD.n990 ldo_1v2_a_0.VDD.n989 9.0005
R4527 ldo_1v2_a_0.VDD.n978 ldo_1v2_a_0.VDD.n977 9.0005
R4528 ldo_1v2_a_0.VDD.n433 ldo_1v2_a_0.VDD.n432 8.501
R4529 ldo_1v2_a_0.VDD.n455 ldo_1v2_a_0.VDD.t105 8.501
R4530 ldo_1v2_a_0.VDD.n551 ldo_1v2_a_0.VDD.n387 8.501
R4531 ldo_1v2_a_0.VDD.n552 ldo_1v2_a_0.VDD.n551 8.501
R4532 ldo_1v2_a_0.VDD.n555 ldo_1v2_a_0.VDD.n554 8.501
R4533 ldo_1v2_a_0.VDD.n550 ldo_1v2_a_0.VDD.t79 8.501
R4534 ldo_1v2_a_0.VDD.n561 ldo_1v2_a_0.VDD.n560 8.501
R4535 ldo_1v2_a_0.VDD.n564 ldo_1v2_a_0.VDD.n563 8.501
R4536 ldo_1v2_a_0.VDD.n573 ldo_1v2_a_0.VDD.n572 8.501
R4537 ldo_1v2_a_0.VDD.n545 ldo_1v2_a_0.VDD.t58 8.501
R4538 ldo_1v2_a_0.VDD.n579 ldo_1v2_a_0.VDD.n578 8.501
R4539 ldo_1v2_a_0.VDD.n581 ldo_1v2_a_0.VDD.t32 8.501
R4540 ldo_1v2_a_0.VDD.n543 ldo_1v2_a_0.VDD.n542 8.501
R4541 ldo_1v2_a_0.VDD.n586 ldo_1v2_a_0.VDD.t56 8.501
R4542 ldo_1v2_a_0.VDD.t64 ldo_1v2_a_0.VDD.n611 8.501
R4543 ldo_1v2_a_0.VDD.n639 ldo_1v2_a_0.VDD.n381 8.501
R4544 ldo_1v2_a_0.VDD.t60 ldo_1v2_a_0.VDD.n331 8.501
R4545 ldo_1v2_a_0.VDD.t60 ldo_1v2_a_0.VDD.n332 8.501
R4546 ldo_1v2_a_0.VDD.t60 ldo_1v2_a_0.VDD.n333 8.501
R4547 ldo_1v2_a_0.VDD.t60 ldo_1v2_a_0.VDD.n334 8.501
R4548 ldo_1v2_a_0.VDD.t60 ldo_1v2_a_0.VDD.n682 8.501
R4549 ldo_1v2_a_0.VDD.t60 ldo_1v2_a_0.VDD.n326 8.501
R4550 ldo_1v2_a_0.VDD.t60 ldo_1v2_a_0.VDD.n325 8.501
R4551 ldo_1v2_a_0.VDD.t60 ldo_1v2_a_0.VDD.n324 8.501
R4552 ldo_1v2_a_0.VDD.t60 ldo_1v2_a_0.VDD.n323 8.501
R4553 ldo_1v2_a_0.VDD.t60 ldo_1v2_a_0.VDD.n292 8.501
R4554 ldo_1v2_a_0.VDD.t60 ldo_1v2_a_0.VDD.n293 8.501
R4555 ldo_1v2_a_0.VDD.t60 ldo_1v2_a_0.VDD.n294 8.501
R4556 ldo_1v2_a_0.VDD.t60 ldo_1v2_a_0.VDD.n295 8.501
R4557 ldo_1v2_a_0.VDD.t60 ldo_1v2_a_0.VDD.n297 8.501
R4558 ldo_1v2_a_0.VDD.t60 ldo_1v2_a_0.VDD.n291 8.501
R4559 ldo_1v2_a_0.VDD.t60 ldo_1v2_a_0.VDD.n298 8.501
R4560 ldo_1v2_a_0.VDD.t60 ldo_1v2_a_0.VDD.n303 8.501
R4561 ldo_1v2_a_0.VDD.t60 ldo_1v2_a_0.VDD.n304 8.501
R4562 ldo_1v2_a_0.VDD.t60 ldo_1v2_a_0.VDD.n305 8.501
R4563 ldo_1v2_a_0.VDD.t60 ldo_1v2_a_0.VDD.n306 8.501
R4564 ldo_1v2_a_0.VDD.t60 ldo_1v2_a_0.VDD.n307 8.501
R4565 ldo_1v2_a_0.VDD.t60 ldo_1v2_a_0.VDD.n308 8.501
R4566 ldo_1v2_a_0.VDD.t60 ldo_1v2_a_0.VDD.n309 8.501
R4567 ldo_1v2_a_0.VDD.t60 ldo_1v2_a_0.VDD.n310 8.501
R4568 ldo_1v2_a_0.VDD.t60 ldo_1v2_a_0.VDD.n311 8.501
R4569 ldo_1v2_a_0.VDD.t60 ldo_1v2_a_0.VDD.n312 8.501
R4570 ldo_1v2_a_0.VDD.t60 ldo_1v2_a_0.VDD.n313 8.501
R4571 ldo_1v2_a_0.VDD.t60 ldo_1v2_a_0.VDD.n314 8.501
R4572 ldo_1v2_a_0.VDD.t60 ldo_1v2_a_0.VDD.n315 8.501
R4573 ldo_1v2_a_0.VDD.t60 ldo_1v2_a_0.VDD.n316 8.501
R4574 ldo_1v2_a_0.VDD.t60 ldo_1v2_a_0.VDD.n317 8.501
R4575 ldo_1v2_a_0.VDD.t60 ldo_1v2_a_0.VDD.n318 8.501
R4576 ldo_1v2_a_0.VDD.t60 ldo_1v2_a_0.VDD.n319 8.501
R4577 ldo_1v2_a_0.VDD.t60 ldo_1v2_a_0.VDD.n320 8.501
R4578 ldo_1v2_a_0.VDD.t60 ldo_1v2_a_0.VDD.n321 8.501
R4579 ldo_1v2_a_0.VDD.n683 ldo_1v2_a_0.VDD.t60 8.501
R4580 ldo_1v2_a_0.VDD.t60 ldo_1v2_a_0.VDD.n302 8.501
R4581 ldo_1v2_a_0.VDD.t60 ldo_1v2_a_0.VDD.n299 8.501
R4582 ldo_1v2_a_0.VDD.n656 ldo_1v2_a_0.VDD.n241 8.501
R4583 ldo_1v2_a_0.VDD.n713 ldo_1v2_a_0.VDD.n712 8.501
R4584 ldo_1v2_a_0.VDD.n716 ldo_1v2_a_0.VDD.n265 8.501
R4585 ldo_1v2_a_0.VDD.n712 ldo_1v2_a_0.VDD.n711 8.501
R4586 ldo_1v2_a_0.VDD.n716 ldo_1v2_a_0.VDD.n264 8.501
R4587 ldo_1v2_a_0.VDD.n734 ldo_1v2_a_0.VDD.n256 8.501
R4588 ldo_1v2_a_0.VDD.n738 ldo_1v2_a_0.VDD.n254 8.501
R4589 ldo_1v2_a_0.VDD.n738 ldo_1v2_a_0.VDD.n253 8.501
R4590 ldo_1v2_a_0.VDD.n738 ldo_1v2_a_0.VDD.n252 8.501
R4591 ldo_1v2_a_0.VDD.n738 ldo_1v2_a_0.VDD.n249 8.501
R4592 ldo_1v2_a_0.VDD.n740 ldo_1v2_a_0.VDD.n246 8.501
R4593 ldo_1v2_a_0.VDD.t0 ldo_1v2_a_0.VDD.n96 8.501
R4594 ldo_1v2_a_0.VDD.t0 ldo_1v2_a_0.VDD.n95 8.501
R4595 ldo_1v2_a_0.VDD.t0 ldo_1v2_a_0.VDD.n94 8.501
R4596 ldo_1v2_a_0.VDD.t0 ldo_1v2_a_0.VDD.n93 8.501
R4597 ldo_1v2_a_0.VDD.t0 ldo_1v2_a_0.VDD.n92 8.501
R4598 ldo_1v2_a_0.VDD.t0 ldo_1v2_a_0.VDD.n91 8.501
R4599 ldo_1v2_a_0.VDD.t0 ldo_1v2_a_0.VDD.n90 8.501
R4600 ldo_1v2_a_0.VDD.t0 ldo_1v2_a_0.VDD.n89 8.501
R4601 ldo_1v2_a_0.VDD.t0 ldo_1v2_a_0.VDD.n88 8.501
R4602 ldo_1v2_a_0.VDD.t0 ldo_1v2_a_0.VDD.n87 8.501
R4603 ldo_1v2_a_0.VDD.t0 ldo_1v2_a_0.VDD.n86 8.501
R4604 ldo_1v2_a_0.VDD.t0 ldo_1v2_a_0.VDD.n85 8.501
R4605 ldo_1v2_a_0.VDD.t0 ldo_1v2_a_0.VDD.n84 8.501
R4606 ldo_1v2_a_0.VDD.t0 ldo_1v2_a_0.VDD.n83 8.501
R4607 ldo_1v2_a_0.VDD.t0 ldo_1v2_a_0.VDD.n82 8.501
R4608 ldo_1v2_a_0.VDD.t0 ldo_1v2_a_0.VDD.n81 8.501
R4609 ldo_1v2_a_0.VDD.t0 ldo_1v2_a_0.VDD.n80 8.501
R4610 ldo_1v2_a_0.VDD.t0 ldo_1v2_a_0.VDD.n79 8.501
R4611 ldo_1v2_a_0.VDD.t0 ldo_1v2_a_0.VDD.n78 8.501
R4612 ldo_1v2_a_0.VDD.t0 ldo_1v2_a_0.VDD.n77 8.501
R4613 ldo_1v2_a_0.VDD.t0 ldo_1v2_a_0.VDD.n118 8.501
R4614 ldo_1v2_a_0.VDD.t0 ldo_1v2_a_0.VDD.n117 8.501
R4615 ldo_1v2_a_0.VDD.t0 ldo_1v2_a_0.VDD.n116 8.501
R4616 ldo_1v2_a_0.VDD.t0 ldo_1v2_a_0.VDD.n115 8.501
R4617 ldo_1v2_a_0.VDD.t0 ldo_1v2_a_0.VDD.n114 8.501
R4618 ldo_1v2_a_0.VDD.t0 ldo_1v2_a_0.VDD.n113 8.501
R4619 ldo_1v2_a_0.VDD.t0 ldo_1v2_a_0.VDD.n112 8.501
R4620 ldo_1v2_a_0.VDD.t0 ldo_1v2_a_0.VDD.n111 8.501
R4621 ldo_1v2_a_0.VDD.t0 ldo_1v2_a_0.VDD.n110 8.501
R4622 ldo_1v2_a_0.VDD.t0 ldo_1v2_a_0.VDD.n109 8.501
R4623 ldo_1v2_a_0.VDD.t0 ldo_1v2_a_0.VDD.n108 8.501
R4624 ldo_1v2_a_0.VDD.t0 ldo_1v2_a_0.VDD.n107 8.501
R4625 ldo_1v2_a_0.VDD.t0 ldo_1v2_a_0.VDD.n106 8.501
R4626 ldo_1v2_a_0.VDD.t0 ldo_1v2_a_0.VDD.n105 8.501
R4627 ldo_1v2_a_0.VDD.t0 ldo_1v2_a_0.VDD.n104 8.501
R4628 ldo_1v2_a_0.VDD.t0 ldo_1v2_a_0.VDD.n103 8.501
R4629 ldo_1v2_a_0.VDD.t0 ldo_1v2_a_0.VDD.n102 8.501
R4630 ldo_1v2_a_0.VDD.t0 ldo_1v2_a_0.VDD.n101 8.501
R4631 ldo_1v2_a_0.VDD.t0 ldo_1v2_a_0.VDD.n100 8.501
R4632 ldo_1v2_a_0.VDD.t0 ldo_1v2_a_0.VDD.n99 8.501
R4633 ldo_1v2_a_0.VDD.t0 ldo_1v2_a_0.VDD.n98 8.501
R4634 ldo_1v2_a_0.VDD.t0 ldo_1v2_a_0.VDD.n97 8.501
R4635 ldo_1v2_a_0.VDD.t0 ldo_1v2_a_0.VDD.n74 8.501
R4636 ldo_1v2_a_0.VDD.t0 ldo_1v2_a_0.VDD.n73 8.501
R4637 ldo_1v2_a_0.VDD.t0 ldo_1v2_a_0.VDD.n72 8.501
R4638 ldo_1v2_a_0.VDD.t0 ldo_1v2_a_0.VDD.n71 8.501
R4639 ldo_1v2_a_0.VDD.t0 ldo_1v2_a_0.VDD.n70 8.501
R4640 ldo_1v2_a_0.VDD.t0 ldo_1v2_a_0.VDD.n69 8.501
R4641 ldo_1v2_a_0.VDD.t0 ldo_1v2_a_0.VDD.n68 8.501
R4642 ldo_1v2_a_0.VDD.t0 ldo_1v2_a_0.VDD.n67 8.501
R4643 ldo_1v2_a_0.VDD.t0 ldo_1v2_a_0.VDD.n66 8.501
R4644 ldo_1v2_a_0.VDD.t0 ldo_1v2_a_0.VDD.n65 8.501
R4645 ldo_1v2_a_0.VDD.t0 ldo_1v2_a_0.VDD.n64 8.501
R4646 ldo_1v2_a_0.VDD.t0 ldo_1v2_a_0.VDD.n63 8.501
R4647 ldo_1v2_a_0.VDD.t0 ldo_1v2_a_0.VDD.n62 8.501
R4648 ldo_1v2_a_0.VDD.t0 ldo_1v2_a_0.VDD.n61 8.501
R4649 ldo_1v2_a_0.VDD.t0 ldo_1v2_a_0.VDD.n60 8.501
R4650 ldo_1v2_a_0.VDD.t0 ldo_1v2_a_0.VDD.n59 8.501
R4651 ldo_1v2_a_0.VDD.t0 ldo_1v2_a_0.VDD.n58 8.501
R4652 ldo_1v2_a_0.VDD.t0 ldo_1v2_a_0.VDD.n57 8.501
R4653 ldo_1v2_a_0.VDD.t0 ldo_1v2_a_0.VDD.n56 8.501
R4654 ldo_1v2_a_0.VDD.t0 ldo_1v2_a_0.VDD.n55 8.501
R4655 ldo_1v2_a_0.VDD.t0 ldo_1v2_a_0.VDD.n54 8.501
R4656 ldo_1v2_a_0.VDD.t0 ldo_1v2_a_0.VDD.n53 8.501
R4657 ldo_1v2_a_0.VDD.t0 ldo_1v2_a_0.VDD.n52 8.501
R4658 ldo_1v2_a_0.VDD.t0 ldo_1v2_a_0.VDD.n51 8.501
R4659 ldo_1v2_a_0.VDD.t0 ldo_1v2_a_0.VDD.n50 8.501
R4660 ldo_1v2_a_0.VDD.t0 ldo_1v2_a_0.VDD.n49 8.501
R4661 ldo_1v2_a_0.VDD.t0 ldo_1v2_a_0.VDD.n48 8.501
R4662 ldo_1v2_a_0.VDD.t0 ldo_1v2_a_0.VDD.n47 8.501
R4663 ldo_1v2_a_0.VDD.t0 ldo_1v2_a_0.VDD.n46 8.501
R4664 ldo_1v2_a_0.VDD.t0 ldo_1v2_a_0.VDD.n45 8.501
R4665 ldo_1v2_a_0.VDD.t0 ldo_1v2_a_0.VDD.n44 8.501
R4666 ldo_1v2_a_0.VDD.t0 ldo_1v2_a_0.VDD.n43 8.501
R4667 ldo_1v2_a_0.VDD.t0 ldo_1v2_a_0.VDD.n42 8.501
R4668 ldo_1v2_a_0.VDD.t0 ldo_1v2_a_0.VDD.n122 8.501
R4669 ldo_1v2_a_0.VDD.t0 ldo_1v2_a_0.VDD.n123 8.501
R4670 ldo_1v2_a_0.VDD.t0 ldo_1v2_a_0.VDD.n124 8.501
R4671 ldo_1v2_a_0.VDD.t0 ldo_1v2_a_0.VDD.n125 8.501
R4672 ldo_1v2_a_0.VDD.t0 ldo_1v2_a_0.VDD.n126 8.501
R4673 ldo_1v2_a_0.VDD.t0 ldo_1v2_a_0.VDD.n127 8.501
R4674 ldo_1v2_a_0.VDD.t0 ldo_1v2_a_0.VDD.n128 8.501
R4675 ldo_1v2_a_0.VDD.t0 ldo_1v2_a_0.VDD.n129 8.501
R4676 ldo_1v2_a_0.VDD.t0 ldo_1v2_a_0.VDD.n130 8.501
R4677 ldo_1v2_a_0.VDD.t0 ldo_1v2_a_0.VDD.n131 8.501
R4678 ldo_1v2_a_0.VDD.t0 ldo_1v2_a_0.VDD.n132 8.501
R4679 ldo_1v2_a_0.VDD.t0 ldo_1v2_a_0.VDD.n133 8.501
R4680 ldo_1v2_a_0.VDD.t0 ldo_1v2_a_0.VDD.n134 8.501
R4681 ldo_1v2_a_0.VDD.t0 ldo_1v2_a_0.VDD.n135 8.501
R4682 ldo_1v2_a_0.VDD.t0 ldo_1v2_a_0.VDD.n136 8.501
R4683 ldo_1v2_a_0.VDD.t0 ldo_1v2_a_0.VDD.n137 8.501
R4684 ldo_1v2_a_0.VDD.t0 ldo_1v2_a_0.VDD.n138 8.501
R4685 ldo_1v2_a_0.VDD.t0 ldo_1v2_a_0.VDD.n139 8.501
R4686 ldo_1v2_a_0.VDD.t0 ldo_1v2_a_0.VDD.n140 8.501
R4687 ldo_1v2_a_0.VDD.t0 ldo_1v2_a_0.VDD.n792 8.501
R4688 ldo_1v2_a_0.VDD.t0 ldo_1v2_a_0.VDD.n39 8.501
R4689 ldo_1v2_a_0.VDD.n971 ldo_1v2_a_0.VDD.t0 8.501
R4690 ldo_1v2_a_0.VDD.t0 ldo_1v2_a_0.VDD.n793 8.501
R4691 ldo_1v2_a_0.VDD.t0 ldo_1v2_a_0.VDD.n794 8.501
R4692 ldo_1v2_a_0.VDD.t0 ldo_1v2_a_0.VDD.n795 8.501
R4693 ldo_1v2_a_0.VDD.t0 ldo_1v2_a_0.VDD.n796 8.501
R4694 ldo_1v2_a_0.VDD.t0 ldo_1v2_a_0.VDD.n797 8.501
R4695 ldo_1v2_a_0.VDD.t0 ldo_1v2_a_0.VDD.n798 8.501
R4696 ldo_1v2_a_0.VDD.t0 ldo_1v2_a_0.VDD.n799 8.501
R4697 ldo_1v2_a_0.VDD.t0 ldo_1v2_a_0.VDD.n800 8.501
R4698 ldo_1v2_a_0.VDD.t0 ldo_1v2_a_0.VDD.n801 8.501
R4699 ldo_1v2_a_0.VDD.t0 ldo_1v2_a_0.VDD.n802 8.501
R4700 ldo_1v2_a_0.VDD.t0 ldo_1v2_a_0.VDD.n803 8.501
R4701 ldo_1v2_a_0.VDD.t0 ldo_1v2_a_0.VDD.n804 8.501
R4702 ldo_1v2_a_0.VDD.t0 ldo_1v2_a_0.VDD.n805 8.501
R4703 ldo_1v2_a_0.VDD.t0 ldo_1v2_a_0.VDD.n806 8.501
R4704 ldo_1v2_a_0.VDD.t0 ldo_1v2_a_0.VDD.n807 8.501
R4705 ldo_1v2_a_0.VDD.t0 ldo_1v2_a_0.VDD.n808 8.501
R4706 ldo_1v2_a_0.VDD.t0 ldo_1v2_a_0.VDD.n809 8.501
R4707 ldo_1v2_a_0.VDD.t0 ldo_1v2_a_0.VDD.n810 8.501
R4708 ldo_1v2_a_0.VDD.t0 ldo_1v2_a_0.VDD.n811 8.501
R4709 ldo_1v2_a_0.VDD.t0 ldo_1v2_a_0.VDD.n812 8.501
R4710 ldo_1v2_a_0.VDD.t0 ldo_1v2_a_0.VDD.n813 8.501
R4711 ldo_1v2_a_0.VDD.t0 ldo_1v2_a_0.VDD.n970 8.501
R4712 ldo_1v2_a_0.VDD.n554 ldo_1v2_a_0.VDD.n329 8.5005
R4713 ldo_1v2_a_0.VDD.t79 ldo_1v2_a_0.VDD.n329 8.5005
R4714 ldo_1v2_a_0.VDD.n560 ldo_1v2_a_0.VDD.n329 8.5005
R4715 ldo_1v2_a_0.VDD.n563 ldo_1v2_a_0.VDD.n329 8.5005
R4716 ldo_1v2_a_0.VDD.n572 ldo_1v2_a_0.VDD.n329 8.5005
R4717 ldo_1v2_a_0.VDD.t58 ldo_1v2_a_0.VDD.n329 8.5005
R4718 ldo_1v2_a_0.VDD.n578 ldo_1v2_a_0.VDD.n329 8.5005
R4719 ldo_1v2_a_0.VDD.t32 ldo_1v2_a_0.VDD.n329 8.5005
R4720 ldo_1v2_a_0.VDD.n542 ldo_1v2_a_0.VDD.n329 8.5005
R4721 ldo_1v2_a_0.VDD.t56 ldo_1v2_a_0.VDD.n329 8.5005
R4722 ldo_1v2_a_0.VDD.t64 ldo_1v2_a_0.VDD.n329 8.5005
R4723 ldo_1v2_a_0.VDD.n662 ldo_1v2_a_0.VDD.n661 8.5005
R4724 ldo_1v2_a_0.VDD.t33 ldo_1v2_a_0.VDD.n238 8.5005
R4725 ldo_1v2_a_0.VDD.n251 ldo_1v2_a_0.VDD.n250 8.5005
R4726 ldo_1v2_a_0.VDD.t124 ldo_1v2_a_0.VDD.n197 8.4962
R4727 ldo_1v2_a_0.VDD.t125 ldo_1v2_a_0.VDD.n199 8.49614
R4728 ldo_1v2_a_0.VDD.t125 ldo_1v2_a_0.VDD.n201 8.49614
R4729 ldo_1v2_a_0.VDD.t125 ldo_1v2_a_0.VDD.n198 8.49614
R4730 ldo_1v2_a_0.VDD.t124 ldo_1v2_a_0.VDD.n203 8.49614
R4731 ldo_1v2_a_0.VDD.t124 ldo_1v2_a_0.VDD.n204 8.49614
R4732 ldo_1v2_a_0.VDD.n205 ldo_1v2_a_0.VDD.t124 8.49614
R4733 ldo_1v2_a_0.VDD.n399 ldo_1v2_a_0.VDD.n398 8.49571
R4734 ldo_1v2_a_0.VDD.n665 ldo_1v2_a_0.VDD.n366 8.49381
R4735 ldo_1v2_a_0.VDD.n575 ldo_1v2_a_0.VDD.n574 8.49367
R4736 ldo_1v2_a_0.VDD.n588 ldo_1v2_a_0.VDD.n587 8.49322
R4737 ldo_1v2_a_0.VDD.n482 ldo_1v2_a_0.VDD.t80 8.49227
R4738 ldo_1v2_a_0.VDD.n484 ldo_1v2_a_0.VDD.t80 8.49227
R4739 ldo_1v2_a_0.VDD.n486 ldo_1v2_a_0.VDD.t80 8.49227
R4740 ldo_1v2_a_0.VDD.n488 ldo_1v2_a_0.VDD.t80 8.49227
R4741 ldo_1v2_a_0.VDD.n490 ldo_1v2_a_0.VDD.t80 8.49227
R4742 ldo_1v2_a_0.VDD.n492 ldo_1v2_a_0.VDD.t81 8.49227
R4743 ldo_1v2_a_0.VDD.t81 ldo_1v2_a_0.VDD.n483 8.49227
R4744 ldo_1v2_a_0.VDD.t81 ldo_1v2_a_0.VDD.n485 8.49227
R4745 ldo_1v2_a_0.VDD.t81 ldo_1v2_a_0.VDD.n487 8.49227
R4746 ldo_1v2_a_0.VDD.t81 ldo_1v2_a_0.VDD.n489 8.49227
R4747 ldo_1v2_a_0.VDD.n473 ldo_1v2_a_0.VDD.t95 8.49227
R4748 ldo_1v2_a_0.VDD.n475 ldo_1v2_a_0.VDD.t95 8.49227
R4749 ldo_1v2_a_0.VDD.n477 ldo_1v2_a_0.VDD.t95 8.49227
R4750 ldo_1v2_a_0.VDD.n479 ldo_1v2_a_0.VDD.t95 8.49227
R4751 ldo_1v2_a_0.VDD.n481 ldo_1v2_a_0.VDD.t95 8.49227
R4752 ldo_1v2_a_0.VDD.n496 ldo_1v2_a_0.VDD.t96 8.49227
R4753 ldo_1v2_a_0.VDD.t96 ldo_1v2_a_0.VDD.n474 8.49227
R4754 ldo_1v2_a_0.VDD.t96 ldo_1v2_a_0.VDD.n476 8.49227
R4755 ldo_1v2_a_0.VDD.t96 ldo_1v2_a_0.VDD.n478 8.49227
R4756 ldo_1v2_a_0.VDD.t96 ldo_1v2_a_0.VDD.n480 8.49227
R4757 ldo_1v2_a_0.VDD.t130 ldo_1v2_a_0.VDD.n593 8.49149
R4758 ldo_1v2_a_0.VDD.t130 ldo_1v2_a_0.VDD.n595 8.49149
R4759 ldo_1v2_a_0.VDD.t130 ldo_1v2_a_0.VDD.n596 8.49149
R4760 ldo_1v2_a_0.VDD.t130 ldo_1v2_a_0.VDD.n604 8.49149
R4761 ldo_1v2_a_0.VDD.t131 ldo_1v2_a_0.VDD.n599 8.49149
R4762 ldo_1v2_a_0.VDD.t131 ldo_1v2_a_0.VDD.n600 8.49149
R4763 ldo_1v2_a_0.VDD.t131 ldo_1v2_a_0.VDD.n602 8.49149
R4764 ldo_1v2_a_0.VDD.n603 ldo_1v2_a_0.VDD.t131 8.49149
R4765 ldo_1v2_a_0.VDD.t131 ldo_1v2_a_0.VDD.n592 8.49149
R4766 ldo_1v2_a_0.VDD.t83 ldo_1v2_a_0.VDD.n619 8.49149
R4767 ldo_1v2_a_0.VDD.t83 ldo_1v2_a_0.VDD.n621 8.49149
R4768 ldo_1v2_a_0.VDD.t83 ldo_1v2_a_0.VDD.n622 8.49149
R4769 ldo_1v2_a_0.VDD.t83 ldo_1v2_a_0.VDD.n624 8.49149
R4770 ldo_1v2_a_0.VDD.t84 ldo_1v2_a_0.VDD.n625 8.49149
R4771 ldo_1v2_a_0.VDD.t84 ldo_1v2_a_0.VDD.n626 8.49149
R4772 ldo_1v2_a_0.VDD.t84 ldo_1v2_a_0.VDD.n628 8.49149
R4773 ldo_1v2_a_0.VDD.t84 ldo_1v2_a_0.VDD.n629 8.49149
R4774 ldo_1v2_a_0.VDD.t84 ldo_1v2_a_0.VDD.n618 8.49149
R4775 ldo_1v2_a_0.VDD.n518 ldo_1v2_a_0.VDD.t102 8.49146
R4776 ldo_1v2_a_0.VDD.n520 ldo_1v2_a_0.VDD.t102 8.49146
R4777 ldo_1v2_a_0.VDD.n522 ldo_1v2_a_0.VDD.t102 8.49146
R4778 ldo_1v2_a_0.VDD.n524 ldo_1v2_a_0.VDD.t102 8.49146
R4779 ldo_1v2_a_0.VDD.n526 ldo_1v2_a_0.VDD.t102 8.49146
R4780 ldo_1v2_a_0.VDD.n529 ldo_1v2_a_0.VDD.t103 8.49146
R4781 ldo_1v2_a_0.VDD.t103 ldo_1v2_a_0.VDD.n519 8.49146
R4782 ldo_1v2_a_0.VDD.t103 ldo_1v2_a_0.VDD.n521 8.49146
R4783 ldo_1v2_a_0.VDD.t103 ldo_1v2_a_0.VDD.n523 8.49146
R4784 ldo_1v2_a_0.VDD.t103 ldo_1v2_a_0.VDD.n525 8.49146
R4785 ldo_1v2_a_0.VDD.n509 ldo_1v2_a_0.VDD.t127 8.49146
R4786 ldo_1v2_a_0.VDD.n511 ldo_1v2_a_0.VDD.t127 8.49146
R4787 ldo_1v2_a_0.VDD.n513 ldo_1v2_a_0.VDD.t127 8.49146
R4788 ldo_1v2_a_0.VDD.n515 ldo_1v2_a_0.VDD.t127 8.49146
R4789 ldo_1v2_a_0.VDD.n517 ldo_1v2_a_0.VDD.t127 8.49146
R4790 ldo_1v2_a_0.VDD.n533 ldo_1v2_a_0.VDD.t128 8.49146
R4791 ldo_1v2_a_0.VDD.t128 ldo_1v2_a_0.VDD.n510 8.49146
R4792 ldo_1v2_a_0.VDD.t128 ldo_1v2_a_0.VDD.n512 8.49146
R4793 ldo_1v2_a_0.VDD.t128 ldo_1v2_a_0.VDD.n514 8.49146
R4794 ldo_1v2_a_0.VDD.t128 ldo_1v2_a_0.VDD.n516 8.49146
R4795 ldo_1v2_a_0.VDD.t130 ldo_1v2_a_0.VDD.n594 8.49136
R4796 ldo_1v2_a_0.VDD.t130 ldo_1v2_a_0.VDD.n597 8.49136
R4797 ldo_1v2_a_0.VDD.t131 ldo_1v2_a_0.VDD.n598 8.49136
R4798 ldo_1v2_a_0.VDD.t131 ldo_1v2_a_0.VDD.n601 8.49136
R4799 ldo_1v2_a_0.VDD.t83 ldo_1v2_a_0.VDD.n620 8.49136
R4800 ldo_1v2_a_0.VDD.t83 ldo_1v2_a_0.VDD.n623 8.49136
R4801 ldo_1v2_a_0.VDD.n630 ldo_1v2_a_0.VDD.t84 8.49136
R4802 ldo_1v2_a_0.VDD.t84 ldo_1v2_a_0.VDD.n627 8.49136
R4803 ldo_1v2_a_0.VDD.n715 ldo_1v2_a_0.VDD.n714 8.49047
R4804 ldo_1v2_a_0.VDD.n681 ldo_1v2_a_0.VDD.n680 8.48956
R4805 ldo_1v2_a_0.VDD.t150 ldo_1v2_a_0.VDD.n408 8.48782
R4806 ldo_1v2_a_0.VDD.t150 ldo_1v2_a_0.VDD.n409 8.48782
R4807 ldo_1v2_a_0.VDD.t150 ldo_1v2_a_0.VDD.n411 8.48782
R4808 ldo_1v2_a_0.VDD.t150 ldo_1v2_a_0.VDD.n412 8.48782
R4809 ldo_1v2_a_0.VDD.n413 ldo_1v2_a_0.VDD.t150 8.48782
R4810 ldo_1v2_a_0.VDD.t152 ldo_1v2_a_0.VDD.n402 8.48782
R4811 ldo_1v2_a_0.VDD.t152 ldo_1v2_a_0.VDD.n404 8.48782
R4812 ldo_1v2_a_0.VDD.t152 ldo_1v2_a_0.VDD.n405 8.48782
R4813 ldo_1v2_a_0.VDD.t152 ldo_1v2_a_0.VDD.n407 8.48782
R4814 ldo_1v2_a_0.VDD.t145 ldo_1v2_a_0.VDD.n20 8.48782
R4815 ldo_1v2_a_0.VDD.t145 ldo_1v2_a_0.VDD.n21 8.48782
R4816 ldo_1v2_a_0.VDD.t145 ldo_1v2_a_0.VDD.n23 8.48782
R4817 ldo_1v2_a_0.VDD.t145 ldo_1v2_a_0.VDD.n24 8.48782
R4818 ldo_1v2_a_0.VDD.n25 ldo_1v2_a_0.VDD.t145 8.48782
R4819 ldo_1v2_a_0.VDD.t147 ldo_1v2_a_0.VDD.n14 8.48782
R4820 ldo_1v2_a_0.VDD.t147 ldo_1v2_a_0.VDD.n16 8.48782
R4821 ldo_1v2_a_0.VDD.t147 ldo_1v2_a_0.VDD.n17 8.48782
R4822 ldo_1v2_a_0.VDD.t147 ldo_1v2_a_0.VDD.n19 8.48782
R4823 ldo_1v2_a_0.VDD.t150 ldo_1v2_a_0.VDD.n410 8.48764
R4824 ldo_1v2_a_0.VDD.t150 ldo_1v2_a_0.VDD.n401 8.48764
R4825 ldo_1v2_a_0.VDD.t152 ldo_1v2_a_0.VDD.n403 8.48764
R4826 ldo_1v2_a_0.VDD.t152 ldo_1v2_a_0.VDD.n406 8.48764
R4827 ldo_1v2_a_0.VDD.t145 ldo_1v2_a_0.VDD.n22 8.48764
R4828 ldo_1v2_a_0.VDD.t145 ldo_1v2_a_0.VDD.n13 8.48764
R4829 ldo_1v2_a_0.VDD.t147 ldo_1v2_a_0.VDD.n15 8.48764
R4830 ldo_1v2_a_0.VDD.t147 ldo_1v2_a_0.VDD.n18 8.48764
R4831 ldo_1v2_a_0.VDD.n705 ldo_1v2_a_0.VDD.n270 8.48499
R4832 ldo_1v2_a_0.VDD.n685 ldo_1v2_a_0.VDD.n684 8.48362
R4833 ldo_1v2_a_0.VDD.n553 ldo_1v2_a_0.VDD.n463 8.48316
R4834 ldo_1v2_a_0.VDD.n676 ldo_1v2_a_0.VDD.n340 8.48043
R4835 ldo_1v2_a_0.VDD.n571 ldo_1v2_a_0.VDD.n570 8.47723
R4836 ldo_1v2_a_0.VDD.n613 ldo_1v2_a_0.VDD.n502 8.46995
R4837 ldo_1v2_a_0.VDD.n617 ldo_1v2_a_0.VDD.n462 8.46995
R4838 ldo_1v2_a_0.VDD.n557 ldo_1v2_a_0.VDD.n556 8.46995
R4839 ldo_1v2_a_0.VDD.n559 ldo_1v2_a_0.VDD.n558 8.46995
R4840 ldo_1v2_a_0.VDD.n562 ldo_1v2_a_0.VDD.n549 8.46995
R4841 ldo_1v2_a_0.VDD.n577 ldo_1v2_a_0.VDD.n576 8.46995
R4842 ldo_1v2_a_0.VDD.n580 ldo_1v2_a_0.VDD.n544 8.46995
R4843 ldo_1v2_a_0.VDD.n583 ldo_1v2_a_0.VDD.n582 8.46995
R4844 ldo_1v2_a_0.VDD.n585 ldo_1v2_a_0.VDD.n584 8.46995
R4845 ldo_1v2_a_0.VDD.n360 ldo_1v2_a_0.VDD.n352 8.46995
R4846 ldo_1v2_a_0.VDD.n359 ldo_1v2_a_0.VDD.n353 8.46995
R4847 ldo_1v2_a_0.VDD.n358 ldo_1v2_a_0.VDD.n354 8.46995
R4848 ldo_1v2_a_0.VDD.n357 ldo_1v2_a_0.VDD.n355 8.46995
R4849 ldo_1v2_a_0.VDD.n356 ldo_1v2_a_0.VDD.n335 8.46995
R4850 ldo_1v2_a_0.VDD.n679 ldo_1v2_a_0.VDD.n337 8.46995
R4851 ldo_1v2_a_0.VDD.n677 ldo_1v2_a_0.VDD.n339 8.46995
R4852 ldo_1v2_a_0.VDD.n348 ldo_1v2_a_0.VDD.n341 8.46995
R4853 ldo_1v2_a_0.VDD.n347 ldo_1v2_a_0.VDD.n342 8.46995
R4854 ldo_1v2_a_0.VDD.n346 ldo_1v2_a_0.VDD.n343 8.46995
R4855 ldo_1v2_a_0.VDD.n345 ldo_1v2_a_0.VDD.n344 8.46995
R4856 ldo_1v2_a_0.VDD.n296 ldo_1v2_a_0.VDD.n290 8.46995
R4857 ldo_1v2_a_0.VDD.n663 ldo_1v2_a_0.VDD.n645 8.46995
R4858 ldo_1v2_a_0.VDD.n647 ldo_1v2_a_0.VDD.n646 8.46995
R4859 ldo_1v2_a_0.VDD.n704 ldo_1v2_a_0.VDD.n271 8.46995
R4860 ldo_1v2_a_0.VDD.n703 ldo_1v2_a_0.VDD.n272 8.46995
R4861 ldo_1v2_a_0.VDD.n702 ldo_1v2_a_0.VDD.n273 8.46995
R4862 ldo_1v2_a_0.VDD.n701 ldo_1v2_a_0.VDD.n274 8.46995
R4863 ldo_1v2_a_0.VDD.n700 ldo_1v2_a_0.VDD.n275 8.46995
R4864 ldo_1v2_a_0.VDD.n699 ldo_1v2_a_0.VDD.n276 8.46995
R4865 ldo_1v2_a_0.VDD.n697 ldo_1v2_a_0.VDD.n278 8.46995
R4866 ldo_1v2_a_0.VDD.n696 ldo_1v2_a_0.VDD.n279 8.46995
R4867 ldo_1v2_a_0.VDD.n695 ldo_1v2_a_0.VDD.n280 8.46995
R4868 ldo_1v2_a_0.VDD.n694 ldo_1v2_a_0.VDD.n281 8.46995
R4869 ldo_1v2_a_0.VDD.n693 ldo_1v2_a_0.VDD.n282 8.46995
R4870 ldo_1v2_a_0.VDD.n692 ldo_1v2_a_0.VDD.n283 8.46995
R4871 ldo_1v2_a_0.VDD.n691 ldo_1v2_a_0.VDD.n284 8.46995
R4872 ldo_1v2_a_0.VDD.n690 ldo_1v2_a_0.VDD.n285 8.46995
R4873 ldo_1v2_a_0.VDD.n689 ldo_1v2_a_0.VDD.n286 8.46995
R4874 ldo_1v2_a_0.VDD.n688 ldo_1v2_a_0.VDD.n287 8.46995
R4875 ldo_1v2_a_0.VDD.n687 ldo_1v2_a_0.VDD.n288 8.46995
R4876 ldo_1v2_a_0.VDD.n686 ldo_1v2_a_0.VDD.n289 8.46995
R4877 ldo_1v2_a_0.VDD.n143 ldo_1v2_a_0.VDD.n142 8.46995
R4878 ldo_1v2_a_0.VDD.n145 ldo_1v2_a_0.VDD.n144 8.46995
R4879 ldo_1v2_a_0.VDD.n147 ldo_1v2_a_0.VDD.n146 8.46995
R4880 ldo_1v2_a_0.VDD.n149 ldo_1v2_a_0.VDD.n148 8.46995
R4881 ldo_1v2_a_0.VDD.n151 ldo_1v2_a_0.VDD.n150 8.46995
R4882 ldo_1v2_a_0.VDD.n153 ldo_1v2_a_0.VDD.n152 8.46995
R4883 ldo_1v2_a_0.VDD.n155 ldo_1v2_a_0.VDD.n154 8.46995
R4884 ldo_1v2_a_0.VDD.n157 ldo_1v2_a_0.VDD.n156 8.46995
R4885 ldo_1v2_a_0.VDD.n159 ldo_1v2_a_0.VDD.n158 8.46995
R4886 ldo_1v2_a_0.VDD.n161 ldo_1v2_a_0.VDD.n160 8.46995
R4887 ldo_1v2_a_0.VDD.n163 ldo_1v2_a_0.VDD.n162 8.46995
R4888 ldo_1v2_a_0.VDD.n165 ldo_1v2_a_0.VDD.n164 8.46995
R4889 ldo_1v2_a_0.VDD.n167 ldo_1v2_a_0.VDD.n166 8.46995
R4890 ldo_1v2_a_0.VDD.n169 ldo_1v2_a_0.VDD.n168 8.46995
R4891 ldo_1v2_a_0.VDD.n171 ldo_1v2_a_0.VDD.n170 8.46995
R4892 ldo_1v2_a_0.VDD.n173 ldo_1v2_a_0.VDD.n172 8.46995
R4893 ldo_1v2_a_0.VDD.n175 ldo_1v2_a_0.VDD.n174 8.46995
R4894 ldo_1v2_a_0.VDD.n177 ldo_1v2_a_0.VDD.n176 8.46995
R4895 ldo_1v2_a_0.VDD.n179 ldo_1v2_a_0.VDD.n178 8.46995
R4896 ldo_1v2_a_0.VDD.n181 ldo_1v2_a_0.VDD.n180 8.46995
R4897 ldo_1v2_a_0.VDD.n183 ldo_1v2_a_0.VDD.n182 8.46995
R4898 ldo_1v2_a_0.VDD.n899 ldo_1v2_a_0.VDD.n856 8.46995
R4899 ldo_1v2_a_0.VDD.n898 ldo_1v2_a_0.VDD.n857 8.46995
R4900 ldo_1v2_a_0.VDD.n897 ldo_1v2_a_0.VDD.n858 8.46995
R4901 ldo_1v2_a_0.VDD.n896 ldo_1v2_a_0.VDD.n859 8.46995
R4902 ldo_1v2_a_0.VDD.n895 ldo_1v2_a_0.VDD.n860 8.46995
R4903 ldo_1v2_a_0.VDD.n894 ldo_1v2_a_0.VDD.n861 8.46995
R4904 ldo_1v2_a_0.VDD.n893 ldo_1v2_a_0.VDD.n862 8.46995
R4905 ldo_1v2_a_0.VDD.n892 ldo_1v2_a_0.VDD.n863 8.46995
R4906 ldo_1v2_a_0.VDD.n891 ldo_1v2_a_0.VDD.n864 8.46995
R4907 ldo_1v2_a_0.VDD.n890 ldo_1v2_a_0.VDD.n865 8.46995
R4908 ldo_1v2_a_0.VDD.n889 ldo_1v2_a_0.VDD.n866 8.46995
R4909 ldo_1v2_a_0.VDD.n888 ldo_1v2_a_0.VDD.n867 8.46995
R4910 ldo_1v2_a_0.VDD.n887 ldo_1v2_a_0.VDD.n868 8.46995
R4911 ldo_1v2_a_0.VDD.n886 ldo_1v2_a_0.VDD.n869 8.46995
R4912 ldo_1v2_a_0.VDD.n885 ldo_1v2_a_0.VDD.n870 8.46995
R4913 ldo_1v2_a_0.VDD.n884 ldo_1v2_a_0.VDD.n871 8.46995
R4914 ldo_1v2_a_0.VDD.n883 ldo_1v2_a_0.VDD.n872 8.46995
R4915 ldo_1v2_a_0.VDD.n882 ldo_1v2_a_0.VDD.n873 8.46995
R4916 ldo_1v2_a_0.VDD.n881 ldo_1v2_a_0.VDD.n874 8.46995
R4917 ldo_1v2_a_0.VDD.n880 ldo_1v2_a_0.VDD.n875 8.46995
R4918 ldo_1v2_a_0.VDD.n879 ldo_1v2_a_0.VDD.n876 8.46995
R4919 ldo_1v2_a_0.VDD.n878 ldo_1v2_a_0.VDD.n877 8.46995
R4920 ldo_1v2_a_0.VDD.n903 ldo_1v2_a_0.VDD.n902 8.46995
R4921 ldo_1v2_a_0.VDD.n905 ldo_1v2_a_0.VDD.n904 8.46995
R4922 ldo_1v2_a_0.VDD.n907 ldo_1v2_a_0.VDD.n906 8.46995
R4923 ldo_1v2_a_0.VDD.n909 ldo_1v2_a_0.VDD.n908 8.46995
R4924 ldo_1v2_a_0.VDD.n911 ldo_1v2_a_0.VDD.n910 8.46995
R4925 ldo_1v2_a_0.VDD.n913 ldo_1v2_a_0.VDD.n912 8.46995
R4926 ldo_1v2_a_0.VDD.n915 ldo_1v2_a_0.VDD.n914 8.46995
R4927 ldo_1v2_a_0.VDD.n917 ldo_1v2_a_0.VDD.n916 8.46995
R4928 ldo_1v2_a_0.VDD.n919 ldo_1v2_a_0.VDD.n918 8.46995
R4929 ldo_1v2_a_0.VDD.n921 ldo_1v2_a_0.VDD.n920 8.46995
R4930 ldo_1v2_a_0.VDD.n923 ldo_1v2_a_0.VDD.n922 8.46995
R4931 ldo_1v2_a_0.VDD.n925 ldo_1v2_a_0.VDD.n924 8.46995
R4932 ldo_1v2_a_0.VDD.n927 ldo_1v2_a_0.VDD.n926 8.46995
R4933 ldo_1v2_a_0.VDD.n929 ldo_1v2_a_0.VDD.n928 8.46995
R4934 ldo_1v2_a_0.VDD.n931 ldo_1v2_a_0.VDD.n930 8.46995
R4935 ldo_1v2_a_0.VDD.n933 ldo_1v2_a_0.VDD.n932 8.46995
R4936 ldo_1v2_a_0.VDD.n935 ldo_1v2_a_0.VDD.n934 8.46995
R4937 ldo_1v2_a_0.VDD.n937 ldo_1v2_a_0.VDD.n936 8.46995
R4938 ldo_1v2_a_0.VDD.n939 ldo_1v2_a_0.VDD.n938 8.46995
R4939 ldo_1v2_a_0.VDD.n941 ldo_1v2_a_0.VDD.n940 8.46995
R4940 ldo_1v2_a_0.VDD.n943 ldo_1v2_a_0.VDD.n942 8.46995
R4941 ldo_1v2_a_0.VDD.n945 ldo_1v2_a_0.VDD.n944 8.46995
R4942 ldo_1v2_a_0.VDD.n947 ldo_1v2_a_0.VDD.n946 8.46995
R4943 ldo_1v2_a_0.VDD.n949 ldo_1v2_a_0.VDD.n948 8.46995
R4944 ldo_1v2_a_0.VDD.n951 ldo_1v2_a_0.VDD.n950 8.46995
R4945 ldo_1v2_a_0.VDD.n953 ldo_1v2_a_0.VDD.n952 8.46995
R4946 ldo_1v2_a_0.VDD.n955 ldo_1v2_a_0.VDD.n954 8.46995
R4947 ldo_1v2_a_0.VDD.n957 ldo_1v2_a_0.VDD.n956 8.46995
R4948 ldo_1v2_a_0.VDD.n959 ldo_1v2_a_0.VDD.n958 8.46995
R4949 ldo_1v2_a_0.VDD.n961 ldo_1v2_a_0.VDD.n960 8.46995
R4950 ldo_1v2_a_0.VDD.n963 ldo_1v2_a_0.VDD.n962 8.46995
R4951 ldo_1v2_a_0.VDD.n965 ldo_1v2_a_0.VDD.n964 8.46995
R4952 ldo_1v2_a_0.VDD.n967 ldo_1v2_a_0.VDD.n966 8.46995
R4953 ldo_1v2_a_0.VDD.n754 ldo_1v2_a_0.VDD.n753 8.46995
R4954 ldo_1v2_a_0.VDD.n756 ldo_1v2_a_0.VDD.n755 8.46995
R4955 ldo_1v2_a_0.VDD.n758 ldo_1v2_a_0.VDD.n757 8.46995
R4956 ldo_1v2_a_0.VDD.n760 ldo_1v2_a_0.VDD.n759 8.46995
R4957 ldo_1v2_a_0.VDD.n762 ldo_1v2_a_0.VDD.n761 8.46995
R4958 ldo_1v2_a_0.VDD.n764 ldo_1v2_a_0.VDD.n763 8.46995
R4959 ldo_1v2_a_0.VDD.n766 ldo_1v2_a_0.VDD.n765 8.46995
R4960 ldo_1v2_a_0.VDD.n768 ldo_1v2_a_0.VDD.n767 8.46995
R4961 ldo_1v2_a_0.VDD.n770 ldo_1v2_a_0.VDD.n769 8.46995
R4962 ldo_1v2_a_0.VDD.n772 ldo_1v2_a_0.VDD.n771 8.46995
R4963 ldo_1v2_a_0.VDD.n774 ldo_1v2_a_0.VDD.n773 8.46995
R4964 ldo_1v2_a_0.VDD.n776 ldo_1v2_a_0.VDD.n775 8.46995
R4965 ldo_1v2_a_0.VDD.n778 ldo_1v2_a_0.VDD.n777 8.46995
R4966 ldo_1v2_a_0.VDD.n780 ldo_1v2_a_0.VDD.n779 8.46995
R4967 ldo_1v2_a_0.VDD.n782 ldo_1v2_a_0.VDD.n781 8.46995
R4968 ldo_1v2_a_0.VDD.n784 ldo_1v2_a_0.VDD.n783 8.46995
R4969 ldo_1v2_a_0.VDD.n786 ldo_1v2_a_0.VDD.n785 8.46995
R4970 ldo_1v2_a_0.VDD.n788 ldo_1v2_a_0.VDD.n787 8.46995
R4971 ldo_1v2_a_0.VDD.n789 ldo_1v2_a_0.VDD.n141 8.46995
R4972 ldo_1v2_a_0.VDD.n791 ldo_1v2_a_0.VDD.n790 8.46995
R4973 ldo_1v2_a_0.VDD.n40 ldo_1v2_a_0.VDD.n38 8.46995
R4974 ldo_1v2_a_0.VDD.n816 ldo_1v2_a_0.VDD.n815 8.46995
R4975 ldo_1v2_a_0.VDD.n818 ldo_1v2_a_0.VDD.n817 8.46995
R4976 ldo_1v2_a_0.VDD.n820 ldo_1v2_a_0.VDD.n819 8.46995
R4977 ldo_1v2_a_0.VDD.n822 ldo_1v2_a_0.VDD.n821 8.46995
R4978 ldo_1v2_a_0.VDD.n824 ldo_1v2_a_0.VDD.n823 8.46995
R4979 ldo_1v2_a_0.VDD.n826 ldo_1v2_a_0.VDD.n825 8.46995
R4980 ldo_1v2_a_0.VDD.n828 ldo_1v2_a_0.VDD.n827 8.46995
R4981 ldo_1v2_a_0.VDD.n830 ldo_1v2_a_0.VDD.n829 8.46995
R4982 ldo_1v2_a_0.VDD.n832 ldo_1v2_a_0.VDD.n831 8.46995
R4983 ldo_1v2_a_0.VDD.n834 ldo_1v2_a_0.VDD.n833 8.46995
R4984 ldo_1v2_a_0.VDD.n836 ldo_1v2_a_0.VDD.n835 8.46995
R4985 ldo_1v2_a_0.VDD.n838 ldo_1v2_a_0.VDD.n837 8.46995
R4986 ldo_1v2_a_0.VDD.n840 ldo_1v2_a_0.VDD.n839 8.46995
R4987 ldo_1v2_a_0.VDD.n842 ldo_1v2_a_0.VDD.n841 8.46995
R4988 ldo_1v2_a_0.VDD.n844 ldo_1v2_a_0.VDD.n843 8.46995
R4989 ldo_1v2_a_0.VDD.n846 ldo_1v2_a_0.VDD.n845 8.46995
R4990 ldo_1v2_a_0.VDD.n848 ldo_1v2_a_0.VDD.n847 8.46995
R4991 ldo_1v2_a_0.VDD.n850 ldo_1v2_a_0.VDD.n849 8.46995
R4992 ldo_1v2_a_0.VDD.n852 ldo_1v2_a_0.VDD.n851 8.46995
R4993 ldo_1v2_a_0.VDD.n854 ldo_1v2_a_0.VDD.n853 8.46995
R4994 ldo_1v2_a_0.VDD.n855 ldo_1v2_a_0.VDD.n814 8.46995
R4995 ldo_1v2_a_0.VDD.n613 ldo_1v2_a_0.VDD.n536 8.46995
R4996 ldo_1v2_a_0.VDD.n666 ldo_1v2_a_0.VDD.n665 8.46995
R4997 ldo_1v2_a_0.VDD.n678 ldo_1v2_a_0.VDD.n338 8.44997
R4998 ldo_1v2_a_0.VDD.n698 ldo_1v2_a_0.VDD.n277 8.44454
R4999 ldo_1v2_a_0.VDD.n494 ldo_1v2_a_0.VDD.t78 7.49298
R5000 ldo_1v2_a_0.VDD.n531 ldo_1v2_a_0.VDD.t100 7.49223
R5001 ldo_1v2_a_0.VDD.n423 ldo_1v2_a_0.VDD.t111 7.45874
R5002 ldo_1v2_a_0.VDD.n450 ldo_1v2_a_0.VDD.t104 7.45874
R5003 ldo_1v2_a_0.VDD.n7 ldo_1v2_a_0.VDD.t117 7.45874
R5004 ldo_1v2_a_0.VDD.n10 ldo_1v2_a_0.VDD.t90 7.45874
R5005 ldo_1v2_a_0.VDD.n708 ldo_1v2_a_0.VDD.n707 5.66778
R5006 ldo_1v2_a_0.VDD.t0 ldo_1v2_a_0.VDD.n41 5.66778
R5007 ldo_1v2_a_0.VDD.n746 ldo_1v2_a_0.VDD.n745 5.66056
R5008 ldo_1v2_a_0.VDD.n210 ldo_1v2_a_0.VDD.t68 5.6377
R5009 ldo_1v2_a_0.VDD.n216 ldo_1v2_a_0.VDD.t67 5.6377
R5010 ldo_1v2_a_0.VDD.n120 ldo_1v2_a_0.VDD.n35 5.63535
R5011 ldo_1v2_a_0.VDD.n211 ldo_1v2_a_0.VDD.t66 5.63513
R5012 ldo_1v2_a_0.VDD.n213 ldo_1v2_a_0.VDD.t65 5.63513
R5013 ldo_1v2_a_0.VDD.n737 ldo_1v2_a_0.VDD.n237 5.63414
R5014 ldo_1v2_a_0.VDD.n969 ldo_1v2_a_0.VDD.n968 5.62487
R5015 ldo_1v2_a_0.VDD.n456 ldo_1v2_a_0.VDD.n393 5.62179
R5016 ldo_1v2_a_0.VDD.n719 ldo_1v2_a_0.VDD.t135 5.61838
R5017 ldo_1v2_a_0.VDD.n566 ldo_1v2_a_0.VDD.n565 5.61281
R5018 ldo_1v2_a_0.VDD.n610 ldo_1v2_a_0.VDD.n609 5.61281
R5019 ldo_1v2_a_0.VDD.n745 ldo_1v2_a_0.VDD.n195 5.5992
R5020 ldo_1v2_a_0.VDD.n751 ldo_1v2_a_0.VDD.n750 5.21452
R5021 ldo_1v2_a_0.VDD.n637 ldo_1v2_a_0.VDD.n383 5.0605
R5022 ldo_1v2_a_0.VDD.t132 ldo_1v2_a_0.VDD.n651 5.0005
R5023 ldo_1v2_a_0.VDD.n652 ldo_1v2_a_0.VDD.t132 5.0005
R5024 ldo_1v2_a_0.VDD.n459 ldo_1v2_a_0.VDD.n383 4.81693
R5025 ldo_1v2_a_0.VDD.n213 ldo_1v2_a_0.VDD.n212 4.73988
R5026 ldo_1v2_a_0.VDD.n217 ldo_1v2_a_0.VDD.n216 4.73687
R5027 ldo_1v2_a_0.VDD.n217 ldo_1v2_a_0.VDD.n210 4.72808
R5028 ldo_1v2_a_0.VDD.n384 ldo_1v2_a_0.VDD.t61 4.69525
R5029 ldo_1v2_a_0.VDD ldo_1v2_a_0.VDD.n211 4.51108
R5030 ldo_1v2_a_0.VDD.n548 ldo_1v2_a_0.VDD.t31 4.25113
R5031 ldo_1v2_a_0.VDD.n538 ldo_1v2_a_0.VDD.t101 4.25113
R5032 ldo_1v2_a_0.VDD.n613 ldo_1v2_a_0.VDD.n469 4.251
R5033 ldo_1v2_a_0.VDD.n613 ldo_1v2_a_0.VDD.n470 4.251
R5034 ldo_1v2_a_0.VDD.n613 ldo_1v2_a_0.VDD.n471 4.251
R5035 ldo_1v2_a_0.VDD.n613 ldo_1v2_a_0.VDD.n472 4.251
R5036 ldo_1v2_a_0.VDD.n613 ldo_1v2_a_0.VDD.n501 4.251
R5037 ldo_1v2_a_0.VDD.n613 ldo_1v2_a_0.VDD.n503 4.251
R5038 ldo_1v2_a_0.VDD.n613 ldo_1v2_a_0.VDD.n504 4.251
R5039 ldo_1v2_a_0.VDD.n613 ldo_1v2_a_0.VDD.n505 4.251
R5040 ldo_1v2_a_0.VDD.n613 ldo_1v2_a_0.VDD.n506 4.251
R5041 ldo_1v2_a_0.VDD.n613 ldo_1v2_a_0.VDD.n508 4.251
R5042 ldo_1v2_a_0.VDD.n613 ldo_1v2_a_0.VDD.n612 4.251
R5043 ldo_1v2_a_0.VDD.t60 ldo_1v2_a_0.VDD.n300 4.251
R5044 ldo_1v2_a_0.VDD.t0 ldo_1v2_a_0.VDD.n121 4.251
R5045 ldo_1v2_a_0.VDD.t0 ldo_1v2_a_0.VDD.n119 4.251
R5046 ldo_1v2_a_0.VDD.t31 ldo_1v2_a_0.VDD.n329 4.2505
R5047 ldo_1v2_a_0.VDD.t101 ldo_1v2_a_0.VDD.n329 4.2505
R5048 ldo_1v2_a_0.VDD.n613 ldo_1v2_a_0.VDD.n464 4.24242
R5049 ldo_1v2_a_0.VDD.n301 ldo_1v2_a_0.VDD.n269 4.20667
R5050 ldo_1v2_a_0.VDD.n901 ldo_1v2_a_0.VDD.n900 4.18441
R5051 ldo_1v2_a_0.VDD.n744 ldo_1v2_a_0.VDD.n242 4.17435
R5052 ldo_1v2_a_0.VDD.n459 ldo_1v2_a_0.VDD.n458 3.51573
R5053 ldo_1v2_a_0.VDD.n752 ldo_1v2_a_0.VDD.n185 3.38004
R5054 ldo_1v2_a_0.VDD.n999 ldo_1v2_a_0.VDD.n2 3.34326
R5055 ldo_1v2_a_0.VDD.n729 ldo_1v2_a_0.VDD.n236 3.30365
R5056 ldo_1v2_a_0.VDD.n745 ldo_1v2_a_0.VDD.n191 3.2806
R5057 ldo_1v2_a_0.VDD.n659 ldo_1v2_a_0.VDD.n267 2.80781
R5058 ldo_1v2_a_0.VDD.n261 ldo_1v2_a_0.VDD.n239 2.72923
R5059 ldo_1v2_a_0.VDD.n718 ldo_1v2_a_0.VDD.n239 2.72656
R5060 ldo_1v2_a_0.VDD.n731 ldo_1v2_a_0.VDD.n236 2.72608
R5061 ldo_1v2_a_0.VDD.n733 ldo_1v2_a_0.VDD.n236 2.71834
R5062 ldo_1v2_a_0.VDD.n259 ldo_1v2_a_0.VDD.n239 2.71697
R5063 ldo_1v2_a_0.VDD.n665 ldo_1v2_a_0.VDD.n644 2.69993
R5064 ldo_1v2_a_0.VDD.n648 ldo_1v2_a_0.VDD.t85 2.51599
R5065 ldo_1v2_a_0.VDD.n268 ldo_1v2_a_0.VDD.n267 2.36678
R5066 ldo_1v2_a_0.VDD.n386 ldo_1v2_a_0.VDD.n384 2.3405
R5067 ldo_1v2_a_0.VDD.n976 ldo_1v2_a_0.VDD.n974 2.33943
R5068 ldo_1v2_a_0.VDD.n449 ldo_1v2_a_0.VDD.t109 2.31869
R5069 ldo_1v2_a_0.VDD.n451 ldo_1v2_a_0.VDD.t110 2.31869
R5070 ldo_1v2_a_0.VDD.n6 ldo_1v2_a_0.VDD.t121 2.31869
R5071 ldo_1v2_a_0.VDD.n8 ldo_1v2_a_0.VDD.t122 2.31869
R5072 ldo_1v2_a_0.VDD.n424 ldo_1v2_a_0.VDD.t112 2.31605
R5073 ldo_1v2_a_0.VDD.n422 ldo_1v2_a_0.VDD.t113 2.31605
R5074 ldo_1v2_a_0.VDD.n11 ldo_1v2_a_0.VDD.t92 2.31605
R5075 ldo_1v2_a_0.VDD.n9 ldo_1v2_a_0.VDD.t93 2.31605
R5076 ldo_1v2_a_0.VDD.n384 ldo_1v2_a_0.VDD.t57 2.31525
R5077 ldo_1v2_a_0.VDD.n424 ldo_1v2_a_0.VDD.t115 2.31525
R5078 ldo_1v2_a_0.VDD.n422 ldo_1v2_a_0.VDD.t116 2.31525
R5079 ldo_1v2_a_0.VDD.n11 ldo_1v2_a_0.VDD.t98 2.31525
R5080 ldo_1v2_a_0.VDD.n9 ldo_1v2_a_0.VDD.t99 2.31525
R5081 ldo_1v2_a_0.VDD.n438 ldo_1v2_a_0.VDD.t40 2.3132
R5082 ldo_1v2_a_0.VDD.n437 ldo_1v2_a_0.VDD.t37 2.3132
R5083 ldo_1v2_a_0.VDD.n436 ldo_1v2_a_0.VDD.t38 2.3132
R5084 ldo_1v2_a_0.VDD.n435 ldo_1v2_a_0.VDD.t46 2.3132
R5085 ldo_1v2_a_0.VDD.n449 ldo_1v2_a_0.VDD.t106 2.31261
R5086 ldo_1v2_a_0.VDD.n451 ldo_1v2_a_0.VDD.t107 2.31261
R5087 ldo_1v2_a_0.VDD.n6 ldo_1v2_a_0.VDD.t118 2.31261
R5088 ldo_1v2_a_0.VDD.n8 ldo_1v2_a_0.VDD.t119 2.31261
R5089 ldo_1v2_a_0.VDD.n744 ldo_1v2_a_0.VDD.n245 2.31162
R5090 ldo_1v2_a_0.VDD.n640 ldo_1v2_a_0.VDD.n330 2.3037
R5091 ldo_1v2_a_0.VDD.n989 ldo_1v2_a_0.VDD.t7 2.2809
R5092 ldo_1v2_a_0.VDD.n987 ldo_1v2_a_0.VDD.t4 2.2809
R5093 ldo_1v2_a_0.VDD.n985 ldo_1v2_a_0.VDD.t3 2.2809
R5094 ldo_1v2_a_0.VDD.n983 ldo_1v2_a_0.VDD.t6 2.2809
R5095 ldo_1v2_a_0.VDD.n981 ldo_1v2_a_0.VDD.t17 2.2809
R5096 ldo_1v2_a_0.VDD.n979 ldo_1v2_a_0.VDD.t12 2.2809
R5097 ldo_1v2_a_0.VDD.n975 ldo_1v2_a_0.VDD.t15 2.2809
R5098 ldo_1v2_a_0.VDD.n977 ldo_1v2_a_0.VDD.t21 2.2809
R5099 ldo_1v2_a_0.VDD.n654 ldo_1v2_a_0.VDD.t72 2.27836
R5100 ldo_1v2_a_0.VDD.n654 ldo_1v2_a_0.VDD.n653 2.2705
R5101 ldo_1v2_a_0.VDD.n987 ldo_1v2_a_0.VDD.t13 2.26969
R5102 ldo_1v2_a_0.VDD.n985 ldo_1v2_a_0.VDD.t19 2.26969
R5103 ldo_1v2_a_0.VDD.n983 ldo_1v2_a_0.VDD.t18 2.26969
R5104 ldo_1v2_a_0.VDD.n981 ldo_1v2_a_0.VDD.t2 2.26969
R5105 ldo_1v2_a_0.VDD.n979 ldo_1v2_a_0.VDD.t24 2.26969
R5106 ldo_1v2_a_0.VDD.n975 ldo_1v2_a_0.VDD.t9 2.26969
R5107 ldo_1v2_a_0.VDD.n989 ldo_1v2_a_0.VDD.t20 2.26703
R5108 ldo_1v2_a_0.VDD.n977 ldo_1v2_a_0.VDD.t1 2.26481
R5109 ldo_1v2_a_0.VDD.n655 ldo_1v2_a_0.VDD.t74 2.26124
R5110 ldo_1v2_a_0.VDD.n749 ldo_1v2_a_0.VDD.n748 2.22112
R5111 ldo_1v2_a_0.VDD.n438 ldo_1v2_a_0.VDD.t36 2.19633
R5112 ldo_1v2_a_0.VDD.n437 ldo_1v2_a_0.VDD.t45 2.19633
R5113 ldo_1v2_a_0.VDD.n436 ldo_1v2_a_0.VDD.t49 2.19633
R5114 ldo_1v2_a_0.VDD.n435 ldo_1v2_a_0.VDD.t41 2.19633
R5115 ldo_1v2_a_0.VDD.n655 ldo_1v2_a_0.VDD.n654 2.1805
R5116 ldo_1v2_a_0.VDD.n745 ldo_1v2_a_0.VDD.n196 2.13611
R5117 ldo_1v2_a_0.VDD.n613 ldo_1v2_a_0.VDD.n500 2.12619
R5118 ldo_1v2_a_0.VDD.n613 ldo_1v2_a_0.VDD.n537 2.126
R5119 ldo_1v2_a_0.VDD.n750 ldo_1v2_a_0.VDD.n749 2.06071
R5120 ldo_1v2_a_0.VDD.n439 ldo_1v2_a_0.VDD.t42 2.01722
R5121 ldo_1v2_a_0.VDD.n434 ldo_1v2_a_0.VDD.t52 2.01722
R5122 ldo_1v2_a_0.VDD.n439 ldo_1v2_a_0.VDD.t53 2.01696
R5123 ldo_1v2_a_0.VDD.n434 ldo_1v2_a_0.VDD.t44 2.01696
R5124 ldo_1v2_a_0.VDD.n744 ldo_1v2_a_0.VDD.n743 2.01041
R5125 ldo_1v2_a_0.VDD.n991 ldo_1v2_a_0.VDD.n990 2.00503
R5126 ldo_1v2_a_0.VDD.n2 ldo_1v2_a_0.VDD.n1 1.98219
R5127 ldo_1v2_a_0.VDD.n613 ldo_1v2_a_0.VDD.n499 1.97603
R5128 ldo_1v2_a_0.VDD.n717 ldo_1v2_a_0.VDD.n236 1.97148
R5129 ldo_1v2_a_0.VDD.n735 ldo_1v2_a_0.VDD.n237 1.97148
R5130 ldo_1v2_a_0.VDD.n744 ldo_1v2_a_0.VDD.n243 1.96232
R5131 ldo_1v2_a_0.VDD.n672 ldo_1v2_a_0.VDD.n671 1.87401
R5132 ldo_1v2_a_0.VDD.n670 ldo_1v2_a_0.VDD.n669 1.87205
R5133 ldo_1v2_a_0.VDD.n674 ldo_1v2_a_0.VDD.n673 1.86894
R5134 ldo_1v2_a_0.VDD.n668 ldo_1v2_a_0.VDD.n349 1.86407
R5135 ldo_1v2_a_0.VDD.n438 ldo_1v2_a_0.VDD.n437 1.78638
R5136 ldo_1v2_a_0.VDD.n437 ldo_1v2_a_0.VDD.n436 1.78638
R5137 ldo_1v2_a_0.VDD.n436 ldo_1v2_a_0.VDD.n435 1.78638
R5138 ldo_1v2_a_0.VDD.n636 ldo_1v2_a_0.VDD.n461 1.76618
R5139 ldo_1v2_a_0.VDD.n439 ldo_1v2_a_0.VDD.n438 1.74485
R5140 ldo_1v2_a_0.VDD.n435 ldo_1v2_a_0.VDD.n434 1.74485
R5141 ldo_1v2_a_0.VDD.n456 ldo_1v2_a_0.VDD.n395 1.73315
R5142 ldo_1v2_a_0.VDD.n257 ldo_1v2_a_0.VDD.n239 1.71723
R5143 ldo_1v2_a_0.VDD.n671 ldo_1v2_a_0.VDD.n670 1.69845
R5144 ldo_1v2_a_0.VDD.n636 ldo_1v2_a_0.VDD.n389 1.66893
R5145 ldo_1v2_a_0.VDD.n674 ldo_1v2_a_0.VDD.n349 1.6646
R5146 ldo_1v2_a_0.VDD.n215 ldo_1v2_a_0.VDD.n214 1.5476
R5147 ldo_1v2_a_0.VDD.n442 ldo_1v2_a_0.VDD.n441 1.54403
R5148 ldo_1v2_a_0.VDD.n995 ldo_1v2_a_0.VDD.n994 1.49599
R5149 ldo_1v2_a_0.VDD.n452 ldo_1v2_a_0.VDD.n446 1.49256
R5150 ldo_1v2_a_0.VDD.n636 ldo_1v2_a_0.VDD.n390 1.45772
R5151 ldo_1v2_a_0.VDD.n442 ldo_1v2_a_0.VDD 1.44517
R5152 ldo_1v2_a_0.VDD.n433 ldo_1v2_a_0.VDD.n429 1.42399
R5153 ldo_1v2_a_0.VDD.n535 ldo_1v2_a_0.VDD.n466 1.42355
R5154 ldo_1v2_a_0.VDD.n457 ldo_1v2_a_0.VDD.n392 1.39607
R5155 ldo_1v2_a_0.VDD.n186 ldo_1v2_a_0.VDD.n0 1.39045
R5156 ldo_1v2_a_0.VDD.n440 ldo_1v2_a_0.VDD.n429 1.38828
R5157 ldo_1v2_a_0.VDD.n361 ldo_1v2_a_0.VDD.n360 1.37725
R5158 ldo_1v2_a_0.VDD.n724 ldo_1v2_a_0.VDD.n723 1.37685
R5159 ldo_1v2_a_0.VDD.n441 ldo_1v2_a_0.VDD.n440 1.37187
R5160 ldo_1v2_a_0.VDD.n446 ldo_1v2_a_0.VDD.n445 1.37083
R5161 ldo_1v2_a_0.VDD.n527 ldo_1v2_a_0.VDD.n466 1.35394
R5162 ldo_1v2_a_0.VDD.n751 ldo_1v2_a_0.VDD.n186 1.34569
R5163 ldo_1v2_a_0.VDD.n613 ldo_1v2_a_0.VDD.n507 1.3443
R5164 ldo_1v2_a_0.VDD.n657 ldo_1v2_a_0.VDD.n267 1.34355
R5165 ldo_1v2_a_0.VDD.n614 ldo_1v2_a_0.VDD.n465 1.33579
R5166 ldo_1v2_a_0.VDD.n998 ldo_1v2_a_0.VDD.n3 1.3332
R5167 ldo_1v2_a_0.VDD.n444 ldo_1v2_a_0.VDD.n443 1.31979
R5168 ldo_1v2_a_0.VDD.n993 ldo_1v2_a_0.VDD.n992 1.31425
R5169 ldo_1v2_a_0.VDD.n1001 ldo_1v2_a_0.VDD.n1000 1.31418
R5170 ldo_1v2_a_0.VDD.n445 ldo_1v2_a_0.VDD.n444 1.31175
R5171 ldo_1v2_a_0.VDD.t33 ldo_1v2_a_0.VDD.n237 1.30819
R5172 ldo_1v2_a_0.VDD.n1002 ldo_1v2_a_0.VDD.n1001 1.29722
R5173 ldo_1v2_a_0.VDD.n443 ldo_1v2_a_0.VDD.n442 1.28154
R5174 ldo_1v2_a_0.VDD.n590 ldo_1v2_a_0.VDD.n361 1.26821
R5175 ldo_1v2_a_0.VDD.n994 ldo_1v2_a_0.VDD.n993 1.26569
R5176 ldo_1v2_a_0.VDD.n725 ldo_1v2_a_0.VDD.n724 1.26116
R5177 ldo_1v2_a_0.VDD.n615 ldo_1v2_a_0.VDD.n614 1.25836
R5178 ldo_1v2_a_0.VDD.n458 ldo_1v2_a_0.VDD.n457 1.23489
R5179 ldo_1v2_a_0.VDD.n447 ldo_1v2_a_0.VDD.n394 1.21933
R5180 ldo_1v2_a_0.VDD.n385 ldo_1v2_a_0.VDD.t63 1.21778
R5181 ldo_1v2_a_0.VDD.n414 ldo_1v2_a_0.VDD.t151 1.21777
R5182 ldo_1v2_a_0.VDD.n26 ldo_1v2_a_0.VDD.t146 1.21777
R5183 ldo_1v2_a_0.VDD.n414 ldo_1v2_a_0.VDD.t153 1.21769
R5184 ldo_1v2_a_0.VDD.n26 ldo_1v2_a_0.VDD.t148 1.21769
R5185 ldo_1v2_a_0.VDD.n385 ldo_1v2_a_0.VDD.t59 1.21769
R5186 ldo_1v2_a_0.VDD.n639 ldo_1v2_a_0.VDD.n638 1.21087
R5187 ldo_1v2_a_0.VDD.n591 ldo_1v2_a_0.VDD.n330 1.20802
R5188 ldo_1v2_a_0.VDD.n609 ldo_1v2_a_0.VDD.n608 1.12045
R5189 ldo_1v2_a_0.VDD.n419 ldo_1v2_a_0.VDD.n394 1.10856
R5190 ldo_1v2_a_0.VDD ldo_1v2_a_0.VDD.n0 1.09867
R5191 ldo_1v2_a_0.VDD.n218 ldo_1v2_a_0.VDD.n209 1.0974
R5192 ldo_1v2_a_0.VDD.n637 ldo_1v2_a_0.VDD 1.09317
R5193 ldo_1v2_a_0.VDD.n12 ldo_1v2_a_0.VDD.n3 1.09163
R5194 ldo_1v2_a_0.VDD.n665 ldo_1v2_a_0.VDD.n664 1.08547
R5195 ldo_1v2_a_0.VDD.n641 ldo_1v2_a_0.VDD.n351 1.0742
R5196 ldo_1v2_a_0.VDD.n636 ldo_1v2_a_0.VDD.n635 1.07408
R5197 ldo_1v2_a_0.VDD.n726 ldo_1v2_a_0.VDD.n239 1.07227
R5198 ldo_1v2_a_0.VDD.t60 ldo_1v2_a_0.VDD.n329 1.063
R5199 ldo_1v2_a_0.VDD.n220 ldo_1v2_a_0.VDD.n218 1.05182
R5200 ldo_1v2_a_0.VDD.n453 ldo_1v2_a_0.VDD.n452 1.04812
R5201 ldo_1v2_a_0.VDD.n996 ldo_1v2_a_0.VDD.n995 1.04812
R5202 ldo_1v2_a_0.VDD.n425 ldo_1v2_a_0.VDD.n421 1.01635
R5203 ldo_1v2_a_0.VDD.n33 ldo_1v2_a_0.VDD.n32 1.01635
R5204 ldo_1v2_a_0.VDD.n247 ldo_1v2_a_0.VDD.n234 1.001
R5205 ldo_1v2_a_0.VDD.n426 ldo_1v2_a_0.VDD.n425 0.999039
R5206 ldo_1v2_a_0.VDD.n421 ldo_1v2_a_0.VDD.n420 0.98486
R5207 ldo_1v2_a_0.VDD.n32 ldo_1v2_a_0.VDD.n31 0.98486
R5208 ldo_1v2_a_0.VDD.n34 ldo_1v2_a_0.VDD.n33 0.964161
R5209 ldo_1v2_a_0.VDD.n715 ldo_1v2_a_0.VDD.n266 0.958217
R5210 ldo_1v2_a_0.VDD.n649 ldo_1v2_a_0.VDD.n244 0.944142
R5211 ldo_1v2_a_0.VDD.n722 ldo_1v2_a_0.VDD.n721 0.942375
R5212 ldo_1v2_a_0.VDD.n723 ldo_1v2_a_0.VDD.n722 0.942375
R5213 ldo_1v2_a_0.VDD.n263 ldo_1v2_a_0.VDD.t86 0.937592
R5214 ldo_1v2_a_0.VDD.n453 ldo_1v2_a_0.VDD.n448 0.923466
R5215 ldo_1v2_a_0.VDD.n997 ldo_1v2_a_0.VDD.n996 0.923466
R5216 ldo_1v2_a_0.VDD.n527 ldo_1v2_a_0.VDD.n467 0.887923
R5217 ldo_1v2_a_0.VDD.n993 ldo_1v2_a_0.VDD.n34 0.88512
R5218 ldo_1v2_a_0.VDD.n739 ldo_1v2_a_0.VDD.n247 0.882772
R5219 ldo_1v2_a_0.VDD.n707 ldo_1v2_a_0.VDD.n266 0.879741
R5220 ldo_1v2_a_0.VDD.n667 ldo_1v2_a_0.VDD.n351 0.877698
R5221 ldo_1v2_a_0.VDD.n431 ldo_1v2_a_0.VDD.n427 0.876792
R5222 ldo_1v2_a_0.VDD.n454 ldo_1v2_a_0.VDD.n400 0.87628
R5223 ldo_1v2_a_0.VDD.n467 ldo_1v2_a_0.VDD.n465 0.876184
R5224 ldo_1v2_a_0.VDD.n740 ldo_1v2_a_0.VDD.n739 0.875188
R5225 ldo_1v2_a_0.VDD.n5 ldo_1v2_a_0.VDD.n4 0.874719
R5226 ldo_1v2_a_0.VDD.n721 ldo_1v2_a_0.VDD.n720 0.871609
R5227 ldo_1v2_a_0.VDD.n723 ldo_1v2_a_0.VDD.n720 0.871208
R5228 ldo_1v2_a_0.VDD.n635 ldo_1v2_a_0.VDD.n617 0.866082
R5229 ldo_1v2_a_0.VDD.n739 ldo_1v2_a_0.VDD.n738 0.853823
R5230 ldo_1v2_a_0.VDD.n712 ldo_1v2_a_0.VDD.n710 0.85096
R5231 ldo_1v2_a_0.VDD.n997 ldo_1v2_a_0.VDD.n4 0.845753
R5232 ldo_1v2_a_0.VDD.n726 ldo_1v2_a_0.VDD.n725 0.842712
R5233 ldo_1v2_a_0.VDD.n433 ldo_1v2_a_0.VDD.n427 0.84222
R5234 ldo_1v2_a_0.VDD.n448 ldo_1v2_a_0.VDD.n400 0.841289
R5235 ldo_1v2_a_0.VDD.n212 ldo_1v2_a_0.VDD.n192 0.818827
R5236 ldo_1v2_a_0.VDD.n218 ldo_1v2_a_0.VDD.n217 0.818682
R5237 ldo_1v2_a_0.VDD.n664 ldo_1v2_a_0.VDD.n663 0.815415
R5238 ldo_1v2_a_0.VDD.n460 ldo_1v2_a_0.VDD.n390 0.814137
R5239 ldo_1v2_a_0.VDD.n978 ldo_1v2_a_0.VDD.n976 0.8101
R5240 ldo_1v2_a_0.VDD.n980 ldo_1v2_a_0.VDD.n978 0.8101
R5241 ldo_1v2_a_0.VDD.n982 ldo_1v2_a_0.VDD.n980 0.8101
R5242 ldo_1v2_a_0.VDD.n984 ldo_1v2_a_0.VDD.n982 0.8101
R5243 ldo_1v2_a_0.VDD.n986 ldo_1v2_a_0.VDD.n984 0.8101
R5244 ldo_1v2_a_0.VDD.n988 ldo_1v2_a_0.VDD.n986 0.8101
R5245 ldo_1v2_a_0.VDD.n990 ldo_1v2_a_0.VDD.n988 0.8101
R5246 ldo_1v2_a_0.VDD.n445 ldo_1v2_a_0.VDD.n426 0.808959
R5247 ldo_1v2_a_0.VDD.n417 ldo_1v2_a_0.VDD.n400 0.807928
R5248 ldo_1v2_a_0.VDD.n29 ldo_1v2_a_0.VDD.n4 0.802632
R5249 ldo_1v2_a_0.VDD.n390 ldo_1v2_a_0.VDD.n383 0.787029
R5250 ldo_1v2_a_0.VDD.n30 ldo_1v2_a_0.VDD.n29 0.785937
R5251 ldo_1v2_a_0.VDD.n418 ldo_1v2_a_0.VDD.n417 0.782205
R5252 ldo_1v2_a_0.VDD.n444 ldo_1v2_a_0.VDD.n427 0.756625
R5253 ldo_1v2_a_0.VDD.n637 ldo_1v2_a_0.VDD.n636 0.73963
R5254 ldo_1v2_a_0.VDD.n635 ldo_1v2_a_0.VDD.n634 0.735632
R5255 ldo_1v2_a_0.VDD.n454 ldo_1v2_a_0.VDD.n418 0.730224
R5256 ldo_1v2_a_0.VDD.n30 ldo_1v2_a_0.VDD.n5 0.729245
R5257 ldo_1v2_a_0.VDD.n727 ldo_1v2_a_0.VDD.n726 0.729061
R5258 ldo_1v2_a_0.VDD.n709 ldo_1v2_a_0.VDD.n266 0.722671
R5259 ldo_1v2_a_0.VDD.n34 ldo_1v2_a_0.VDD.n5 0.719972
R5260 ldo_1v2_a_0.VDD.n420 ldo_1v2_a_0.VDD.n418 0.719826
R5261 ldo_1v2_a_0.VDD.n720 ldo_1v2_a_0.VDD.n239 0.717314
R5262 ldo_1v2_a_0.VDD.n31 ldo_1v2_a_0.VDD.n30 0.716058
R5263 ldo_1v2_a_0.VDD.n389 ldo_1v2_a_0.VDD 0.701679
R5264 ldo_1v2_a_0.VDD.n657 ldo_1v2_a_0.VDD.n656 0.695947
R5265 ldo_1v2_a_0.VDD.n389 ldo_1v2_a_0.VDD.n383 0.688353
R5266 ldo_1v2_a_0.VDD.n608 ldo_1v2_a_0.VDD.n330 0.675006
R5267 ldo_1v2_a_0.VDD.n607 ldo_1v2_a_0.VDD.n591 0.667828
R5268 ldo_1v2_a_0.VDD.n454 ldo_1v2_a_0.VDD.n426 0.658132
R5269 ldo_1v2_a_0.VDD.n454 ldo_1v2_a_0.VDD.n421 0.655112
R5270 ldo_1v2_a_0.VDD.n32 ldo_1v2_a_0.VDD.n5 0.655112
R5271 ldo_1v2_a_0.VDD.n267 ldo_1v2_a_0.VDD.n240 0.654846
R5272 ldo_1v2_a_0.VDD.t33 ldo_1v2_a_0.VDD.n236 0.654346
R5273 ldo_1v2_a_0.VDD.n539 ldo_1v2_a_0.VDD.n507 0.645616
R5274 ldo_1v2_a_0.VDD.n608 ldo_1v2_a_0.VDD.n607 0.632556
R5275 ldo_1v2_a_0.VDD.n591 ldo_1v2_a_0.VDD.n590 0.619084
R5276 ldo_1v2_a_0.VDD.n454 ldo_1v2_a_0.VDD.n453 0.598536
R5277 ldo_1v2_a_0.VDD.n996 ldo_1v2_a_0.VDD.n5 0.598536
R5278 ldo_1v2_a_0.VDD.n664 ldo_1v2_a_0.VDD.n350 0.572107
R5279 ldo_1v2_a_0.VDD.n209 ldo_1v2_a_0.VDD.n208 0.56169
R5280 ldo_1v2_a_0.VDD.n258 ldo_1v2_a_0.VDD.n257 0.554816
R5281 ldo_1v2_a_0.VDD.n649 ldo_1v2_a_0.VDD.n243 0.553396
R5282 ldo_1v2_a_0.VDD.n658 ldo_1v2_a_0.VDD.n657 0.551483
R5283 ldo_1v2_a_0.VDD.n745 ldo_1v2_a_0.VDD.n209 0.546591
R5284 ldo_1v2_a_0.VDD.n243 ldo_1v2_a_0.VDD 0.546003
R5285 ldo_1v2_a_0.VDD.n546 ldo_1v2_a_0.VDD.n507 0.545468
R5286 ldo_1v2_a_0.VDD.n452 ldo_1v2_a_0.VDD.n451 0.543
R5287 ldo_1v2_a_0.VDD.n995 ldo_1v2_a_0.VDD.n8 0.543
R5288 ldo_1v2_a_0.VDD.n425 ldo_1v2_a_0.VDD.n424 0.538
R5289 ldo_1v2_a_0.VDD.n33 ldo_1v2_a_0.VDD.n11 0.538
R5290 ldo_1v2_a_0.VDD.n744 ldo_1v2_a_0.VDD.n244 0.530307
R5291 ldo_1v2_a_0.VDD.n735 ldo_1v2_a_0.VDD.n734 0.529604
R5292 ldo_1v2_a_0.VDD.t60 ldo_1v2_a_0.VDD.n322 0.516151
R5293 ldo_1v2_a_0.VDD.n717 ldo_1v2_a_0.VDD.n716 0.51127
R5294 ldo_1v2_a_0.VDD.n419 ldo_1v2_a_0.VDD.n395 0.509107
R5295 ldo_1v2_a_0.VDD.n257 ldo_1v2_a_0.VDD.n255 0.507416
R5296 ldo_1v2_a_0.VDD.n665 ldo_1v2_a_0.VDD.n351 0.507051
R5297 ldo_1v2_a_0.VDD.n728 ldo_1v2_a_0.VDD.n717 0.504822
R5298 ldo_1v2_a_0.VDD.n220 ldo_1v2_a_0.VDD.n219 0.495982
R5299 ldo_1v2_a_0.VDD.n1002 ldo_1v2_a_0.VDD.n1 0.473177
R5300 ldo_1v2_a_0.VDD.n12 ldo_1v2_a_0.VDD.n1 0.461993
R5301 ldo_1v2_a_0.VDD.n613 ldo_1v2_a_0.VDD.n468 0.460459
R5302 ldo_1v2_a_0.VDD.n248 ldo_1v2_a_0.VDD.t71 0.458601
R5303 ldo_1v2_a_0.VDD.n650 ldo_1v2_a_0.VDD.n245 0.455061
R5304 ldo_1v2_a_0.VDD.n260 ldo_1v2_a_0.VDD.n259 0.452993
R5305 ldo_1v2_a_0.VDD.n736 ldo_1v2_a_0.VDD.n735 0.451655
R5306 ldo_1v2_a_0.VDD.n499 ldo_1v2_a_0.VDD.n498 0.44188
R5307 ldo_1v2_a_0.VDD.n638 ldo_1v2_a_0.VDD.n637 0.43868
R5308 ldo_1v2_a_0.VDD.n613 ldo_1v2_a_0.VDD.n328 0.436857
R5309 ldo_1v2_a_0.VDD.n650 ldo_1v2_a_0.VDD.n244 0.435644
R5310 ldo_1v2_a_0.VDD.n215 ldo_1v2_a_0.VDD.n211 0.434057
R5311 ldo_1v2_a_0.VDD.n214 ldo_1v2_a_0.VDD.n213 0.434057
R5312 ldo_1v2_a_0.VDD.n214 ldo_1v2_a_0.VDD.n210 0.425595
R5313 ldo_1v2_a_0.VDD.n216 ldo_1v2_a_0.VDD.n215 0.425595
R5314 ldo_1v2_a_0.VDD.n461 ldo_1v2_a_0.VDD.n460 0.424758
R5315 ldo_1v2_a_0.VDD.n745 ldo_1v2_a_0.VDD.n220 0.422816
R5316 ldo_1v2_a_0.VDD.n644 ldo_1v2_a_0.VDD.n350 0.416289
R5317 ldo_1v2_a_0.VDD.n395 ldo_1v2_a_0.VDD.n392 0.415708
R5318 ldo_1v2_a_0.VDD.n734 ldo_1v2_a_0.VDD.n733 0.415432
R5319 ldo_1v2_a_0.VDD.n640 ldo_1v2_a_0.VDD.n639 0.414104
R5320 ldo_1v2_a_0.VDD.n707 ldo_1v2_a_0.VDD.n706 0.404026
R5321 ldo_1v2_a_0.VDD ldo_1v2_a_0.VDD.n392 0.398333
R5322 ldo_1v2_a_0.VDD ldo_1v2_a_0.VDD.n1002 0.398333
R5323 ldo_1v2_a_0.VDD.n202 ldo_1v2_a_0.VDD.n196 0.391747
R5324 ldo_1v2_a_0.VDD.n745 ldo_1v2_a_0.VDD.n192 0.386864
R5325 ldo_1v2_a_0.VDD.n262 ldo_1v2_a_0.VDD.n261 0.378131
R5326 ldo_1v2_a_0.VDD.n568 ldo_1v2_a_0.VDD.n499 0.376728
R5327 ldo_1v2_a_0.VDD.n202 ldo_1v2_a_0.VDD.n195 0.376084
R5328 ldo_1v2_a_0.VDD.n654 ldo_1v2_a_0.VDD.n649 0.373153
R5329 ldo_1v2_a_0.VDD.n707 ldo_1v2_a_0.VDD.n268 0.373011
R5330 ldo_1v2_a_0.VDD.n386 ldo_1v2_a_0.VDD.n385 0.370507
R5331 ldo_1v2_a_0.VDD.n727 ldo_1v2_a_0.VDD.n718 0.36482
R5332 ldo_1v2_a_0.VDD.n644 ldo_1v2_a_0.VDD 0.360963
R5333 ldo_1v2_a_0.VDD.n903 ldo_1v2_a_0.VDD.n901 0.360233
R5334 ldo_1v2_a_0.VDD.t60 ldo_1v2_a_0.VDD.n330 0.354667
R5335 ldo_1v2_a_0.VDD.n732 ldo_1v2_a_0.VDD.n731 0.353952
R5336 ldo_1v2_a_0.VDD.n424 ldo_1v2_a_0.VDD.n423 0.350521
R5337 ldo_1v2_a_0.VDD.n450 ldo_1v2_a_0.VDD.n449 0.350521
R5338 ldo_1v2_a_0.VDD.n7 ldo_1v2_a_0.VDD.n6 0.350521
R5339 ldo_1v2_a_0.VDD.n11 ldo_1v2_a_0.VDD.n10 0.350521
R5340 ldo_1v2_a_0.VDD.n730 ldo_1v2_a_0.VDD.n262 0.346468
R5341 ldo_1v2_a_0.VDD.n423 ldo_1v2_a_0.VDD.n422 0.340521
R5342 ldo_1v2_a_0.VDD.n451 ldo_1v2_a_0.VDD.n450 0.340521
R5343 ldo_1v2_a_0.VDD.n8 ldo_1v2_a_0.VDD.n7 0.340521
R5344 ldo_1v2_a_0.VDD.n10 ldo_1v2_a_0.VDD.n9 0.340521
R5345 ldo_1v2_a_0.VDD.n415 ldo_1v2_a_0.VDD.n414 0.340083
R5346 ldo_1v2_a_0.VDD.n27 ldo_1v2_a_0.VDD.n26 0.340083
R5347 ldo_1v2_a_0.VDD.t33 ldo_1v2_a_0.VDD.n744 0.334833
R5348 ldo_1v2_a_0.VDD.n901 ldo_1v2_a_0.VDD.n899 0.333833
R5349 ldo_1v2_a_0.VDD.n741 ldo_1v2_a_0.VDD.n191 0.331157
R5350 ldo_1v2_a_0.VDD.n641 ldo_1v2_a_0.VDD.n640 0.326969
R5351 ldo_1v2_a_0.VDD.n730 ldo_1v2_a_0.VDD.n729 0.325533
R5352 ldo_1v2_a_0.VDD.n647 ldo_1v2_a_0.VDD.n269 0.32511
R5353 ldo_1v2_a_0.VDD.n616 ldo_1v2_a_0.VDD.n615 0.319341
R5354 ldo_1v2_a_0.VDD.n673 ldo_1v2_a_0.VDD.t137 0.317908
R5355 ldo_1v2_a_0.VDD.n668 ldo_1v2_a_0.VDD.t138 0.317346
R5356 ldo_1v2_a_0.VDD.n669 ldo_1v2_a_0.VDD.t139 0.316604
R5357 ldo_1v2_a_0.VDD.n672 ldo_1v2_a_0.VDD.t140 0.316215
R5358 ldo_1v2_a_0.VDD.n566 ldo_1v2_a_0.VDD.n549 0.312698
R5359 ldo_1v2_a_0.VDD.t60 ldo_1v2_a_0.VDD.n327 0.310091
R5360 ldo_1v2_a_0.VDD.n613 ldo_1v2_a_0.VDD.n467 0.307939
R5361 ldo_1v2_a_0.VDD ldo_1v2_a_0.VDD.n660 0.306763
R5362 ldo_1v2_a_0.VDD.n656 ldo_1v2_a_0.VDD.n242 0.306281
R5363 ldo_1v2_a_0.VDD.n748 ldo_1v2_a_0.VDD.n191 0.303925
R5364 ldo_1v2_a_0.VDD.n569 ldo_1v2_a_0.VDD.n568 0.30187
R5365 ldo_1v2_a_0.VDD.n699 ldo_1v2_a_0.VDD.n698 0.301184
R5366 ldo_1v2_a_0.VDD.n698 ldo_1v2_a_0.VDD.n697 0.301184
R5367 ldo_1v2_a_0.VDD.n968 ldo_1v2_a_0.VDD.n967 0.294636
R5368 ldo_1v2_a_0.VDD.n742 ldo_1v2_a_0.VDD.n245 0.292252
R5369 ldo_1v2_a_0.VDD.n678 ldo_1v2_a_0.VDD.n677 0.290323
R5370 ldo_1v2_a_0.VDD.n679 ldo_1v2_a_0.VDD.n678 0.290323
R5371 ldo_1v2_a_0.VDD.n743 ldo_1v2_a_0.VDD.n740 0.289984
R5372 ldo_1v2_a_0.VDD.n729 ldo_1v2_a_0.VDD.n728 0.288272
R5373 ldo_1v2_a_0.VDD.n656 ldo_1v2_a_0.VDD.n655 0.287967
R5374 ldo_1v2_a_0.VDD.n935 ldo_1v2_a_0.VDD.n933 0.287045
R5375 ldo_1v2_a_0.VDD.n741 ldo_1v2_a_0.VDD.n195 0.286368
R5376 ldo_1v2_a_0.VDD.n716 ldo_1v2_a_0.VDD.n263 0.279028
R5377 ldo_1v2_a_0.VDD.n143 ldo_1v2_a_0.VDD.n35 0.278581
R5378 ldo_1v2_a_0.VDD.n740 ldo_1v2_a_0.VDD.n196 0.277104
R5379 ldo_1v2_a_0.VDD.n968 ldo_1v2_a_0.VDD.n855 0.276103
R5380 ldo_1v2_a_0.VDD.n732 ldo_1v2_a_0.VDD.n260 0.272019
R5381 ldo_1v2_a_0.VDD.n733 ldo_1v2_a_0.VDD.n732 0.271693
R5382 ldo_1v2_a_0.VDD.t62 ldo_1v2_a_0.VDD.n388 0.267102
R5383 ldo_1v2_a_0.VDD.n609 ldo_1v2_a_0.VDD.n588 0.266161
R5384 ldo_1v2_a_0.VDD.n660 ldo_1v2_a_0.VDD.n659 0.257467
R5385 ldo_1v2_a_0.VDD.n731 ldo_1v2_a_0.VDD.n730 0.252728
R5386 ldo_1v2_a_0.VDD.n728 ldo_1v2_a_0.VDD.n727 0.252195
R5387 ldo_1v2_a_0.VDD.n704 ldo_1v2_a_0.VDD.n703 0.250378
R5388 ldo_1v2_a_0.VDD.n703 ldo_1v2_a_0.VDD.n702 0.250378
R5389 ldo_1v2_a_0.VDD.n702 ldo_1v2_a_0.VDD.n701 0.250378
R5390 ldo_1v2_a_0.VDD.n701 ldo_1v2_a_0.VDD.n700 0.250378
R5391 ldo_1v2_a_0.VDD.n700 ldo_1v2_a_0.VDD.n699 0.250378
R5392 ldo_1v2_a_0.VDD.n697 ldo_1v2_a_0.VDD.n696 0.250378
R5393 ldo_1v2_a_0.VDD.n696 ldo_1v2_a_0.VDD.n695 0.250378
R5394 ldo_1v2_a_0.VDD.n695 ldo_1v2_a_0.VDD.n694 0.250378
R5395 ldo_1v2_a_0.VDD.n694 ldo_1v2_a_0.VDD.n693 0.250378
R5396 ldo_1v2_a_0.VDD.n693 ldo_1v2_a_0.VDD.n692 0.250378
R5397 ldo_1v2_a_0.VDD.n692 ldo_1v2_a_0.VDD.n691 0.250378
R5398 ldo_1v2_a_0.VDD.n691 ldo_1v2_a_0.VDD.n690 0.250378
R5399 ldo_1v2_a_0.VDD.n690 ldo_1v2_a_0.VDD.n689 0.250378
R5400 ldo_1v2_a_0.VDD.n689 ldo_1v2_a_0.VDD.n688 0.250378
R5401 ldo_1v2_a_0.VDD.n688 ldo_1v2_a_0.VDD.n687 0.250378
R5402 ldo_1v2_a_0.VDD.n687 ldo_1v2_a_0.VDD.n686 0.250378
R5403 ldo_1v2_a_0.VDD.n345 ldo_1v2_a_0.VDD.n290 0.250378
R5404 ldo_1v2_a_0.VDD.n346 ldo_1v2_a_0.VDD.n345 0.250378
R5405 ldo_1v2_a_0.VDD.n347 ldo_1v2_a_0.VDD.n346 0.250378
R5406 ldo_1v2_a_0.VDD.n348 ldo_1v2_a_0.VDD.n347 0.250378
R5407 ldo_1v2_a_0.VDD.n584 ldo_1v2_a_0.VDD.n583 0.250378
R5408 ldo_1v2_a_0.VDD.n583 ldo_1v2_a_0.VDD.n544 0.250378
R5409 ldo_1v2_a_0.VDD.n576 ldo_1v2_a_0.VDD.n544 0.250378
R5410 ldo_1v2_a_0.VDD.n558 ldo_1v2_a_0.VDD.n549 0.250378
R5411 ldo_1v2_a_0.VDD.n558 ldo_1v2_a_0.VDD.n557 0.250378
R5412 ldo_1v2_a_0.VDD.n357 ldo_1v2_a_0.VDD.n356 0.250378
R5413 ldo_1v2_a_0.VDD.n358 ldo_1v2_a_0.VDD.n357 0.250378
R5414 ldo_1v2_a_0.VDD.n359 ldo_1v2_a_0.VDD.n358 0.250378
R5415 ldo_1v2_a_0.VDD.n360 ldo_1v2_a_0.VDD.n359 0.250378
R5416 ldo_1v2_a_0.VDD.n183 ldo_1v2_a_0.VDD.n181 0.250378
R5417 ldo_1v2_a_0.VDD.n181 ldo_1v2_a_0.VDD.n179 0.250378
R5418 ldo_1v2_a_0.VDD.n179 ldo_1v2_a_0.VDD.n177 0.250378
R5419 ldo_1v2_a_0.VDD.n177 ldo_1v2_a_0.VDD.n175 0.250378
R5420 ldo_1v2_a_0.VDD.n175 ldo_1v2_a_0.VDD.n173 0.250378
R5421 ldo_1v2_a_0.VDD.n173 ldo_1v2_a_0.VDD.n171 0.250378
R5422 ldo_1v2_a_0.VDD.n171 ldo_1v2_a_0.VDD.n169 0.250378
R5423 ldo_1v2_a_0.VDD.n169 ldo_1v2_a_0.VDD.n167 0.250378
R5424 ldo_1v2_a_0.VDD.n167 ldo_1v2_a_0.VDD.n165 0.250378
R5425 ldo_1v2_a_0.VDD.n165 ldo_1v2_a_0.VDD.n163 0.250378
R5426 ldo_1v2_a_0.VDD.n163 ldo_1v2_a_0.VDD.n161 0.250378
R5427 ldo_1v2_a_0.VDD.n161 ldo_1v2_a_0.VDD.n159 0.250378
R5428 ldo_1v2_a_0.VDD.n159 ldo_1v2_a_0.VDD.n157 0.250378
R5429 ldo_1v2_a_0.VDD.n157 ldo_1v2_a_0.VDD.n155 0.250378
R5430 ldo_1v2_a_0.VDD.n155 ldo_1v2_a_0.VDD.n153 0.250378
R5431 ldo_1v2_a_0.VDD.n153 ldo_1v2_a_0.VDD.n151 0.250378
R5432 ldo_1v2_a_0.VDD.n151 ldo_1v2_a_0.VDD.n149 0.250378
R5433 ldo_1v2_a_0.VDD.n149 ldo_1v2_a_0.VDD.n147 0.250378
R5434 ldo_1v2_a_0.VDD.n147 ldo_1v2_a_0.VDD.n145 0.250378
R5435 ldo_1v2_a_0.VDD.n145 ldo_1v2_a_0.VDD.n143 0.250378
R5436 ldo_1v2_a_0.VDD.n879 ldo_1v2_a_0.VDD.n878 0.250378
R5437 ldo_1v2_a_0.VDD.n880 ldo_1v2_a_0.VDD.n879 0.250378
R5438 ldo_1v2_a_0.VDD.n881 ldo_1v2_a_0.VDD.n880 0.250378
R5439 ldo_1v2_a_0.VDD.n882 ldo_1v2_a_0.VDD.n881 0.250378
R5440 ldo_1v2_a_0.VDD.n883 ldo_1v2_a_0.VDD.n882 0.250378
R5441 ldo_1v2_a_0.VDD.n884 ldo_1v2_a_0.VDD.n883 0.250378
R5442 ldo_1v2_a_0.VDD.n885 ldo_1v2_a_0.VDD.n884 0.250378
R5443 ldo_1v2_a_0.VDD.n886 ldo_1v2_a_0.VDD.n885 0.250378
R5444 ldo_1v2_a_0.VDD.n887 ldo_1v2_a_0.VDD.n886 0.250378
R5445 ldo_1v2_a_0.VDD.n888 ldo_1v2_a_0.VDD.n887 0.250378
R5446 ldo_1v2_a_0.VDD.n889 ldo_1v2_a_0.VDD.n888 0.250378
R5447 ldo_1v2_a_0.VDD.n890 ldo_1v2_a_0.VDD.n889 0.250378
R5448 ldo_1v2_a_0.VDD.n891 ldo_1v2_a_0.VDD.n890 0.250378
R5449 ldo_1v2_a_0.VDD.n892 ldo_1v2_a_0.VDD.n891 0.250378
R5450 ldo_1v2_a_0.VDD.n893 ldo_1v2_a_0.VDD.n892 0.250378
R5451 ldo_1v2_a_0.VDD.n894 ldo_1v2_a_0.VDD.n893 0.250378
R5452 ldo_1v2_a_0.VDD.n895 ldo_1v2_a_0.VDD.n894 0.250378
R5453 ldo_1v2_a_0.VDD.n896 ldo_1v2_a_0.VDD.n895 0.250378
R5454 ldo_1v2_a_0.VDD.n897 ldo_1v2_a_0.VDD.n896 0.250378
R5455 ldo_1v2_a_0.VDD.n898 ldo_1v2_a_0.VDD.n897 0.250378
R5456 ldo_1v2_a_0.VDD.n899 ldo_1v2_a_0.VDD.n898 0.250378
R5457 ldo_1v2_a_0.VDD.n967 ldo_1v2_a_0.VDD.n965 0.250378
R5458 ldo_1v2_a_0.VDD.n965 ldo_1v2_a_0.VDD.n963 0.250378
R5459 ldo_1v2_a_0.VDD.n963 ldo_1v2_a_0.VDD.n961 0.250378
R5460 ldo_1v2_a_0.VDD.n961 ldo_1v2_a_0.VDD.n959 0.250378
R5461 ldo_1v2_a_0.VDD.n959 ldo_1v2_a_0.VDD.n957 0.250378
R5462 ldo_1v2_a_0.VDD.n957 ldo_1v2_a_0.VDD.n955 0.250378
R5463 ldo_1v2_a_0.VDD.n955 ldo_1v2_a_0.VDD.n953 0.250378
R5464 ldo_1v2_a_0.VDD.n953 ldo_1v2_a_0.VDD.n951 0.250378
R5465 ldo_1v2_a_0.VDD.n951 ldo_1v2_a_0.VDD.n949 0.250378
R5466 ldo_1v2_a_0.VDD.n949 ldo_1v2_a_0.VDD.n947 0.250378
R5467 ldo_1v2_a_0.VDD.n947 ldo_1v2_a_0.VDD.n945 0.250378
R5468 ldo_1v2_a_0.VDD.n945 ldo_1v2_a_0.VDD.n943 0.250378
R5469 ldo_1v2_a_0.VDD.n943 ldo_1v2_a_0.VDD.n941 0.250378
R5470 ldo_1v2_a_0.VDD.n941 ldo_1v2_a_0.VDD.n939 0.250378
R5471 ldo_1v2_a_0.VDD.n939 ldo_1v2_a_0.VDD.n937 0.250378
R5472 ldo_1v2_a_0.VDD.n937 ldo_1v2_a_0.VDD.n935 0.250378
R5473 ldo_1v2_a_0.VDD.n933 ldo_1v2_a_0.VDD.n931 0.250378
R5474 ldo_1v2_a_0.VDD.n931 ldo_1v2_a_0.VDD.n929 0.250378
R5475 ldo_1v2_a_0.VDD.n929 ldo_1v2_a_0.VDD.n927 0.250378
R5476 ldo_1v2_a_0.VDD.n927 ldo_1v2_a_0.VDD.n925 0.250378
R5477 ldo_1v2_a_0.VDD.n925 ldo_1v2_a_0.VDD.n923 0.250378
R5478 ldo_1v2_a_0.VDD.n923 ldo_1v2_a_0.VDD.n921 0.250378
R5479 ldo_1v2_a_0.VDD.n921 ldo_1v2_a_0.VDD.n919 0.250378
R5480 ldo_1v2_a_0.VDD.n919 ldo_1v2_a_0.VDD.n917 0.250378
R5481 ldo_1v2_a_0.VDD.n917 ldo_1v2_a_0.VDD.n915 0.250378
R5482 ldo_1v2_a_0.VDD.n915 ldo_1v2_a_0.VDD.n913 0.250378
R5483 ldo_1v2_a_0.VDD.n913 ldo_1v2_a_0.VDD.n911 0.250378
R5484 ldo_1v2_a_0.VDD.n911 ldo_1v2_a_0.VDD.n909 0.250378
R5485 ldo_1v2_a_0.VDD.n909 ldo_1v2_a_0.VDD.n907 0.250378
R5486 ldo_1v2_a_0.VDD.n907 ldo_1v2_a_0.VDD.n905 0.250378
R5487 ldo_1v2_a_0.VDD.n905 ldo_1v2_a_0.VDD.n903 0.250378
R5488 ldo_1v2_a_0.VDD.n756 ldo_1v2_a_0.VDD.n754 0.250378
R5489 ldo_1v2_a_0.VDD.n758 ldo_1v2_a_0.VDD.n756 0.250378
R5490 ldo_1v2_a_0.VDD.n760 ldo_1v2_a_0.VDD.n758 0.250378
R5491 ldo_1v2_a_0.VDD.n762 ldo_1v2_a_0.VDD.n760 0.250378
R5492 ldo_1v2_a_0.VDD.n764 ldo_1v2_a_0.VDD.n762 0.250378
R5493 ldo_1v2_a_0.VDD.n766 ldo_1v2_a_0.VDD.n764 0.250378
R5494 ldo_1v2_a_0.VDD.n768 ldo_1v2_a_0.VDD.n766 0.250378
R5495 ldo_1v2_a_0.VDD.n770 ldo_1v2_a_0.VDD.n768 0.250378
R5496 ldo_1v2_a_0.VDD.n772 ldo_1v2_a_0.VDD.n770 0.250378
R5497 ldo_1v2_a_0.VDD.n774 ldo_1v2_a_0.VDD.n772 0.250378
R5498 ldo_1v2_a_0.VDD.n776 ldo_1v2_a_0.VDD.n774 0.250378
R5499 ldo_1v2_a_0.VDD.n778 ldo_1v2_a_0.VDD.n776 0.250378
R5500 ldo_1v2_a_0.VDD.n780 ldo_1v2_a_0.VDD.n778 0.250378
R5501 ldo_1v2_a_0.VDD.n782 ldo_1v2_a_0.VDD.n780 0.250378
R5502 ldo_1v2_a_0.VDD.n784 ldo_1v2_a_0.VDD.n782 0.250378
R5503 ldo_1v2_a_0.VDD.n786 ldo_1v2_a_0.VDD.n784 0.250378
R5504 ldo_1v2_a_0.VDD.n788 ldo_1v2_a_0.VDD.n786 0.250378
R5505 ldo_1v2_a_0.VDD.n789 ldo_1v2_a_0.VDD.n788 0.250378
R5506 ldo_1v2_a_0.VDD.n790 ldo_1v2_a_0.VDD.n789 0.250378
R5507 ldo_1v2_a_0.VDD.n816 ldo_1v2_a_0.VDD.n38 0.250378
R5508 ldo_1v2_a_0.VDD.n818 ldo_1v2_a_0.VDD.n816 0.250378
R5509 ldo_1v2_a_0.VDD.n820 ldo_1v2_a_0.VDD.n818 0.250378
R5510 ldo_1v2_a_0.VDD.n822 ldo_1v2_a_0.VDD.n820 0.250378
R5511 ldo_1v2_a_0.VDD.n824 ldo_1v2_a_0.VDD.n822 0.250378
R5512 ldo_1v2_a_0.VDD.n826 ldo_1v2_a_0.VDD.n824 0.250378
R5513 ldo_1v2_a_0.VDD.n828 ldo_1v2_a_0.VDD.n826 0.250378
R5514 ldo_1v2_a_0.VDD.n830 ldo_1v2_a_0.VDD.n828 0.250378
R5515 ldo_1v2_a_0.VDD.n832 ldo_1v2_a_0.VDD.n830 0.250378
R5516 ldo_1v2_a_0.VDD.n834 ldo_1v2_a_0.VDD.n832 0.250378
R5517 ldo_1v2_a_0.VDD.n836 ldo_1v2_a_0.VDD.n834 0.250378
R5518 ldo_1v2_a_0.VDD.n838 ldo_1v2_a_0.VDD.n836 0.250378
R5519 ldo_1v2_a_0.VDD.n840 ldo_1v2_a_0.VDD.n838 0.250378
R5520 ldo_1v2_a_0.VDD.n842 ldo_1v2_a_0.VDD.n840 0.250378
R5521 ldo_1v2_a_0.VDD.n844 ldo_1v2_a_0.VDD.n842 0.250378
R5522 ldo_1v2_a_0.VDD.n846 ldo_1v2_a_0.VDD.n844 0.250378
R5523 ldo_1v2_a_0.VDD.n848 ldo_1v2_a_0.VDD.n846 0.250378
R5524 ldo_1v2_a_0.VDD.n850 ldo_1v2_a_0.VDD.n848 0.250378
R5525 ldo_1v2_a_0.VDD.n852 ldo_1v2_a_0.VDD.n850 0.250378
R5526 ldo_1v2_a_0.VDD.n854 ldo_1v2_a_0.VDD.n852 0.250378
R5527 ldo_1v2_a_0.VDD.n855 ldo_1v2_a_0.VDD.n854 0.250378
R5528 ldo_1v2_a_0.VDD.n567 ldo_1v2_a_0.VDD.n566 0.249752
R5529 ldo_1v2_a_0.VDD.n754 ldo_1v2_a_0.VDD.n752 0.247298
R5530 ldo_1v2_a_0.VDD.n734 ldo_1v2_a_0.VDD.n258 0.247052
R5531 ldo_1v2_a_0.VDD.n718 ldo_1v2_a_0.VDD.n262 0.245706
R5532 ldo_1v2_a_0.VDD.n671 ldo_1v2_a_0.VDD.n350 0.243523
R5533 ldo_1v2_a_0.VDD.n675 ldo_1v2_a_0.VDD.n674 0.239466
R5534 ldo_1v2_a_0.VDD.n743 ldo_1v2_a_0.VDD.n742 0.238432
R5535 ldo_1v2_a_0.VDD.n212 ldo_1v2_a_0.VDD 0.2381
R5536 ldo_1v2_a_0.VDD.n259 ldo_1v2_a_0.VDD.n258 0.2331
R5537 ldo_1v2_a_0.VDD.n634 ldo_1v2_a_0.VDD.n461 0.231603
R5538 ldo_1v2_a_0.VDD.n648 ldo_1v2_a_0.VDD.n263 0.229597
R5539 ldo_1v2_a_0.VDD.n677 ldo_1v2_a_0.VDD.n676 0.229422
R5540 ldo_1v2_a_0.VDD.n261 ldo_1v2_a_0.VDD.n260 0.229285
R5541 ldo_1v2_a_0.VDD.n557 ldo_1v2_a_0.VDD.n463 0.223947
R5542 ldo_1v2_a_0.VDD.n686 ldo_1v2_a_0.VDD.n685 0.223034
R5543 ldo_1v2_a_0.VDD.n685 ldo_1v2_a_0.VDD.n290 0.223034
R5544 ldo_1v2_a_0.VDD.t0 ldo_1v2_a_0.VDD.n76 0.221767
R5545 ldo_1v2_a_0.VDD.n705 ldo_1v2_a_0.VDD.n704 0.220295
R5546 ldo_1v2_a_0.VDD.n670 ldo_1v2_a_0.VDD.n667 0.218208
R5547 ldo_1v2_a_0.VDD.t105 ldo_1v2_a_0.VDD.n396 0.2135
R5548 ldo_1v2_a_0.VDD.n680 ldo_1v2_a_0.VDD.n679 0.211158
R5549 ldo_1v2_a_0.VDD.n75 ldo_1v2_a_0.VDD.n2 0.208317
R5550 ldo_1v2_a_0.VDD.n3 ldo_1v2_a_0.VDD.n2 0.205119
R5551 ldo_1v2_a_0.VDD.n576 ldo_1v2_a_0.VDD.n575 0.202926
R5552 ldo_1v2_a_0.VDD ldo_1v2_a_0.VDD.n242 0.202846
R5553 ldo_1v2_a_0.VDD.n349 ldo_1v2_a_0.VDD.n336 0.194799
R5554 ldo_1v2_a_0.VDD.n417 ldo_1v2_a_0.VDD.n416 0.1941
R5555 ldo_1v2_a_0.VDD.n29 ldo_1v2_a_0.VDD.n28 0.1941
R5556 ldo_1v2_a_0.VDD.n738 ldo_1v2_a_0.VDD.n248 0.191871
R5557 ldo_1v2_a_0.VDD.n547 ldo_1v2_a_0.VDD.n546 0.188534
R5558 ldo_1v2_a_0.VDD.n420 ldo_1v2_a_0.VDD.n419 0.188376
R5559 ldo_1v2_a_0.VDD.n31 ldo_1v2_a_0.VDD.n12 0.188376
R5560 ldo_1v2_a_0.VDD.n665 ldo_1v2_a_0.VDD.n361 0.188124
R5561 ldo_1v2_a_0.VDD.n584 ldo_1v2_a_0.VDD.n541 0.187772
R5562 ldo_1v2_a_0.VDD.n184 ldo_1v2_a_0.VDD.n183 0.187772
R5563 ldo_1v2_a_0.VDD.n878 ldo_1v2_a_0.VDD.n36 0.187772
R5564 ldo_1v2_a_0.VDD.n790 ldo_1v2_a_0.VDD.n37 0.187772
R5565 ldo_1v2_a_0.VDD.n973 ldo_1v2_a_0.VDD.n38 0.187772
R5566 ldo_1v2_a_0.VDD.n456 ldo_1v2_a_0.VDD.n394 0.186959
R5567 ldo_1v2_a_0.VDD.t33 ldo_1v2_a_0.VDD.n239 0.185283
R5568 ldo_1v2_a_0.VDD.n666 ldo_1v2_a_0.VDD 0.184106
R5569 ldo_1v2_a_0.VDD.n440 ldo_1v2_a_0.VDD.n439 0.182128
R5570 ldo_1v2_a_0.VDD.n434 ldo_1v2_a_0.VDD.n433 0.182128
R5571 ldo_1v2_a_0.VDD.n736 ldo_1v2_a_0.VDD.n255 0.175019
R5572 ldo_1v2_a_0.VDD.n540 ldo_1v2_a_0.VDD.n539 0.173648
R5573 ldo_1v2_a_0.VDD.n742 ldo_1v2_a_0.VDD.n741 0.171955
R5574 ldo_1v2_a_0.VDD.n738 ldo_1v2_a_0.VDD.n737 0.166458
R5575 ldo_1v2_a_0.VDD.n448 ldo_1v2_a_0.VDD.n447 0.159173
R5576 ldo_1v2_a_0.VDD.n998 ldo_1v2_a_0.VDD.n997 0.159173
R5577 ldo_1v2_a_0.VDD.n652 ldo_1v2_a_0.VDD.n248 0.155125
R5578 ldo_1v2_a_0.VDD.n745 ldo_1v2_a_0.VDD.t33 0.144568
R5579 ldo_1v2_a_0.VDD.n724 ldo_1v2_a_0.VDD.n239 0.1443
R5580 ldo_1v2_a_0.VDD.n457 ldo_1v2_a_0.VDD.n456 0.143552
R5581 ldo_1v2_a_0.VDD.n1000 ldo_1v2_a_0.VDD.n999 0.13976
R5582 ldo_1v2_a_0.VDD ldo_1v2_a_0.VDD.n386 0.134944
R5583 ldo_1v2_a_0.VDD.n639 ldo_1v2_a_0.VDD.n382 0.132712
R5584 ldo_1v2_a_0.VDD.n667 ldo_1v2_a_0.VDD.n666 0.129106
R5585 ldo_1v2_a_0.VDD.n531 ldo_1v2_a_0.VDD.n530 0.127505
R5586 ldo_1v2_a_0.VDD.n397 ldo_1v2_a_0.VDD.n393 0.12748
R5587 ldo_1v2_a_0.VDD.n570 ldo_1v2_a_0.VDD.n547 0.127367
R5588 ldo_1v2_a_0.VDD.n532 ldo_1v2_a_0.VDD.n531 0.124923
R5589 ldo_1v2_a_0.VDD.t105 ldo_1v2_a_0.VDD.n454 0.123688
R5590 ldo_1v2_a_0.VDD.t91 ldo_1v2_a_0.VDD.n5 0.123688
R5591 ldo_1v2_a_0.VDD.n638 ldo_1v2_a_0.VDD.n329 0.122851
R5592 ldo_1v2_a_0.VDD.n260 ldo_1v2_a_0.VDD 0.1215
R5593 ldo_1v2_a_0.VDD.n539 ldo_1v2_a_0.VDD.n536 0.119939
R5594 ldo_1v2_a_0.VDD.n631 ldo_1v2_a_0.VDD 0.116846
R5595 ldo_1v2_a_0.VDD.n494 ldo_1v2_a_0.VDD.n493 0.116648
R5596 ldo_1v2_a_0.VDD.n999 ldo_1v2_a_0.VDD.n998 0.115543
R5597 ldo_1v2_a_0.VDD.n617 ldo_1v2_a_0.VDD.n616 0.114439
R5598 ldo_1v2_a_0.VDD.n495 ldo_1v2_a_0.VDD.n494 0.114288
R5599 ldo_1v2_a_0.VDD.n1001 ldo_1v2_a_0.VDD.n2 0.114012
R5600 ldo_1v2_a_0.VDD.n184 ldo_1v2_a_0.VDD.n0 0.108667
R5601 ldo_1v2_a_0.VDD.n568 ldo_1v2_a_0.VDD.n502 0.107106
R5602 ldo_1v2_a_0.VDD.n447 ldo_1v2_a_0.VDD.n393 0.103442
R5603 ldo_1v2_a_0.VDD.n974 ldo_1v2_a_0.VDD.n37 0.0995
R5604 ldo_1v2_a_0.VDD.n662 ldo_1v2_a_0.VDD 0.0977632
R5605 ldo_1v2_a_0.VDD.n614 ldo_1v2_a_0.VDD.n613 0.0976763
R5606 ldo_1v2_a_0.VDD.n660 ldo_1v2_a_0.VDD.n268 0.0937033
R5607 ldo_1v2_a_0.VDD.n498 ldo_1v2_a_0.VDD.n497 0.0935043
R5608 ldo_1v2_a_0.VDD.n528 ldo_1v2_a_0.VDD.n527 0.0924249
R5609 ldo_1v2_a_0.VDD.n535 ldo_1v2_a_0.VDD.n534 0.0867441
R5610 ldo_1v2_a_0.VDD.n491 ldo_1v2_a_0.VDD.n465 0.0845343
R5611 ldo_1v2_a_0.VDD.n634 ldo_1v2_a_0.VDD.n633 0.0835288
R5612 ldo_1v2_a_0.VDD.n607 ldo_1v2_a_0.VDD.n606 0.083
R5613 ldo_1v2_a_0.VDD.n613 ldo_1v2_a_0.VDD.n466 0.0823068
R5614 ldo_1v2_a_0.VDD.n663 ldo_1v2_a_0.VDD.n662 0.0796056
R5615 ldo_1v2_a_0.VDD.n443 ldo_1v2_a_0.VDD.n428 0.0761267
R5616 ldo_1v2_a_0.VDD.n752 ldo_1v2_a_0.VDD.n751 0.0755484
R5617 ldo_1v2_a_0.VDD.n706 ldo_1v2_a_0.VDD.n269 0.0752433
R5618 ldo_1v2_a_0.VDD.n662 ldo_1v2_a_0.VDD.n647 0.0722723
R5619 ldo_1v2_a_0.VDD.n721 ldo_1v2_a_0.VDD.n255 0.072
R5620 ldo_1v2_a_0.VDD.n675 ldo_1v2_a_0.VDD.n348 0.070439
R5621 ldo_1v2_a_0.VDD.n356 ldo_1v2_a_0.VDD.n336 0.070439
R5622 ldo_1v2_a_0.VDD.n546 ldo_1v2_a_0.VDD.n502 0.0686056
R5623 ldo_1v2_a_0.VDD.n536 ldo_1v2_a_0.VDD.n535 0.0649389
R5624 ldo_1v2_a_0.VDD.n737 ldo_1v2_a_0.VDD.n736 0.0612668
R5625 ldo_1v2_a_0.VDD.n992 ldo_1v2_a_0.VDD.n35 0.0576206
R5626 ldo_1v2_a_0.VDD.n615 ldo_1v2_a_0.VDD.n464 0.0562218
R5627 ldo_1v2_a_0.VDD.n991 ldo_1v2_a_0.VDD.n36 0.0555
R5628 ldo_1v2_a_0.VDD.n974 ldo_1v2_a_0.VDD.n973 0.0555
R5629 ldo_1v2_a_0.VDD.n658 ldo_1v2_a_0.VDD.n648 0.055107
R5630 ldo_1v2_a_0.VDD.n409 ldo_1v2_a_0.VDD.n403 0.0545837
R5631 ldo_1v2_a_0.VDD.n410 ldo_1v2_a_0.VDD.n404 0.0545837
R5632 ldo_1v2_a_0.VDD.n412 ldo_1v2_a_0.VDD.n406 0.0545837
R5633 ldo_1v2_a_0.VDD.n402 ldo_1v2_a_0.VDD.n401 0.0545837
R5634 ldo_1v2_a_0.VDD.n408 ldo_1v2_a_0.VDD.n403 0.0545837
R5635 ldo_1v2_a_0.VDD.n410 ldo_1v2_a_0.VDD.n405 0.0545837
R5636 ldo_1v2_a_0.VDD.n411 ldo_1v2_a_0.VDD.n406 0.0545837
R5637 ldo_1v2_a_0.VDD.n21 ldo_1v2_a_0.VDD.n15 0.0545837
R5638 ldo_1v2_a_0.VDD.n22 ldo_1v2_a_0.VDD.n16 0.0545837
R5639 ldo_1v2_a_0.VDD.n24 ldo_1v2_a_0.VDD.n18 0.0545837
R5640 ldo_1v2_a_0.VDD.n14 ldo_1v2_a_0.VDD.n13 0.0545837
R5641 ldo_1v2_a_0.VDD.n20 ldo_1v2_a_0.VDD.n15 0.0545837
R5642 ldo_1v2_a_0.VDD.n22 ldo_1v2_a_0.VDD.n17 0.0545837
R5643 ldo_1v2_a_0.VDD.n23 ldo_1v2_a_0.VDD.n18 0.0545837
R5644 ldo_1v2_a_0.VDD.n747 ldo_1v2_a_0.VDD.n193 0.0544623
R5645 ldo_1v2_a_0.VDD.n408 ldo_1v2_a_0.VDD.n402 0.0542181
R5646 ldo_1v2_a_0.VDD.n411 ldo_1v2_a_0.VDD.n405 0.0542181
R5647 ldo_1v2_a_0.VDD.n413 ldo_1v2_a_0.VDD.n407 0.0542181
R5648 ldo_1v2_a_0.VDD.n409 ldo_1v2_a_0.VDD.n404 0.0542181
R5649 ldo_1v2_a_0.VDD.n412 ldo_1v2_a_0.VDD.n407 0.0542181
R5650 ldo_1v2_a_0.VDD.n20 ldo_1v2_a_0.VDD.n14 0.0542181
R5651 ldo_1v2_a_0.VDD.n23 ldo_1v2_a_0.VDD.n17 0.0542181
R5652 ldo_1v2_a_0.VDD.n25 ldo_1v2_a_0.VDD.n19 0.0542181
R5653 ldo_1v2_a_0.VDD.n21 ldo_1v2_a_0.VDD.n16 0.0542181
R5654 ldo_1v2_a_0.VDD.n24 ldo_1v2_a_0.VDD.n19 0.0542181
R5655 ldo_1v2_a_0.VDD.n430 ldo_1v2_a_0.VDD.t35 0.0530906
R5656 ldo_1v2_a_0.VDD.n606 ldo_1v2_a_0.VDD.n605 0.0502115
R5657 ldo_1v2_a_0.VDD.n633 ldo_1v2_a_0.VDD.n632 0.0496827
R5658 ldo_1v2_a_0.VDD.n570 ldo_1v2_a_0.VDD.n569 0.0485334
R5659 ldo_1v2_a_0.VDD.n260 ldo_1v2_a_0.VDD 0.0422722
R5660 ldo_1v2_a_0.VDD.n676 ldo_1v2_a_0.VDD.n675 0.0421501
R5661 ldo_1v2_a_0.VDD.n992 ldo_1v2_a_0.VDD.n991 0.0408333
R5662 ldo_1v2_a_0.VDD.n598 ldo_1v2_a_0.VDD.n593 0.0397982
R5663 ldo_1v2_a_0.VDD.n599 ldo_1v2_a_0.VDD.n594 0.0397982
R5664 ldo_1v2_a_0.VDD.n601 ldo_1v2_a_0.VDD.n596 0.0397982
R5665 ldo_1v2_a_0.VDD.n602 ldo_1v2_a_0.VDD.n597 0.0397982
R5666 ldo_1v2_a_0.VDD.n600 ldo_1v2_a_0.VDD.n594 0.0397982
R5667 ldo_1v2_a_0.VDD.n601 ldo_1v2_a_0.VDD.n595 0.0397982
R5668 ldo_1v2_a_0.VDD.n603 ldo_1v2_a_0.VDD.n597 0.0397982
R5669 ldo_1v2_a_0.VDD.n630 ldo_1v2_a_0.VDD.n619 0.0397982
R5670 ldo_1v2_a_0.VDD.n625 ldo_1v2_a_0.VDD.n620 0.0397982
R5671 ldo_1v2_a_0.VDD.n627 ldo_1v2_a_0.VDD.n622 0.0397982
R5672 ldo_1v2_a_0.VDD.n628 ldo_1v2_a_0.VDD.n623 0.0397982
R5673 ldo_1v2_a_0.VDD.n626 ldo_1v2_a_0.VDD.n620 0.0397982
R5674 ldo_1v2_a_0.VDD.n627 ldo_1v2_a_0.VDD.n621 0.0397982
R5675 ldo_1v2_a_0.VDD.n629 ldo_1v2_a_0.VDD.n623 0.0397982
R5676 ldo_1v2_a_0.VDD.n533 ldo_1v2_a_0.VDD.n509 0.0396731
R5677 ldo_1v2_a_0.VDD.n511 ldo_1v2_a_0.VDD.n510 0.0396731
R5678 ldo_1v2_a_0.VDD.n513 ldo_1v2_a_0.VDD.n512 0.0396731
R5679 ldo_1v2_a_0.VDD.n515 ldo_1v2_a_0.VDD.n514 0.0396731
R5680 ldo_1v2_a_0.VDD.n517 ldo_1v2_a_0.VDD.n516 0.0396731
R5681 ldo_1v2_a_0.VDD.n529 ldo_1v2_a_0.VDD.n518 0.0396731
R5682 ldo_1v2_a_0.VDD.n520 ldo_1v2_a_0.VDD.n519 0.0396731
R5683 ldo_1v2_a_0.VDD.n522 ldo_1v2_a_0.VDD.n521 0.0396731
R5684 ldo_1v2_a_0.VDD.n524 ldo_1v2_a_0.VDD.n523 0.0396731
R5685 ldo_1v2_a_0.VDD.n526 ldo_1v2_a_0.VDD.n525 0.0396731
R5686 ldo_1v2_a_0.VDD.n519 ldo_1v2_a_0.VDD.n518 0.0396731
R5687 ldo_1v2_a_0.VDD.n521 ldo_1v2_a_0.VDD.n520 0.0396731
R5688 ldo_1v2_a_0.VDD.n523 ldo_1v2_a_0.VDD.n522 0.0396731
R5689 ldo_1v2_a_0.VDD.n525 ldo_1v2_a_0.VDD.n524 0.0396731
R5690 ldo_1v2_a_0.VDD.n510 ldo_1v2_a_0.VDD.n509 0.0396731
R5691 ldo_1v2_a_0.VDD.n512 ldo_1v2_a_0.VDD.n511 0.0396731
R5692 ldo_1v2_a_0.VDD.n514 ldo_1v2_a_0.VDD.n513 0.0396731
R5693 ldo_1v2_a_0.VDD.n516 ldo_1v2_a_0.VDD.n515 0.0396731
R5694 ldo_1v2_a_0.VDD.n600 ldo_1v2_a_0.VDD.n595 0.0395343
R5695 ldo_1v2_a_0.VDD.n604 ldo_1v2_a_0.VDD.n603 0.0395343
R5696 ldo_1v2_a_0.VDD.n599 ldo_1v2_a_0.VDD.n593 0.0395343
R5697 ldo_1v2_a_0.VDD.n602 ldo_1v2_a_0.VDD.n596 0.0395343
R5698 ldo_1v2_a_0.VDD.n604 ldo_1v2_a_0.VDD.n592 0.0395343
R5699 ldo_1v2_a_0.VDD.n626 ldo_1v2_a_0.VDD.n621 0.0395343
R5700 ldo_1v2_a_0.VDD.n629 ldo_1v2_a_0.VDD.n624 0.0395343
R5701 ldo_1v2_a_0.VDD.n625 ldo_1v2_a_0.VDD.n619 0.0395343
R5702 ldo_1v2_a_0.VDD.n628 ldo_1v2_a_0.VDD.n622 0.0395343
R5703 ldo_1v2_a_0.VDD.n624 ldo_1v2_a_0.VDD.n618 0.0395343
R5704 ldo_1v2_a_0.VDD.n454 ldo_1v2_a_0.VDD.n446 0.0389493
R5705 ldo_1v2_a_0.VDD.n616 ldo_1v2_a_0.VDD.n463 0.036675
R5706 ldo_1v2_a_0.VDD.n994 ldo_1v2_a_0.VDD.n5 0.0364353
R5707 ldo_1v2_a_0.VDD.n496 ldo_1v2_a_0.VDD.n473 0.0363998
R5708 ldo_1v2_a_0.VDD.n475 ldo_1v2_a_0.VDD.n474 0.0363998
R5709 ldo_1v2_a_0.VDD.n477 ldo_1v2_a_0.VDD.n476 0.0363998
R5710 ldo_1v2_a_0.VDD.n479 ldo_1v2_a_0.VDD.n478 0.0363998
R5711 ldo_1v2_a_0.VDD.n481 ldo_1v2_a_0.VDD.n480 0.0363998
R5712 ldo_1v2_a_0.VDD.n492 ldo_1v2_a_0.VDD.n482 0.0363998
R5713 ldo_1v2_a_0.VDD.n484 ldo_1v2_a_0.VDD.n483 0.0363998
R5714 ldo_1v2_a_0.VDD.n486 ldo_1v2_a_0.VDD.n485 0.0363998
R5715 ldo_1v2_a_0.VDD.n488 ldo_1v2_a_0.VDD.n487 0.0363998
R5716 ldo_1v2_a_0.VDD.n490 ldo_1v2_a_0.VDD.n489 0.0363998
R5717 ldo_1v2_a_0.VDD.n483 ldo_1v2_a_0.VDD.n482 0.0363998
R5718 ldo_1v2_a_0.VDD.n485 ldo_1v2_a_0.VDD.n484 0.0363998
R5719 ldo_1v2_a_0.VDD.n487 ldo_1v2_a_0.VDD.n486 0.0363998
R5720 ldo_1v2_a_0.VDD.n489 ldo_1v2_a_0.VDD.n488 0.0363998
R5721 ldo_1v2_a_0.VDD.n474 ldo_1v2_a_0.VDD.n473 0.0363998
R5722 ldo_1v2_a_0.VDD.n476 ldo_1v2_a_0.VDD.n475 0.0363998
R5723 ldo_1v2_a_0.VDD.n478 ldo_1v2_a_0.VDD.n477 0.0363998
R5724 ldo_1v2_a_0.VDD.n480 ldo_1v2_a_0.VDD.n479 0.0363998
R5725 ldo_1v2_a_0.VDD.n659 ldo_1v2_a_0.VDD.n658 0.035722
R5726 ldo_1v2_a_0.VDD.n706 ldo_1v2_a_0.VDD.n705 0.0330229
R5727 ldo_1v2_a_0.VDD.n398 ldo_1v2_a_0.VDD.n391 0.0327781
R5728 ldo_1v2_a_0.VDD.n651 ldo_1v2_a_0.VDD.n650 0.0286496
R5729 ldo_1v2_a_0.VDD.n365 ldo_1v2_a_0.VDD.n364 0.0284231
R5730 ldo_1v2_a_0.VDD.n363 ldo_1v2_a_0.VDD.n362 0.0284231
R5731 ldo_1v2_a_0.VDD.n590 ldo_1v2_a_0.VDD.n589 0.0284231
R5732 ldo_1v2_a_0.VDD.n416 ldo_1v2_a_0.VDD.n401 0.0277246
R5733 ldo_1v2_a_0.VDD.n28 ldo_1v2_a_0.VDD.n13 0.0277246
R5734 ldo_1v2_a_0.VDD.n415 ldo_1v2_a_0.VDD.n413 0.0273591
R5735 ldo_1v2_a_0.VDD.n27 ldo_1v2_a_0.VDD.n25 0.0273591
R5736 ldo_1v2_a_0.VDD.n746 ldo_1v2_a_0.VDD.n194 0.0267598
R5737 ldo_1v2_a_0.VDD.n747 ldo_1v2_a_0.VDD.n746 0.0259473
R5738 ldo_1v2_a_0.VDD.n643 ldo_1v2_a_0.VDD.n642 0.0250385
R5739 ldo_1v2_a_0.VDD.n380 ldo_1v2_a_0.VDD.n379 0.0250385
R5740 ldo_1v2_a_0.VDD.n378 ldo_1v2_a_0.VDD.n377 0.0250385
R5741 ldo_1v2_a_0.VDD.n376 ldo_1v2_a_0.VDD.n375 0.0250385
R5742 ldo_1v2_a_0.VDD.n374 ldo_1v2_a_0.VDD.n373 0.0250385
R5743 ldo_1v2_a_0.VDD.n372 ldo_1v2_a_0.VDD.n371 0.0250385
R5744 ldo_1v2_a_0.VDD.n370 ldo_1v2_a_0.VDD.n369 0.0250385
R5745 ldo_1v2_a_0.VDD.n368 ldo_1v2_a_0.VDD.n367 0.0250385
R5746 ldo_1v2_a_0.VDD.n680 ldo_1v2_a_0.VDD.n336 0.0238858
R5747 ldo_1v2_a_0.VDD.n208 ldo_1v2_a_0.VDD.n207 0.0222925
R5748 ldo_1v2_a_0.VDD.n716 ldo_1v2_a_0.VDD.n715 0.0220572
R5749 ldo_1v2_a_0.VDD.n458 ldo_1v2_a_0.VDD.n391 0.0216898
R5750 ldo_1v2_a_0.VDD.n203 ldo_1v2_a_0.VDD.n199 0.0209464
R5751 ldo_1v2_a_0.VDD.n205 ldo_1v2_a_0.VDD.n201 0.0209464
R5752 ldo_1v2_a_0.VDD.n203 ldo_1v2_a_0.VDD.n198 0.0209464
R5753 ldo_1v2_a_0.VDD.n204 ldo_1v2_a_0.VDD.n199 0.0209464
R5754 ldo_1v2_a_0.VDD.n201 ldo_1v2_a_0.VDD.n197 0.0208168
R5755 ldo_1v2_a_0.VDD.n541 ldo_1v2_a_0.VDD.n540 0.0206667
R5756 ldo_1v2_a_0.VDD.n569 ldo_1v2_a_0.VDD.n567 0.0206667
R5757 ldo_1v2_a_0.VDD.n598 ldo_1v2_a_0.VDD.n382 0.020281
R5758 ldo_1v2_a_0.VDD.n631 ldo_1v2_a_0.VDD.n630 0.020281
R5759 ldo_1v2_a_0.VDD.n528 ldo_1v2_a_0.VDD.n526 0.0200865
R5760 ldo_1v2_a_0.VDD.n530 ldo_1v2_a_0.VDD.n529 0.0200865
R5761 ldo_1v2_a_0.VDD.n532 ldo_1v2_a_0.VDD.n517 0.0200865
R5762 ldo_1v2_a_0.VDD.n534 ldo_1v2_a_0.VDD.n533 0.0200865
R5763 ldo_1v2_a_0.VDD.n605 ldo_1v2_a_0.VDD.n592 0.0200172
R5764 ldo_1v2_a_0.VDD.n632 ldo_1v2_a_0.VDD.n618 0.0200172
R5765 ldo_1v2_a_0.VDD.n367 ldo_1v2_a_0.VDD.n366 0.0196032
R5766 ldo_1v2_a_0.VDD.n491 ldo_1v2_a_0.VDD.n490 0.0184499
R5767 ldo_1v2_a_0.VDD.n493 ldo_1v2_a_0.VDD.n492 0.0184499
R5768 ldo_1v2_a_0.VDD.n495 ldo_1v2_a_0.VDD.n481 0.0184499
R5769 ldo_1v2_a_0.VDD.n497 ldo_1v2_a_0.VDD.n496 0.0184499
R5770 ldo_1v2_a_0.VDD.n588 ldo_1v2_a_0.VDD.n540 0.0165691
R5771 ldo_1v2_a_0.VDD.n366 ldo_1v2_a_0.VDD.n365 0.0162186
R5772 ldo_1v2_a_0.VDD.n227 ldo_1v2_a_0.VDD.n225 0.0160435
R5773 ldo_1v2_a_0.VDD.n575 ldo_1v2_a_0.VDD.n547 0.015654
R5774 ldo_1v2_a_0.VDD.n227 ldo_1v2_a_0.VDD.n224 0.0155652
R5775 ldo_1v2_a_0.VDD.n653 ldo_1v2_a_0.VDD.n651 0.0147913
R5776 ldo_1v2_a_0.VDD.n232 ldo_1v2_a_0.VDD.n231 0.0143696
R5777 ldo_1v2_a_0.VDD.n230 ldo_1v2_a_0.VDD.n223 0.0138913
R5778 ldo_1v2_a_0.VDD.n226 ldo_1v2_a_0.VDD.n190 0.0126957
R5779 ldo_1v2_a_0.VDD.n498 ldo_1v2_a_0.VDD.n464 0.0126844
R5780 ldo_1v2_a_0.VDD.n417 ldo_1v2_a_0.VDD 0.0122333
R5781 ldo_1v2_a_0.VDD.n29 ldo_1v2_a_0.VDD 0.0122333
R5782 ldo_1v2_a_0.VDD.n228 ldo_1v2_a_0.VDD.n222 0.0122174
R5783 ldo_1v2_a_0.VDD.n219 ldo_1v2_a_0.VDD.n188 0.0119783
R5784 ldo_1v2_a_0.VDD.n206 ldo_1v2_a_0.VDD.n202 0.0119151
R5785 ldo_1v2_a_0.VDD.n398 ldo_1v2_a_0.VDD.n397 0.0118999
R5786 ldo_1v2_a_0.VDD.n233 ldo_1v2_a_0.VDD.n189 0.0110217
R5787 ldo_1v2_a_0.VDD.n198 ldo_1v2_a_0.VDD.n193 0.0107232
R5788 ldo_1v2_a_0.VDD.n204 ldo_1v2_a_0.VDD.n200 0.0107232
R5789 ldo_1v2_a_0.VDD.n206 ldo_1v2_a_0.VDD.n205 0.0107232
R5790 ldo_1v2_a_0.VDD.n207 ldo_1v2_a_0.VDD.n197 0.0105936
R5791 ldo_1v2_a_0.VDD.n229 ldo_1v2_a_0.VDD.n221 0.0105435
R5792 ldo_1v2_a_0.VDD.n186 ldo_1v2_a_0.VDD.n185 0.0101633
R5793 ldo_1v2_a_0.VDD.n202 ldo_1v2_a_0.VDD.n200 0.00854245
R5794 ldo_1v2_a_0.VDD.n221 ldo_1v2_a_0.VDD.n187 0.00815217
R5795 ldo_1v2_a_0.VDD.n233 ldo_1v2_a_0.VDD.n194 0.00791304
R5796 ldo_1v2_a_0.VDD.n229 ldo_1v2_a_0.VDD.n222 0.00671739
R5797 ldo_1v2_a_0.VDD.n750 ldo_1v2_a_0.VDD.n187 0.006
R5798 ldo_1v2_a_0.VDD.n228 ldo_1v2_a_0.VDD.n223 0.00504348
R5799 ldo_1v2_a_0.VDD.n643 ldo_1v2_a_0.VDD.n641 0.00473077
R5800 ldo_1v2_a_0.VDD.n642 ldo_1v2_a_0.VDD.n380 0.00473077
R5801 ldo_1v2_a_0.VDD.n379 ldo_1v2_a_0.VDD.n378 0.00473077
R5802 ldo_1v2_a_0.VDD.n377 ldo_1v2_a_0.VDD.n376 0.00473077
R5803 ldo_1v2_a_0.VDD.n375 ldo_1v2_a_0.VDD.n374 0.00473077
R5804 ldo_1v2_a_0.VDD.n373 ldo_1v2_a_0.VDD.n372 0.00473077
R5805 ldo_1v2_a_0.VDD.n371 ldo_1v2_a_0.VDD.n370 0.00473077
R5806 ldo_1v2_a_0.VDD.n369 ldo_1v2_a_0.VDD.n368 0.00473077
R5807 ldo_1v2_a_0.VDD.n232 ldo_1v2_a_0.VDD.n226 0.00456522
R5808 ldo_1v2_a_0.VDD.n460 ldo_1v2_a_0.VDD.n459 0.00411502
R5809 ldo_1v2_a_0.VDD.n749 ldo_1v2_a_0.VDD.n190 0.00408696
R5810 ldo_1v2_a_0.VDD.n429 ldo_1v2_a_0.VDD.n428 0.00388614
R5811 ldo_1v2_a_0.VDD.n750 ldo_1v2_a_0.VDD.n188 0.0036087
R5812 ldo_1v2_a_0.VDD.n230 ldo_1v2_a_0.VDD.n224 0.00336957
R5813 ldo_1v2_a_0.VDD.n231 ldo_1v2_a_0.VDD.n225 0.0028913
R5814 ldo_1v2_a_0.VDD.n749 ldo_1v2_a_0.VDD.n189 0.00265217
R5815 ldo_1v2_a_0.VDD.n587 ldo_1v2_a_0.VDD.n538 0.002125
R5816 ldo_1v2_a_0.VDD.n565 ldo_1v2_a_0.VDD.n548 0.002125
R5817 ldo_1v2_a_0.VDD.n182 ldo_1v2_a_0.VDD.n76 0.00198699
R5818 ldo_1v2_a_0.VDD.n714 ldo_1v2_a_0.VDD.n710 0.00194998
R5819 ldo_1v2_a_0.VDD.t64 ldo_1v2_a_0.VDD.n328 0.00194868
R5820 ldo_1v2_a_0.VDD.n571 ldo_1v2_a_0.VDD.n548 0.00187493
R5821 ldo_1v2_a_0.VDD.n610 ldo_1v2_a_0.VDD.n538 0.00187493
R5822 ldo_1v2_a_0.VDD.n431 ldo_1v2_a_0.VDD.n430 0.00183706
R5823 ldo_1v2_a_0.VDD.t56 ldo_1v2_a_0.VDD.n537 0.00175
R5824 ldo_1v2_a_0.VDD.n646 ldo_1v2_a_0.VDD.n300 0.00175
R5825 ldo_1v2_a_0.VDD.n142 ldo_1v2_a_0.VDD.n121 0.00175
R5826 ldo_1v2_a_0.VDD.n856 ldo_1v2_a_0.VDD.n119 0.00175
R5827 ldo_1v2_a_0.VDD.n708 ldo_1v2_a_0.VDD.n267 0.00166667
R5828 ldo_1v2_a_0.VDD.n966 ldo_1v2_a_0.VDD.n41 0.00166667
R5829 ldo_1v2_a_0.VDD.n563 ldo_1v2_a_0.VDD.n500 0.00162501
R5830 ldo_1v2_a_0.VDD.n748 ldo_1v2_a_0.VDD.n747 0.00162319
R5831 ldo_1v2_a_0.VDD.n637 ldo_1v2_a_0.VDD 0.00161336
R5832 ldo_1v2_a_0.VDD.n462 ldo_1v2_a_0.VDD.n388 0.00150783
R5833 ldo_1v2_a_0.VDD.n711 ldo_1v2_a_0.VDD.n264 0.0015
R5834 ldo_1v2_a_0.VDD.n711 ldo_1v2_a_0.VDD.n265 0.0015
R5835 ldo_1v2_a_0.VDD.n713 ldo_1v2_a_0.VDD.n265 0.0015
R5836 ldo_1v2_a_0.VDD.n636 ldo_1v2_a_0.VDD.n388 0.00149216
R5837 ldo_1v2_a_0.VDD.n441 ldo_1v2_a_0.VDD.n428 0.00140444
R5838 ldo_1v2_a_0.VDD.t31 ldo_1v2_a_0.VDD.n500 0.00137497
R5839 ldo_1v2_a_0.VDD.n364 ldo_1v2_a_0.VDD.n363 0.00134615
R5840 ldo_1v2_a_0.VDD.n589 ldo_1v2_a_0.VDD.n362 0.00134615
R5841 ldo_1v2_a_0.VDD.n709 ldo_1v2_a_0.VDD.n708 0.00133332
R5842 ldo_1v2_a_0.VDD.n969 ldo_1v2_a_0.VDD.n41 0.00133332
R5843 ldo_1v2_a_0.VDD.n301 ldo_1v2_a_0.VDD.n300 0.00124998
R5844 ldo_1v2_a_0.VDD.n121 ldo_1v2_a_0.VDD.n120 0.00124998
R5845 ldo_1v2_a_0.VDD.n900 ldo_1v2_a_0.VDD.n119 0.00124998
R5846 ldo_1v2_a_0.VDD.t101 ldo_1v2_a_0.VDD.n537 0.00124997
R5847 ldo_1v2_a_0.VDD.n430 ldo_1v2_a_0.VDD.n428 0.0011619
R5848 ldo_1v2_a_0.VDD.t60 ldo_1v2_a_0.VDD.n328 0.00105127
R5849 ldo_1v2_a_0.VDD.n710 ldo_1v2_a_0.VDD.n709 0.00104999
R5850 ldo_1v2_a_0.VDD.n185 ldo_1v2_a_0.VDD.n76 0.00101299
R5851 ldo_1v2_a_0.VDD.n185 ldo_1v2_a_0.VDD.n122 0.001
R5852 ldo_1v2_a_0.VDD.n753 ldo_1v2_a_0.VDD.n123 0.001
R5853 ldo_1v2_a_0.VDD.n755 ldo_1v2_a_0.VDD.n124 0.001
R5854 ldo_1v2_a_0.VDD.n757 ldo_1v2_a_0.VDD.n125 0.001
R5855 ldo_1v2_a_0.VDD.n759 ldo_1v2_a_0.VDD.n126 0.001
R5856 ldo_1v2_a_0.VDD.n761 ldo_1v2_a_0.VDD.n127 0.001
R5857 ldo_1v2_a_0.VDD.n763 ldo_1v2_a_0.VDD.n128 0.001
R5858 ldo_1v2_a_0.VDD.n765 ldo_1v2_a_0.VDD.n129 0.001
R5859 ldo_1v2_a_0.VDD.n767 ldo_1v2_a_0.VDD.n130 0.001
R5860 ldo_1v2_a_0.VDD.n769 ldo_1v2_a_0.VDD.n131 0.001
R5861 ldo_1v2_a_0.VDD.n771 ldo_1v2_a_0.VDD.n132 0.001
R5862 ldo_1v2_a_0.VDD.n773 ldo_1v2_a_0.VDD.n133 0.001
R5863 ldo_1v2_a_0.VDD.n775 ldo_1v2_a_0.VDD.n134 0.001
R5864 ldo_1v2_a_0.VDD.n777 ldo_1v2_a_0.VDD.n135 0.001
R5865 ldo_1v2_a_0.VDD.n779 ldo_1v2_a_0.VDD.n136 0.001
R5866 ldo_1v2_a_0.VDD.n781 ldo_1v2_a_0.VDD.n137 0.001
R5867 ldo_1v2_a_0.VDD.n783 ldo_1v2_a_0.VDD.n138 0.001
R5868 ldo_1v2_a_0.VDD.n785 ldo_1v2_a_0.VDD.n139 0.001
R5869 ldo_1v2_a_0.VDD.n787 ldo_1v2_a_0.VDD.n140 0.001
R5870 ldo_1v2_a_0.VDD.n792 ldo_1v2_a_0.VDD.n141 0.001
R5871 ldo_1v2_a_0.VDD.n791 ldo_1v2_a_0.VDD.n39 0.001
R5872 ldo_1v2_a_0.VDD.n972 ldo_1v2_a_0.VDD.n971 0.001
R5873 ldo_1v2_a_0.VDD.n793 ldo_1v2_a_0.VDD.n40 0.001
R5874 ldo_1v2_a_0.VDD.n815 ldo_1v2_a_0.VDD.n794 0.001
R5875 ldo_1v2_a_0.VDD.n817 ldo_1v2_a_0.VDD.n795 0.001
R5876 ldo_1v2_a_0.VDD.n819 ldo_1v2_a_0.VDD.n796 0.001
R5877 ldo_1v2_a_0.VDD.n821 ldo_1v2_a_0.VDD.n797 0.001
R5878 ldo_1v2_a_0.VDD.n823 ldo_1v2_a_0.VDD.n798 0.001
R5879 ldo_1v2_a_0.VDD.n825 ldo_1v2_a_0.VDD.n799 0.001
R5880 ldo_1v2_a_0.VDD.n827 ldo_1v2_a_0.VDD.n800 0.001
R5881 ldo_1v2_a_0.VDD.n829 ldo_1v2_a_0.VDD.n801 0.001
R5882 ldo_1v2_a_0.VDD.n831 ldo_1v2_a_0.VDD.n802 0.001
R5883 ldo_1v2_a_0.VDD.n833 ldo_1v2_a_0.VDD.n803 0.001
R5884 ldo_1v2_a_0.VDD.n835 ldo_1v2_a_0.VDD.n804 0.001
R5885 ldo_1v2_a_0.VDD.n837 ldo_1v2_a_0.VDD.n805 0.001
R5886 ldo_1v2_a_0.VDD.n839 ldo_1v2_a_0.VDD.n806 0.001
R5887 ldo_1v2_a_0.VDD.n841 ldo_1v2_a_0.VDD.n807 0.001
R5888 ldo_1v2_a_0.VDD.n843 ldo_1v2_a_0.VDD.n808 0.001
R5889 ldo_1v2_a_0.VDD.n845 ldo_1v2_a_0.VDD.n809 0.001
R5890 ldo_1v2_a_0.VDD.n847 ldo_1v2_a_0.VDD.n810 0.001
R5891 ldo_1v2_a_0.VDD.n849 ldo_1v2_a_0.VDD.n811 0.001
R5892 ldo_1v2_a_0.VDD.n851 ldo_1v2_a_0.VDD.n812 0.001
R5893 ldo_1v2_a_0.VDD.n853 ldo_1v2_a_0.VDD.n813 0.001
R5894 ldo_1v2_a_0.VDD.n970 ldo_1v2_a_0.VDD.n814 0.001
R5895 ldo_1v2_a_0.VDD.t33 ldo_1v2_a_0.VDD.n234 0.001
R5896 ldo_1v2_a_0.VDD.t33 ldo_1v2_a_0.VDD.n240 0.001
R5897 ldo_1v2_a_0.VDD.n611 ldo_1v2_a_0.VDD.n610 0.001
R5898 ldo_1v2_a_0.VDD.n586 ldo_1v2_a_0.VDD.n585 0.001
R5899 ldo_1v2_a_0.VDD.n582 ldo_1v2_a_0.VDD.n543 0.001
R5900 ldo_1v2_a_0.VDD.n581 ldo_1v2_a_0.VDD.n580 0.001
R5901 ldo_1v2_a_0.VDD.n579 ldo_1v2_a_0.VDD.n577 0.001
R5902 ldo_1v2_a_0.VDD.n574 ldo_1v2_a_0.VDD.n545 0.001
R5903 ldo_1v2_a_0.VDD.n573 ldo_1v2_a_0.VDD.n571 0.001
R5904 ldo_1v2_a_0.VDD.n564 ldo_1v2_a_0.VDD.n562 0.001
R5905 ldo_1v2_a_0.VDD.n561 ldo_1v2_a_0.VDD.n559 0.001
R5906 ldo_1v2_a_0.VDD.n556 ldo_1v2_a_0.VDD.n550 0.001
R5907 ldo_1v2_a_0.VDD.n555 ldo_1v2_a_0.VDD.n553 0.001
R5908 ldo_1v2_a_0.VDD.n552 ldo_1v2_a_0.VDD.n462 0.001
R5909 ldo_1v2_a_0.VDD.n381 ldo_1v2_a_0.VDD.n330 0.001
R5910 ldo_1v2_a_0.VDD.n636 ldo_1v2_a_0.VDD.n387 0.001
R5911 ldo_1v2_a_0.VDD.n456 ldo_1v2_a_0.VDD.n455 0.001
R5912 ldo_1v2_a_0.VDD.n399 ldo_1v2_a_0.VDD.n396 0.001
R5913 ldo_1v2_a_0.VDD.n432 ldo_1v2_a_0.VDD.n431 0.001
R5914 ldo_1v2_a_0.VDD.n432 ldo_1v2_a_0.VDD.n428 0.001
R5915 ldo_1v2_a_0.VDD.n456 ldo_1v2_a_0.VDD.n396 0.001
R5916 ldo_1v2_a_0.VDD.n455 ldo_1v2_a_0.VDD.n399 0.001
R5917 ldo_1v2_a_0.VDD.n612 ldo_1v2_a_0.VDD.t101 0.001
R5918 ldo_1v2_a_0.VDD.n542 ldo_1v2_a_0.VDD.n508 0.001
R5919 ldo_1v2_a_0.VDD.t32 ldo_1v2_a_0.VDD.n506 0.001
R5920 ldo_1v2_a_0.VDD.n578 ldo_1v2_a_0.VDD.n505 0.001
R5921 ldo_1v2_a_0.VDD.t58 ldo_1v2_a_0.VDD.n504 0.001
R5922 ldo_1v2_a_0.VDD.n572 ldo_1v2_a_0.VDD.n503 0.001
R5923 ldo_1v2_a_0.VDD.t31 ldo_1v2_a_0.VDD.n501 0.001
R5924 ldo_1v2_a_0.VDD.n560 ldo_1v2_a_0.VDD.n472 0.001
R5925 ldo_1v2_a_0.VDD.t79 ldo_1v2_a_0.VDD.n471 0.001
R5926 ldo_1v2_a_0.VDD.n554 ldo_1v2_a_0.VDD.n470 0.001
R5927 ldo_1v2_a_0.VDD.n551 ldo_1v2_a_0.VDD.n469 0.001
R5928 ldo_1v2_a_0.VDD.n468 ldo_1v2_a_0.VDD.t62 0.001
R5929 ldo_1v2_a_0.VDD.n551 ldo_1v2_a_0.VDD.n468 0.001
R5930 ldo_1v2_a_0.VDD.n554 ldo_1v2_a_0.VDD.n469 0.001
R5931 ldo_1v2_a_0.VDD.t79 ldo_1v2_a_0.VDD.n470 0.001
R5932 ldo_1v2_a_0.VDD.n560 ldo_1v2_a_0.VDD.n471 0.001
R5933 ldo_1v2_a_0.VDD.n563 ldo_1v2_a_0.VDD.n472 0.001
R5934 ldo_1v2_a_0.VDD.n572 ldo_1v2_a_0.VDD.n501 0.001
R5935 ldo_1v2_a_0.VDD.t58 ldo_1v2_a_0.VDD.n503 0.001
R5936 ldo_1v2_a_0.VDD.n578 ldo_1v2_a_0.VDD.n504 0.001
R5937 ldo_1v2_a_0.VDD.t32 ldo_1v2_a_0.VDD.n505 0.001
R5938 ldo_1v2_a_0.VDD.n542 ldo_1v2_a_0.VDD.n506 0.001
R5939 ldo_1v2_a_0.VDD.t56 ldo_1v2_a_0.VDD.n508 0.001
R5940 ldo_1v2_a_0.VDD.n612 ldo_1v2_a_0.VDD.t64 0.001
R5941 ldo_1v2_a_0.VDD.n387 ldo_1v2_a_0.VDD.n329 0.001
R5942 ldo_1v2_a_0.VDD.n553 ldo_1v2_a_0.VDD.n552 0.001
R5943 ldo_1v2_a_0.VDD.n556 ldo_1v2_a_0.VDD.n555 0.001
R5944 ldo_1v2_a_0.VDD.n559 ldo_1v2_a_0.VDD.n550 0.001
R5945 ldo_1v2_a_0.VDD.n562 ldo_1v2_a_0.VDD.n561 0.001
R5946 ldo_1v2_a_0.VDD.n565 ldo_1v2_a_0.VDD.n564 0.001
R5947 ldo_1v2_a_0.VDD.n574 ldo_1v2_a_0.VDD.n573 0.001
R5948 ldo_1v2_a_0.VDD.n577 ldo_1v2_a_0.VDD.n545 0.001
R5949 ldo_1v2_a_0.VDD.n580 ldo_1v2_a_0.VDD.n579 0.001
R5950 ldo_1v2_a_0.VDD.n582 ldo_1v2_a_0.VDD.n581 0.001
R5951 ldo_1v2_a_0.VDD.n585 ldo_1v2_a_0.VDD.n543 0.001
R5952 ldo_1v2_a_0.VDD.n587 ldo_1v2_a_0.VDD.n586 0.001
R5953 ldo_1v2_a_0.VDD.n611 ldo_1v2_a_0.VDD.n330 0.001
R5954 ldo_1v2_a_0.VDD.n381 ldo_1v2_a_0.VDD.n329 0.001
R5955 ldo_1v2_a_0.VDD.n665 ldo_1v2_a_0.VDD.n322 0.001
R5956 ldo_1v2_a_0.VDD.n296 ldo_1v2_a_0.VDD.n291 0.001
R5957 ldo_1v2_a_0.VDD.n344 ldo_1v2_a_0.VDD.n297 0.001
R5958 ldo_1v2_a_0.VDD.n343 ldo_1v2_a_0.VDD.n295 0.001
R5959 ldo_1v2_a_0.VDD.n342 ldo_1v2_a_0.VDD.n294 0.001
R5960 ldo_1v2_a_0.VDD.n341 ldo_1v2_a_0.VDD.n293 0.001
R5961 ldo_1v2_a_0.VDD.n340 ldo_1v2_a_0.VDD.n292 0.001
R5962 ldo_1v2_a_0.VDD.n340 ldo_1v2_a_0.VDD.n323 0.001
R5963 ldo_1v2_a_0.VDD.n339 ldo_1v2_a_0.VDD.n324 0.001
R5964 ldo_1v2_a_0.VDD.n338 ldo_1v2_a_0.VDD.n325 0.001
R5965 ldo_1v2_a_0.VDD.n337 ldo_1v2_a_0.VDD.n326 0.001
R5966 ldo_1v2_a_0.VDD.n682 ldo_1v2_a_0.VDD.n335 0.001
R5967 ldo_1v2_a_0.VDD.n355 ldo_1v2_a_0.VDD.n334 0.001
R5968 ldo_1v2_a_0.VDD.n354 ldo_1v2_a_0.VDD.n333 0.001
R5969 ldo_1v2_a_0.VDD.n353 ldo_1v2_a_0.VDD.n332 0.001
R5970 ldo_1v2_a_0.VDD.n352 ldo_1v2_a_0.VDD.n331 0.001
R5971 ldo_1v2_a_0.VDD.n665 ldo_1v2_a_0.VDD.n327 0.001
R5972 ldo_1v2_a_0.VDD.n352 ldo_1v2_a_0.VDD.n327 0.001
R5973 ldo_1v2_a_0.VDD.n353 ldo_1v2_a_0.VDD.n331 0.001
R5974 ldo_1v2_a_0.VDD.n354 ldo_1v2_a_0.VDD.n332 0.001
R5975 ldo_1v2_a_0.VDD.n355 ldo_1v2_a_0.VDD.n333 0.001
R5976 ldo_1v2_a_0.VDD.n335 ldo_1v2_a_0.VDD.n334 0.001
R5977 ldo_1v2_a_0.VDD.n682 ldo_1v2_a_0.VDD.n681 0.001
R5978 ldo_1v2_a_0.VDD.n681 ldo_1v2_a_0.VDD.n326 0.001
R5979 ldo_1v2_a_0.VDD.n337 ldo_1v2_a_0.VDD.n325 0.001
R5980 ldo_1v2_a_0.VDD.n338 ldo_1v2_a_0.VDD.n324 0.001
R5981 ldo_1v2_a_0.VDD.n339 ldo_1v2_a_0.VDD.n323 0.001
R5982 ldo_1v2_a_0.VDD.n341 ldo_1v2_a_0.VDD.n292 0.001
R5983 ldo_1v2_a_0.VDD.n342 ldo_1v2_a_0.VDD.n293 0.001
R5984 ldo_1v2_a_0.VDD.n343 ldo_1v2_a_0.VDD.n294 0.001
R5985 ldo_1v2_a_0.VDD.n344 ldo_1v2_a_0.VDD.n295 0.001
R5986 ldo_1v2_a_0.VDD.n297 ldo_1v2_a_0.VDD.n296 0.001
R5987 ldo_1v2_a_0.VDD.n684 ldo_1v2_a_0.VDD.n291 0.001
R5988 ldo_1v2_a_0.VDD.n645 ldo_1v2_a_0.VDD.n322 0.001
R5989 ldo_1v2_a_0.VDD.n645 ldo_1v2_a_0.VDD.n298 0.001
R5990 ldo_1v2_a_0.VDD.n661 ldo_1v2_a_0.VDD.n299 0.001
R5991 ldo_1v2_a_0.VDD.n302 ldo_1v2_a_0.VDD.n301 0.001
R5992 ldo_1v2_a_0.VDD.n303 ldo_1v2_a_0.VDD.n270 0.001
R5993 ldo_1v2_a_0.VDD.n304 ldo_1v2_a_0.VDD.n271 0.001
R5994 ldo_1v2_a_0.VDD.n305 ldo_1v2_a_0.VDD.n272 0.001
R5995 ldo_1v2_a_0.VDD.n306 ldo_1v2_a_0.VDD.n273 0.001
R5996 ldo_1v2_a_0.VDD.n307 ldo_1v2_a_0.VDD.n274 0.001
R5997 ldo_1v2_a_0.VDD.n308 ldo_1v2_a_0.VDD.n275 0.001
R5998 ldo_1v2_a_0.VDD.n309 ldo_1v2_a_0.VDD.n276 0.001
R5999 ldo_1v2_a_0.VDD.n310 ldo_1v2_a_0.VDD.n277 0.001
R6000 ldo_1v2_a_0.VDD.n311 ldo_1v2_a_0.VDD.n278 0.001
R6001 ldo_1v2_a_0.VDD.n312 ldo_1v2_a_0.VDD.n279 0.001
R6002 ldo_1v2_a_0.VDD.n313 ldo_1v2_a_0.VDD.n280 0.001
R6003 ldo_1v2_a_0.VDD.n314 ldo_1v2_a_0.VDD.n281 0.001
R6004 ldo_1v2_a_0.VDD.n315 ldo_1v2_a_0.VDD.n282 0.001
R6005 ldo_1v2_a_0.VDD.n316 ldo_1v2_a_0.VDD.n283 0.001
R6006 ldo_1v2_a_0.VDD.n317 ldo_1v2_a_0.VDD.n284 0.001
R6007 ldo_1v2_a_0.VDD.n318 ldo_1v2_a_0.VDD.n285 0.001
R6008 ldo_1v2_a_0.VDD.n319 ldo_1v2_a_0.VDD.n286 0.001
R6009 ldo_1v2_a_0.VDD.n320 ldo_1v2_a_0.VDD.n287 0.001
R6010 ldo_1v2_a_0.VDD.n321 ldo_1v2_a_0.VDD.n288 0.001
R6011 ldo_1v2_a_0.VDD.n683 ldo_1v2_a_0.VDD.n289 0.001
R6012 ldo_1v2_a_0.VDD.n646 ldo_1v2_a_0.VDD.n299 0.001
R6013 ldo_1v2_a_0.VDD.n303 ldo_1v2_a_0.VDD.n271 0.001
R6014 ldo_1v2_a_0.VDD.n304 ldo_1v2_a_0.VDD.n272 0.001
R6015 ldo_1v2_a_0.VDD.n305 ldo_1v2_a_0.VDD.n273 0.001
R6016 ldo_1v2_a_0.VDD.n306 ldo_1v2_a_0.VDD.n274 0.001
R6017 ldo_1v2_a_0.VDD.n307 ldo_1v2_a_0.VDD.n275 0.001
R6018 ldo_1v2_a_0.VDD.n308 ldo_1v2_a_0.VDD.n276 0.001
R6019 ldo_1v2_a_0.VDD.n309 ldo_1v2_a_0.VDD.n277 0.001
R6020 ldo_1v2_a_0.VDD.n310 ldo_1v2_a_0.VDD.n278 0.001
R6021 ldo_1v2_a_0.VDD.n311 ldo_1v2_a_0.VDD.n279 0.001
R6022 ldo_1v2_a_0.VDD.n312 ldo_1v2_a_0.VDD.n280 0.001
R6023 ldo_1v2_a_0.VDD.n313 ldo_1v2_a_0.VDD.n281 0.001
R6024 ldo_1v2_a_0.VDD.n314 ldo_1v2_a_0.VDD.n282 0.001
R6025 ldo_1v2_a_0.VDD.n315 ldo_1v2_a_0.VDD.n283 0.001
R6026 ldo_1v2_a_0.VDD.n316 ldo_1v2_a_0.VDD.n284 0.001
R6027 ldo_1v2_a_0.VDD.n317 ldo_1v2_a_0.VDD.n285 0.001
R6028 ldo_1v2_a_0.VDD.n318 ldo_1v2_a_0.VDD.n286 0.001
R6029 ldo_1v2_a_0.VDD.n319 ldo_1v2_a_0.VDD.n287 0.001
R6030 ldo_1v2_a_0.VDD.n320 ldo_1v2_a_0.VDD.n288 0.001
R6031 ldo_1v2_a_0.VDD.n321 ldo_1v2_a_0.VDD.n289 0.001
R6032 ldo_1v2_a_0.VDD.n684 ldo_1v2_a_0.VDD.n683 0.001
R6033 ldo_1v2_a_0.VDD.n302 ldo_1v2_a_0.VDD.n270 0.001
R6034 ldo_1v2_a_0.VDD.n661 ldo_1v2_a_0.VDD.n298 0.001
R6035 ldo_1v2_a_0.VDD.n744 ldo_1v2_a_0.VDD.n241 0.001
R6036 ldo_1v2_a_0.VDD.n267 ldo_1v2_a_0.VDD.n241 0.001
R6037 ldo_1v2_a_0.VDD.n712 ldo_1v2_a_0.VDD.n240 0.001
R6038 ldo_1v2_a_0.VDD.n249 ldo_1v2_a_0.VDD.n247 0.001
R6039 ldo_1v2_a_0.VDD.n252 ldo_1v2_a_0.VDD.n251 0.001
R6040 ldo_1v2_a_0.VDD.n253 ldo_1v2_a_0.VDD.n235 0.001
R6041 ldo_1v2_a_0.VDD.n254 ldo_1v2_a_0.VDD.n238 0.001
R6042 ldo_1v2_a_0.VDD.n256 ldo_1v2_a_0.VDD.n237 0.001
R6043 ldo_1v2_a_0.VDD.n264 ldo_1v2_a_0.VDD.n236 0.001
R6044 ldo_1v2_a_0.VDD.n714 ldo_1v2_a_0.VDD.n713 0.001
R6045 ldo_1v2_a_0.VDD.n256 ldo_1v2_a_0.VDD.n236 0.001
R6046 ldo_1v2_a_0.VDD.n254 ldo_1v2_a_0.VDD.n237 0.001
R6047 ldo_1v2_a_0.VDD.n253 ldo_1v2_a_0.VDD.n238 0.001
R6048 ldo_1v2_a_0.VDD.n252 ldo_1v2_a_0.VDD.n235 0.001
R6049 ldo_1v2_a_0.VDD.n251 ldo_1v2_a_0.VDD.n249 0.001
R6050 ldo_1v2_a_0.VDD.n247 ldo_1v2_a_0.VDD.n246 0.001
R6051 ldo_1v2_a_0.VDD.n744 ldo_1v2_a_0.VDD.n246 0.001
R6052 ldo_1v2_a_0.VDD.n250 ldo_1v2_a_0.VDD.n234 0.001
R6053 ldo_1v2_a_0.VDD.t0 ldo_1v2_a_0.VDD.n75 0.001
R6054 ldo_1v2_a_0.VDD.n75 ldo_1v2_a_0.VDD.t91 0.001
R6055 ldo_1v2_a_0.VDD.n966 ldo_1v2_a_0.VDD.n42 0.001
R6056 ldo_1v2_a_0.VDD.n964 ldo_1v2_a_0.VDD.n43 0.001
R6057 ldo_1v2_a_0.VDD.n962 ldo_1v2_a_0.VDD.n44 0.001
R6058 ldo_1v2_a_0.VDD.n960 ldo_1v2_a_0.VDD.n45 0.001
R6059 ldo_1v2_a_0.VDD.n958 ldo_1v2_a_0.VDD.n46 0.001
R6060 ldo_1v2_a_0.VDD.n956 ldo_1v2_a_0.VDD.n47 0.001
R6061 ldo_1v2_a_0.VDD.n954 ldo_1v2_a_0.VDD.n48 0.001
R6062 ldo_1v2_a_0.VDD.n952 ldo_1v2_a_0.VDD.n49 0.001
R6063 ldo_1v2_a_0.VDD.n950 ldo_1v2_a_0.VDD.n50 0.001
R6064 ldo_1v2_a_0.VDD.n948 ldo_1v2_a_0.VDD.n51 0.001
R6065 ldo_1v2_a_0.VDD.n946 ldo_1v2_a_0.VDD.n52 0.001
R6066 ldo_1v2_a_0.VDD.n944 ldo_1v2_a_0.VDD.n53 0.001
R6067 ldo_1v2_a_0.VDD.n942 ldo_1v2_a_0.VDD.n54 0.001
R6068 ldo_1v2_a_0.VDD.n940 ldo_1v2_a_0.VDD.n55 0.001
R6069 ldo_1v2_a_0.VDD.n938 ldo_1v2_a_0.VDD.n56 0.001
R6070 ldo_1v2_a_0.VDD.n936 ldo_1v2_a_0.VDD.n57 0.001
R6071 ldo_1v2_a_0.VDD.n934 ldo_1v2_a_0.VDD.n58 0.001
R6072 ldo_1v2_a_0.VDD.n932 ldo_1v2_a_0.VDD.n59 0.001
R6073 ldo_1v2_a_0.VDD.n930 ldo_1v2_a_0.VDD.n60 0.001
R6074 ldo_1v2_a_0.VDD.n928 ldo_1v2_a_0.VDD.n61 0.001
R6075 ldo_1v2_a_0.VDD.n926 ldo_1v2_a_0.VDD.n62 0.001
R6076 ldo_1v2_a_0.VDD.n924 ldo_1v2_a_0.VDD.n63 0.001
R6077 ldo_1v2_a_0.VDD.n922 ldo_1v2_a_0.VDD.n64 0.001
R6078 ldo_1v2_a_0.VDD.n920 ldo_1v2_a_0.VDD.n65 0.001
R6079 ldo_1v2_a_0.VDD.n918 ldo_1v2_a_0.VDD.n66 0.001
R6080 ldo_1v2_a_0.VDD.n916 ldo_1v2_a_0.VDD.n67 0.001
R6081 ldo_1v2_a_0.VDD.n914 ldo_1v2_a_0.VDD.n68 0.001
R6082 ldo_1v2_a_0.VDD.n912 ldo_1v2_a_0.VDD.n69 0.001
R6083 ldo_1v2_a_0.VDD.n910 ldo_1v2_a_0.VDD.n70 0.001
R6084 ldo_1v2_a_0.VDD.n908 ldo_1v2_a_0.VDD.n71 0.001
R6085 ldo_1v2_a_0.VDD.n906 ldo_1v2_a_0.VDD.n72 0.001
R6086 ldo_1v2_a_0.VDD.n904 ldo_1v2_a_0.VDD.n73 0.001
R6087 ldo_1v2_a_0.VDD.n902 ldo_1v2_a_0.VDD.n74 0.001
R6088 ldo_1v2_a_0.VDD.n182 ldo_1v2_a_0.VDD.n77 0.001
R6089 ldo_1v2_a_0.VDD.n180 ldo_1v2_a_0.VDD.n78 0.001
R6090 ldo_1v2_a_0.VDD.n178 ldo_1v2_a_0.VDD.n79 0.001
R6091 ldo_1v2_a_0.VDD.n176 ldo_1v2_a_0.VDD.n80 0.001
R6092 ldo_1v2_a_0.VDD.n174 ldo_1v2_a_0.VDD.n81 0.001
R6093 ldo_1v2_a_0.VDD.n172 ldo_1v2_a_0.VDD.n82 0.001
R6094 ldo_1v2_a_0.VDD.n170 ldo_1v2_a_0.VDD.n83 0.001
R6095 ldo_1v2_a_0.VDD.n168 ldo_1v2_a_0.VDD.n84 0.001
R6096 ldo_1v2_a_0.VDD.n166 ldo_1v2_a_0.VDD.n85 0.001
R6097 ldo_1v2_a_0.VDD.n164 ldo_1v2_a_0.VDD.n86 0.001
R6098 ldo_1v2_a_0.VDD.n162 ldo_1v2_a_0.VDD.n87 0.001
R6099 ldo_1v2_a_0.VDD.n160 ldo_1v2_a_0.VDD.n88 0.001
R6100 ldo_1v2_a_0.VDD.n158 ldo_1v2_a_0.VDD.n89 0.001
R6101 ldo_1v2_a_0.VDD.n156 ldo_1v2_a_0.VDD.n90 0.001
R6102 ldo_1v2_a_0.VDD.n154 ldo_1v2_a_0.VDD.n91 0.001
R6103 ldo_1v2_a_0.VDD.n152 ldo_1v2_a_0.VDD.n92 0.001
R6104 ldo_1v2_a_0.VDD.n150 ldo_1v2_a_0.VDD.n93 0.001
R6105 ldo_1v2_a_0.VDD.n148 ldo_1v2_a_0.VDD.n94 0.001
R6106 ldo_1v2_a_0.VDD.n146 ldo_1v2_a_0.VDD.n95 0.001
R6107 ldo_1v2_a_0.VDD.n144 ldo_1v2_a_0.VDD.n96 0.001
R6108 ldo_1v2_a_0.VDD.n120 ldo_1v2_a_0.VDD.n97 0.001
R6109 ldo_1v2_a_0.VDD.n877 ldo_1v2_a_0.VDD.n98 0.001
R6110 ldo_1v2_a_0.VDD.n876 ldo_1v2_a_0.VDD.n99 0.001
R6111 ldo_1v2_a_0.VDD.n875 ldo_1v2_a_0.VDD.n100 0.001
R6112 ldo_1v2_a_0.VDD.n874 ldo_1v2_a_0.VDD.n101 0.001
R6113 ldo_1v2_a_0.VDD.n873 ldo_1v2_a_0.VDD.n102 0.001
R6114 ldo_1v2_a_0.VDD.n872 ldo_1v2_a_0.VDD.n103 0.001
R6115 ldo_1v2_a_0.VDD.n871 ldo_1v2_a_0.VDD.n104 0.001
R6116 ldo_1v2_a_0.VDD.n870 ldo_1v2_a_0.VDD.n105 0.001
R6117 ldo_1v2_a_0.VDD.n869 ldo_1v2_a_0.VDD.n106 0.001
R6118 ldo_1v2_a_0.VDD.n868 ldo_1v2_a_0.VDD.n107 0.001
R6119 ldo_1v2_a_0.VDD.n867 ldo_1v2_a_0.VDD.n108 0.001
R6120 ldo_1v2_a_0.VDD.n866 ldo_1v2_a_0.VDD.n109 0.001
R6121 ldo_1v2_a_0.VDD.n865 ldo_1v2_a_0.VDD.n110 0.001
R6122 ldo_1v2_a_0.VDD.n864 ldo_1v2_a_0.VDD.n111 0.001
R6123 ldo_1v2_a_0.VDD.n863 ldo_1v2_a_0.VDD.n112 0.001
R6124 ldo_1v2_a_0.VDD.n862 ldo_1v2_a_0.VDD.n113 0.001
R6125 ldo_1v2_a_0.VDD.n861 ldo_1v2_a_0.VDD.n114 0.001
R6126 ldo_1v2_a_0.VDD.n860 ldo_1v2_a_0.VDD.n115 0.001
R6127 ldo_1v2_a_0.VDD.n859 ldo_1v2_a_0.VDD.n116 0.001
R6128 ldo_1v2_a_0.VDD.n858 ldo_1v2_a_0.VDD.n117 0.001
R6129 ldo_1v2_a_0.VDD.n857 ldo_1v2_a_0.VDD.n118 0.001
R6130 ldo_1v2_a_0.VDD.n142 ldo_1v2_a_0.VDD.n96 0.001
R6131 ldo_1v2_a_0.VDD.n144 ldo_1v2_a_0.VDD.n95 0.001
R6132 ldo_1v2_a_0.VDD.n146 ldo_1v2_a_0.VDD.n94 0.001
R6133 ldo_1v2_a_0.VDD.n148 ldo_1v2_a_0.VDD.n93 0.001
R6134 ldo_1v2_a_0.VDD.n150 ldo_1v2_a_0.VDD.n92 0.001
R6135 ldo_1v2_a_0.VDD.n152 ldo_1v2_a_0.VDD.n91 0.001
R6136 ldo_1v2_a_0.VDD.n154 ldo_1v2_a_0.VDD.n90 0.001
R6137 ldo_1v2_a_0.VDD.n156 ldo_1v2_a_0.VDD.n89 0.001
R6138 ldo_1v2_a_0.VDD.n158 ldo_1v2_a_0.VDD.n88 0.001
R6139 ldo_1v2_a_0.VDD.n160 ldo_1v2_a_0.VDD.n87 0.001
R6140 ldo_1v2_a_0.VDD.n162 ldo_1v2_a_0.VDD.n86 0.001
R6141 ldo_1v2_a_0.VDD.n164 ldo_1v2_a_0.VDD.n85 0.001
R6142 ldo_1v2_a_0.VDD.n166 ldo_1v2_a_0.VDD.n84 0.001
R6143 ldo_1v2_a_0.VDD.n168 ldo_1v2_a_0.VDD.n83 0.001
R6144 ldo_1v2_a_0.VDD.n170 ldo_1v2_a_0.VDD.n82 0.001
R6145 ldo_1v2_a_0.VDD.n172 ldo_1v2_a_0.VDD.n81 0.001
R6146 ldo_1v2_a_0.VDD.n174 ldo_1v2_a_0.VDD.n80 0.001
R6147 ldo_1v2_a_0.VDD.n176 ldo_1v2_a_0.VDD.n79 0.001
R6148 ldo_1v2_a_0.VDD.n178 ldo_1v2_a_0.VDD.n78 0.001
R6149 ldo_1v2_a_0.VDD.n180 ldo_1v2_a_0.VDD.n77 0.001
R6150 ldo_1v2_a_0.VDD.n856 ldo_1v2_a_0.VDD.n118 0.001
R6151 ldo_1v2_a_0.VDD.n857 ldo_1v2_a_0.VDD.n117 0.001
R6152 ldo_1v2_a_0.VDD.n858 ldo_1v2_a_0.VDD.n116 0.001
R6153 ldo_1v2_a_0.VDD.n859 ldo_1v2_a_0.VDD.n115 0.001
R6154 ldo_1v2_a_0.VDD.n860 ldo_1v2_a_0.VDD.n114 0.001
R6155 ldo_1v2_a_0.VDD.n861 ldo_1v2_a_0.VDD.n113 0.001
R6156 ldo_1v2_a_0.VDD.n862 ldo_1v2_a_0.VDD.n112 0.001
R6157 ldo_1v2_a_0.VDD.n863 ldo_1v2_a_0.VDD.n111 0.001
R6158 ldo_1v2_a_0.VDD.n864 ldo_1v2_a_0.VDD.n110 0.001
R6159 ldo_1v2_a_0.VDD.n865 ldo_1v2_a_0.VDD.n109 0.001
R6160 ldo_1v2_a_0.VDD.n866 ldo_1v2_a_0.VDD.n108 0.001
R6161 ldo_1v2_a_0.VDD.n867 ldo_1v2_a_0.VDD.n107 0.001
R6162 ldo_1v2_a_0.VDD.n868 ldo_1v2_a_0.VDD.n106 0.001
R6163 ldo_1v2_a_0.VDD.n869 ldo_1v2_a_0.VDD.n105 0.001
R6164 ldo_1v2_a_0.VDD.n870 ldo_1v2_a_0.VDD.n104 0.001
R6165 ldo_1v2_a_0.VDD.n871 ldo_1v2_a_0.VDD.n103 0.001
R6166 ldo_1v2_a_0.VDD.n872 ldo_1v2_a_0.VDD.n102 0.001
R6167 ldo_1v2_a_0.VDD.n873 ldo_1v2_a_0.VDD.n101 0.001
R6168 ldo_1v2_a_0.VDD.n874 ldo_1v2_a_0.VDD.n100 0.001
R6169 ldo_1v2_a_0.VDD.n875 ldo_1v2_a_0.VDD.n99 0.001
R6170 ldo_1v2_a_0.VDD.n876 ldo_1v2_a_0.VDD.n98 0.001
R6171 ldo_1v2_a_0.VDD.n877 ldo_1v2_a_0.VDD.n97 0.001
R6172 ldo_1v2_a_0.VDD.n900 ldo_1v2_a_0.VDD.n74 0.001
R6173 ldo_1v2_a_0.VDD.n902 ldo_1v2_a_0.VDD.n73 0.001
R6174 ldo_1v2_a_0.VDD.n904 ldo_1v2_a_0.VDD.n72 0.001
R6175 ldo_1v2_a_0.VDD.n906 ldo_1v2_a_0.VDD.n71 0.001
R6176 ldo_1v2_a_0.VDD.n908 ldo_1v2_a_0.VDD.n70 0.001
R6177 ldo_1v2_a_0.VDD.n910 ldo_1v2_a_0.VDD.n69 0.001
R6178 ldo_1v2_a_0.VDD.n912 ldo_1v2_a_0.VDD.n68 0.001
R6179 ldo_1v2_a_0.VDD.n914 ldo_1v2_a_0.VDD.n67 0.001
R6180 ldo_1v2_a_0.VDD.n916 ldo_1v2_a_0.VDD.n66 0.001
R6181 ldo_1v2_a_0.VDD.n918 ldo_1v2_a_0.VDD.n65 0.001
R6182 ldo_1v2_a_0.VDD.n920 ldo_1v2_a_0.VDD.n64 0.001
R6183 ldo_1v2_a_0.VDD.n922 ldo_1v2_a_0.VDD.n63 0.001
R6184 ldo_1v2_a_0.VDD.n924 ldo_1v2_a_0.VDD.n62 0.001
R6185 ldo_1v2_a_0.VDD.n926 ldo_1v2_a_0.VDD.n61 0.001
R6186 ldo_1v2_a_0.VDD.n928 ldo_1v2_a_0.VDD.n60 0.001
R6187 ldo_1v2_a_0.VDD.n930 ldo_1v2_a_0.VDD.n59 0.001
R6188 ldo_1v2_a_0.VDD.n932 ldo_1v2_a_0.VDD.n58 0.001
R6189 ldo_1v2_a_0.VDD.n934 ldo_1v2_a_0.VDD.n57 0.001
R6190 ldo_1v2_a_0.VDD.n936 ldo_1v2_a_0.VDD.n56 0.001
R6191 ldo_1v2_a_0.VDD.n938 ldo_1v2_a_0.VDD.n55 0.001
R6192 ldo_1v2_a_0.VDD.n940 ldo_1v2_a_0.VDD.n54 0.001
R6193 ldo_1v2_a_0.VDD.n942 ldo_1v2_a_0.VDD.n53 0.001
R6194 ldo_1v2_a_0.VDD.n944 ldo_1v2_a_0.VDD.n52 0.001
R6195 ldo_1v2_a_0.VDD.n946 ldo_1v2_a_0.VDD.n51 0.001
R6196 ldo_1v2_a_0.VDD.n948 ldo_1v2_a_0.VDD.n50 0.001
R6197 ldo_1v2_a_0.VDD.n950 ldo_1v2_a_0.VDD.n49 0.001
R6198 ldo_1v2_a_0.VDD.n952 ldo_1v2_a_0.VDD.n48 0.001
R6199 ldo_1v2_a_0.VDD.n954 ldo_1v2_a_0.VDD.n47 0.001
R6200 ldo_1v2_a_0.VDD.n956 ldo_1v2_a_0.VDD.n46 0.001
R6201 ldo_1v2_a_0.VDD.n958 ldo_1v2_a_0.VDD.n45 0.001
R6202 ldo_1v2_a_0.VDD.n960 ldo_1v2_a_0.VDD.n44 0.001
R6203 ldo_1v2_a_0.VDD.n962 ldo_1v2_a_0.VDD.n43 0.001
R6204 ldo_1v2_a_0.VDD.n964 ldo_1v2_a_0.VDD.n42 0.001
R6205 ldo_1v2_a_0.VDD.n753 ldo_1v2_a_0.VDD.n122 0.001
R6206 ldo_1v2_a_0.VDD.n755 ldo_1v2_a_0.VDD.n123 0.001
R6207 ldo_1v2_a_0.VDD.n757 ldo_1v2_a_0.VDD.n124 0.001
R6208 ldo_1v2_a_0.VDD.n759 ldo_1v2_a_0.VDD.n125 0.001
R6209 ldo_1v2_a_0.VDD.n761 ldo_1v2_a_0.VDD.n126 0.001
R6210 ldo_1v2_a_0.VDD.n763 ldo_1v2_a_0.VDD.n127 0.001
R6211 ldo_1v2_a_0.VDD.n765 ldo_1v2_a_0.VDD.n128 0.001
R6212 ldo_1v2_a_0.VDD.n767 ldo_1v2_a_0.VDD.n129 0.001
R6213 ldo_1v2_a_0.VDD.n769 ldo_1v2_a_0.VDD.n130 0.001
R6214 ldo_1v2_a_0.VDD.n771 ldo_1v2_a_0.VDD.n131 0.001
R6215 ldo_1v2_a_0.VDD.n773 ldo_1v2_a_0.VDD.n132 0.001
R6216 ldo_1v2_a_0.VDD.n775 ldo_1v2_a_0.VDD.n133 0.001
R6217 ldo_1v2_a_0.VDD.n777 ldo_1v2_a_0.VDD.n134 0.001
R6218 ldo_1v2_a_0.VDD.n779 ldo_1v2_a_0.VDD.n135 0.001
R6219 ldo_1v2_a_0.VDD.n781 ldo_1v2_a_0.VDD.n136 0.001
R6220 ldo_1v2_a_0.VDD.n783 ldo_1v2_a_0.VDD.n137 0.001
R6221 ldo_1v2_a_0.VDD.n785 ldo_1v2_a_0.VDD.n138 0.001
R6222 ldo_1v2_a_0.VDD.n787 ldo_1v2_a_0.VDD.n139 0.001
R6223 ldo_1v2_a_0.VDD.n141 ldo_1v2_a_0.VDD.n140 0.001
R6224 ldo_1v2_a_0.VDD.n792 ldo_1v2_a_0.VDD.n791 0.001
R6225 ldo_1v2_a_0.VDD.n972 ldo_1v2_a_0.VDD.n39 0.001
R6226 ldo_1v2_a_0.VDD.n971 ldo_1v2_a_0.VDD.n40 0.001
R6227 ldo_1v2_a_0.VDD.n815 ldo_1v2_a_0.VDD.n793 0.001
R6228 ldo_1v2_a_0.VDD.n817 ldo_1v2_a_0.VDD.n794 0.001
R6229 ldo_1v2_a_0.VDD.n819 ldo_1v2_a_0.VDD.n795 0.001
R6230 ldo_1v2_a_0.VDD.n821 ldo_1v2_a_0.VDD.n796 0.001
R6231 ldo_1v2_a_0.VDD.n823 ldo_1v2_a_0.VDD.n797 0.001
R6232 ldo_1v2_a_0.VDD.n825 ldo_1v2_a_0.VDD.n798 0.001
R6233 ldo_1v2_a_0.VDD.n827 ldo_1v2_a_0.VDD.n799 0.001
R6234 ldo_1v2_a_0.VDD.n829 ldo_1v2_a_0.VDD.n800 0.001
R6235 ldo_1v2_a_0.VDD.n831 ldo_1v2_a_0.VDD.n801 0.001
R6236 ldo_1v2_a_0.VDD.n833 ldo_1v2_a_0.VDD.n802 0.001
R6237 ldo_1v2_a_0.VDD.n835 ldo_1v2_a_0.VDD.n803 0.001
R6238 ldo_1v2_a_0.VDD.n837 ldo_1v2_a_0.VDD.n804 0.001
R6239 ldo_1v2_a_0.VDD.n839 ldo_1v2_a_0.VDD.n805 0.001
R6240 ldo_1v2_a_0.VDD.n841 ldo_1v2_a_0.VDD.n806 0.001
R6241 ldo_1v2_a_0.VDD.n843 ldo_1v2_a_0.VDD.n807 0.001
R6242 ldo_1v2_a_0.VDD.n845 ldo_1v2_a_0.VDD.n808 0.001
R6243 ldo_1v2_a_0.VDD.n847 ldo_1v2_a_0.VDD.n809 0.001
R6244 ldo_1v2_a_0.VDD.n849 ldo_1v2_a_0.VDD.n810 0.001
R6245 ldo_1v2_a_0.VDD.n851 ldo_1v2_a_0.VDD.n811 0.001
R6246 ldo_1v2_a_0.VDD.n853 ldo_1v2_a_0.VDD.n812 0.001
R6247 ldo_1v2_a_0.VDD.n814 ldo_1v2_a_0.VDD.n813 0.001
R6248 ldo_1v2_a_0.VDD.n970 ldo_1v2_a_0.VDD.n969 0.001
R6249 ldo_1v2_a_0.VDD.n653 ldo_1v2_a_0.VDD.n652 0.000933071
R6250 ldo_1v2_a_0.VDD.n748 ldo_1v2_a_0.VDD.n192 0.000572464
R6251 VDD_1v5.n0 VDD_1v5.t17 27.785
R6252 VDD_1v5 VDD_1v5.n30 8.6768
R6253 VDD_1v5.n30 VDD_1v5.n29 7.80884
R6254 VDD_1v5.n0 VDD_1v5.t16 7.45931
R6255 VDD_1v5.n30 VDD_1v5.n0 5.81741
R6256 VDD_1v5.n7 VDD_1v5.n6 4.51203
R6257 VDD_1v5.n8 VDD_1v5.n5 4.51203
R6258 VDD_1v5.n9 VDD_1v5.n4 4.51203
R6259 VDD_1v5.n10 VDD_1v5.n3 4.51203
R6260 VDD_1v5.n11 VDD_1v5.n2 4.51203
R6261 VDD_1v5.n13 VDD_1v5.n12 4.51203
R6262 VDD_1v5.n15 VDD_1v5.n14 4.51203
R6263 VDD_1v5.n23 VDD_1v5.n22 4.51203
R6264 VDD_1v5.n22 VDD_1v5.n21 3.93105
R6265 VDD_1v5.n16 VDD_1v5.n15 3.93088
R6266 VDD_1v5.n14 VDD_1v5.n1 3.45378
R6267 VDD_1v5.n24 VDD_1v5.n23 3.45378
R6268 VDD_1v5.n21 VDD_1v5.n7 2.145
R6269 VDD_1v5.n20 VDD_1v5.n8 2.145
R6270 VDD_1v5.n19 VDD_1v5.n9 2.145
R6271 VDD_1v5.n18 VDD_1v5.n10 2.145
R6272 VDD_1v5.n17 VDD_1v5.n11 2.145
R6273 VDD_1v5.n16 VDD_1v5.n13 2.145
R6274 VDD_1v5.n24 VDD_1v5.n6 2.13378
R6275 VDD_1v5.n25 VDD_1v5.n5 2.13378
R6276 VDD_1v5.n26 VDD_1v5.n4 2.13378
R6277 VDD_1v5.n27 VDD_1v5.n3 2.13378
R6278 VDD_1v5.n28 VDD_1v5.n2 2.13378
R6279 VDD_1v5.n12 VDD_1v5.n1 2.13378
R6280 VDD_1v5.n17 VDD_1v5.n16 1.78638
R6281 VDD_1v5.n18 VDD_1v5.n17 1.78638
R6282 VDD_1v5.n19 VDD_1v5.n18 1.78638
R6283 VDD_1v5.n20 VDD_1v5.n19 1.78638
R6284 VDD_1v5.n21 VDD_1v5.n20 1.78638
R6285 VDD_1v5.n28 VDD_1v5.n27 1.3205
R6286 VDD_1v5.n27 VDD_1v5.n26 1.3205
R6287 VDD_1v5.n26 VDD_1v5.n25 1.3205
R6288 VDD_1v5.n25 VDD_1v5.n24 1.3205
R6289 VDD_1v5.n29 VDD_1v5.n28 0.978543
R6290 VDD_1v5.n29 VDD_1v5.n1 0.342457
R6291 VDD_1v5.n22 VDD_1v5.t9 0.0432676
R6292 VDD_1v5.n6 VDD_1v5.t3 0.0432658
R6293 VDD_1v5.n7 VDD_1v5.t10 0.0432658
R6294 VDD_1v5.n5 VDD_1v5.t6 0.0432658
R6295 VDD_1v5.n8 VDD_1v5.t14 0.0432658
R6296 VDD_1v5.n4 VDD_1v5.t4 0.0432658
R6297 VDD_1v5.n9 VDD_1v5.t13 0.0432658
R6298 VDD_1v5.n3 VDD_1v5.t8 0.0432658
R6299 VDD_1v5.n10 VDD_1v5.t1 0.0432658
R6300 VDD_1v5.n2 VDD_1v5.t12 0.0432658
R6301 VDD_1v5.n11 VDD_1v5.t0 0.0432658
R6302 VDD_1v5.n12 VDD_1v5.t11 0.0432658
R6303 VDD_1v5.n13 VDD_1v5.t7 0.0432658
R6304 VDD_1v5.n14 VDD_1v5.t15 0.0432658
R6305 VDD_1v5.n15 VDD_1v5.t5 0.0432658
R6306 VDD_1v5.n23 VDD_1v5.t2 0.0432658
R6307 a_5285_743.t0 a_5285_743.t1 30.3643
R6308 a_5563_572.t0 a_5563_572.t1 30.3622
R6309 bgr_0.v8t.n18 bgr_0.v8t.t0 20.6536
R6310 bgr_0.v8t.n18 bgr_0.bgr_ctat_ref_0.r_ctat 12.5614
R6311 bgr_0.v8t.t1 bgr_0.v8t.n0 3.74469
R6312 bgr_0.v8t.n16 bgr_0.v8t.t1 2.99318
R6313 bgr_0.v8t.n3 bgr_0.v8t.t7 2.76256
R6314 bgr_0.v8t.n11 bgr_0.v8t.t2 2.75741
R6315 bgr_0.bgr_ctat_ref_0.r_ctat bgr_0.v8t.n17 2.42146
R6316 bgr_0.v8t.n6 bgr_0.v8t.t1 1.65036
R6317 bgr_0.v8t.n8 bgr_0.v8t.t1 1.65036
R6318 bgr_0.v8t.n14 bgr_0.v8t.t1 1.65015
R6319 bgr_0.v8t.n10 bgr_0.v8t.t1 1.65006
R6320 bgr_0.v8t.n12 bgr_0.v8t.t1 1.65006
R6321 bgr_0.v8t.n2 bgr_0.v8t.t1 1.64968
R6322 bgr_0.v8t.n4 bgr_0.v8t.t1 1.64967
R6323 bgr_0.v8t.n10 bgr_0.v8t.n9 1.648
R6324 bgr_0.v8t.n2 bgr_0.v8t.n1 1.63032
R6325 bgr_0.v8t.n13 bgr_0.v8t.n12 1.626
R6326 bgr_0.v8t.n5 bgr_0.v8t.n4 1.621
R6327 bgr_0.v8t.n15 bgr_0.v8t.t4 1.5736
R6328 bgr_0.v8t.n5 bgr_0.v8t.t5 1.57337
R6329 bgr_0.v8t.n7 bgr_0.v8t.t6 1.57337
R6330 bgr_0.v8t.n9 bgr_0.v8t.t9 1.57337
R6331 bgr_0.v8t.n13 bgr_0.v8t.t8 1.57337
R6332 bgr_0.v8t.n1 bgr_0.v8t.t3 1.57336
R6333 bgr_0.v8t.n7 bgr_0.v8t.n6 1.46681
R6334 bgr_0.v8t.n15 bgr_0.v8t.n14 1.45427
R6335 bgr_0.v8t.n8 bgr_0.v8t.n7 1.45305
R6336 bgr_0.v8t.n14 bgr_0.v8t.n13 1.43739
R6337 bgr_0.v8t.n9 bgr_0.v8t.n8 1.43588
R6338 bgr_0.v8t.n6 bgr_0.v8t.n5 1.41868
R6339 bgr_0.v8t.n4 bgr_0.v8t.n3 1.40748
R6340 bgr_0.v8t.n1 bgr_0.v8t.n0 1.39226
R6341 bgr_0.v8t.n11 bgr_0.v8t.n10 1.37449
R6342 bgr_0.v8t.n16 bgr_0.v8t.n15 1.32158
R6343 bgr_0.v8t.n3 bgr_0.v8t.n2 0.47764
R6344 bgr_0.v8t.n12 bgr_0.v8t.n11 0.474937
R6345 bgr_0.v8t.n17 bgr_0.v8t.n0 0.0269774
R6346 bgr_0.v8t.n17 bgr_0.v8t.n16 0.0215604
R6347 bgr_0.bgr_resistors_2_0.diode bgr_0.v8t.n18 0.00942754
R6348 a_13967_15066.t0 a_13967_15066.t1 30.3122
R6349 bgr_0.out_opm.n53 bgr_0.out_opm.t1 8.62828
R6350 bgr_0.out_opm.n53 bgr_0.out_opm.t0 8.60176
R6351 bgr_0.out_opm.n46 bgr_0.out_opm.n45 7.24043
R6352 bgr_0.out_opm.n46 bgr_0.out_opm.t9 5.7453
R6353 bgr_0.out_opm.n1 bgr_0.out_opm.n0 5.55612
R6354 bgr_0.opm_bgr_0.bgr_second_stage_0.bgr_second_stage_cs_0.vout_opm bgr_0.out_opm.n54 5.36341
R6355 bgr_0.opm_bgr_0.bgr_second_stage_0.bgr_second_stage_al_0.Vout_opm bgr_0.out_opm.n51 5.35317
R6356 bgr_0.out_opm.n52 bgr_0.opm_bgr_0.bgr_second_stage_0.vout_opm 2.81837
R6357 bgr_0.out_opm.n21 bgr_0.out_opm.t11 2.43688
R6358 bgr_0.out_opm.n47 bgr_0.bgr_ctat_mirror_0.opm_out 2.4211
R6359 bgr_0.out_opm.n28 bgr_0.out_opm.n27 2.28104
R6360 bgr_0.out_opm.n43 bgr_0.out_opm.n3 2.26577
R6361 bgr_0.out_opm.n26 bgr_0.out_opm.n14 2.2505
R6362 bgr_0.out_opm.n25 bgr_0.out_opm.n13 2.2505
R6363 bgr_0.out_opm.n24 bgr_0.out_opm.n23 2.2505
R6364 bgr_0.out_opm.n22 bgr_0.out_opm.n10 2.2505
R6365 bgr_0.out_opm.n20 bgr_0.out_opm.n9 2.2505
R6366 bgr_0.out_opm.n19 bgr_0.out_opm.n8 2.2505
R6367 bgr_0.out_opm.n18 bgr_0.out_opm.n17 2.2505
R6368 bgr_0.out_opm.n16 bgr_0.out_opm.n5 2.2505
R6369 bgr_0.out_opm.n29 bgr_0.out_opm.n15 2.2505
R6370 bgr_0.out_opm.n30 bgr_0.out_opm.n14 2.2505
R6371 bgr_0.out_opm.n31 bgr_0.out_opm.n13 2.2505
R6372 bgr_0.out_opm.n23 bgr_0.out_opm.n11 2.2505
R6373 bgr_0.out_opm.n35 bgr_0.out_opm.n10 2.2505
R6374 bgr_0.out_opm.n36 bgr_0.out_opm.n9 2.2505
R6375 bgr_0.out_opm.n37 bgr_0.out_opm.n8 2.2505
R6376 bgr_0.out_opm.n17 bgr_0.out_opm.n6 2.2505
R6377 bgr_0.out_opm.n41 bgr_0.out_opm.n5 2.2505
R6378 bgr_0.out_opm.n42 bgr_0.out_opm.n4 2.2505
R6379 bgr_0.out_opm.n30 bgr_0.out_opm.n12 2.2505
R6380 bgr_0.out_opm.n32 bgr_0.out_opm.n31 2.2505
R6381 bgr_0.out_opm.n33 bgr_0.out_opm.n11 2.2505
R6382 bgr_0.out_opm.n35 bgr_0.out_opm.n34 2.2505
R6383 bgr_0.out_opm.n36 bgr_0.out_opm.n7 2.2505
R6384 bgr_0.out_opm.n38 bgr_0.out_opm.n37 2.2505
R6385 bgr_0.out_opm.n39 bgr_0.out_opm.n6 2.2505
R6386 bgr_0.out_opm.n41 bgr_0.out_opm.n40 2.2505
R6387 bgr_0.out_opm.n42 bgr_0.out_opm.n2 2.2505
R6388 bgr_0.out_opm.n44 bgr_0.out_opm.n43 2.2505
R6389 bgr_0.out_opm.n48 bgr_0.out_opm.t2 2.1464
R6390 bgr_0.out_opm.n49 bgr_0.out_opm.t3 2.1464
R6391 bgr_0.out_opm.n49 bgr_0.out_opm.t7 2.14097
R6392 bgr_0.out_opm.n50 bgr_0.out_opm.t4 2.14097
R6393 bgr_0.out_opm.n48 bgr_0.out_opm.t6 2.13796
R6394 bgr_0.out_opm.n51 bgr_0.out_opm.n50 1.83146
R6395 bgr_0.out_opm.n54 bgr_0.out_opm.n53 1.71436
R6396 bgr_0.out_opm.n16 bgr_0.out_opm.n3 1.15554
R6397 bgr_0.out_opm.n27 bgr_0.out_opm.n26 1.15554
R6398 bgr_0.out_opm.n28 bgr_0.out_opm.n12 1.15554
R6399 bgr_0.out_opm.n45 bgr_0.out_opm.n1 1.00577
R6400 bgr_0.out_opm.n50 bgr_0.out_opm.n48 0.9405
R6401 bgr_0.out_opm.n50 bgr_0.out_opm.n49 0.9405
R6402 bgr_0.out_opm.n45 bgr_0.out_opm.n44 0.598654
R6403 bgr_0.out_opm.n51 bgr_0.out_opm.t5 0.315722
R6404 bgr_0.opm_bgr_0.bgr_second_stage_0.vout_opm bgr_0.out_opm.n47 0.307564
R6405 bgr_0.out_opm.n54 bgr_0.out_opm.t1 0.275965
R6406 bgr_0.bgr_ctat_mirror_0.opm_out bgr_0.out_opm.n46 0.190578
R6407 bgr_0.opm_bgr_0.bgr_second_stage_0.bgr_second_stage_cs_0.vout_opm bgr_0.out_opm.n52 0.0973
R6408 bgr_0.out_opm.n47 bgr_0.opm_bgr_0.vout 0.0316385
R6409 bgr_0.out_opm.n1 bgr_0.bgr_ref_out_0.opm_out 0.0308448
R6410 bgr_0.out_opm.n18 bgr_0.out_opm.n16 0.0300385
R6411 bgr_0.out_opm.n19 bgr_0.out_opm.n18 0.0300385
R6412 bgr_0.out_opm.n20 bgr_0.out_opm.n19 0.0300385
R6413 bgr_0.out_opm.n24 bgr_0.out_opm.n22 0.0300385
R6414 bgr_0.out_opm.n25 bgr_0.out_opm.n24 0.0300385
R6415 bgr_0.out_opm.n26 bgr_0.out_opm.n25 0.0300385
R6416 bgr_0.out_opm.n5 bgr_0.out_opm.n4 0.0300385
R6417 bgr_0.out_opm.n17 bgr_0.out_opm.n5 0.0300385
R6418 bgr_0.out_opm.n17 bgr_0.out_opm.n8 0.0300385
R6419 bgr_0.out_opm.n9 bgr_0.out_opm.n8 0.0300385
R6420 bgr_0.out_opm.n10 bgr_0.out_opm.n9 0.0300385
R6421 bgr_0.out_opm.n23 bgr_0.out_opm.n10 0.0300385
R6422 bgr_0.out_opm.n23 bgr_0.out_opm.n13 0.0300385
R6423 bgr_0.out_opm.n14 bgr_0.out_opm.n13 0.0300385
R6424 bgr_0.out_opm.n15 bgr_0.out_opm.n14 0.0300385
R6425 bgr_0.out_opm.n43 bgr_0.out_opm.n42 0.0300385
R6426 bgr_0.out_opm.n42 bgr_0.out_opm.n41 0.0300385
R6427 bgr_0.out_opm.n41 bgr_0.out_opm.n6 0.0300385
R6428 bgr_0.out_opm.n37 bgr_0.out_opm.n6 0.0300385
R6429 bgr_0.out_opm.n37 bgr_0.out_opm.n36 0.0300385
R6430 bgr_0.out_opm.n36 bgr_0.out_opm.n35 0.0300385
R6431 bgr_0.out_opm.n35 bgr_0.out_opm.n11 0.0300385
R6432 bgr_0.out_opm.n31 bgr_0.out_opm.n11 0.0300385
R6433 bgr_0.out_opm.n31 bgr_0.out_opm.n30 0.0300385
R6434 bgr_0.out_opm.n30 bgr_0.out_opm.n29 0.0300385
R6435 bgr_0.out_opm.n44 bgr_0.out_opm.n2 0.0300385
R6436 bgr_0.out_opm.n40 bgr_0.out_opm.n2 0.0300385
R6437 bgr_0.out_opm.n40 bgr_0.out_opm.n39 0.0300385
R6438 bgr_0.out_opm.n39 bgr_0.out_opm.n38 0.0300385
R6439 bgr_0.out_opm.n38 bgr_0.out_opm.n7 0.0300385
R6440 bgr_0.out_opm.n34 bgr_0.out_opm.n7 0.0300385
R6441 bgr_0.out_opm.n34 bgr_0.out_opm.n33 0.0300385
R6442 bgr_0.out_opm.n33 bgr_0.out_opm.n32 0.0300385
R6443 bgr_0.out_opm.n32 bgr_0.out_opm.n12 0.0300385
R6444 bgr_0.out_opm.n27 bgr_0.out_opm.n15 0.0155778
R6445 bgr_0.out_opm.n4 bgr_0.out_opm.n3 0.0155778
R6446 bgr_0.out_opm.n29 bgr_0.out_opm.n28 0.0155778
R6447 bgr_0.out_opm.n21 bgr_0.out_opm.n20 0.0152692
R6448 bgr_0.out_opm.n22 bgr_0.out_opm.n21 0.0152692
R6449 bgr_0.out_opm.n52 bgr_0.opm_bgr_0.bgr_second_stage_0.bgr_second_stage_al_0.Vout_opm 0.00611702
R6450 bgr_0.out_opm.n0 bgr_0.out_opm.t10 0.00249205
R6451 bgr_0.out_opm.n0 bgr_0.out_opm.t8 0.00150783
R6452 VBG_1V.n8 VBG_1V.t0 27.0068
R6453 VBG_1V.n9 VBG_1V.t1 19.9363
R6454 VBG_1V.n13 VBG_1V 12.0547
R6455 VBG_1V.n13 VBG_1V 10.764
R6456 VBG_1V VBG_1V.t10 10.5691
R6457 VBG_1V.n8 VBG_1V 9.7329
R6458 VBG_1V.n12 VBG_1V.t12 7.39842
R6459 VBG_1V.n4 VBG_1V.t3 6.10421
R6460 VBG_1V.n1 VBG_1V.t2 6.1012
R6461 VBG_1V.n12 VBG_1V.t11 6.06797
R6462 VBG_1V.n0 VBG_1V.t4 5.52735
R6463 VBG_1V.n3 VBG_1V.t7 5.5256
R6464 VBG_1V.n2 VBG_1V.t5 5.5256
R6465 VBG_1V.n5 VBG_1V.t6 5.5256
R6466 VBG_1V VBG_1V.n12 4.59507
R6467 VBG_1V VBG_1V.n6 4.4261
R6468 VBG_1V.n4 VBG_1V.n3 3.32046
R6469 VBG_1V.n5 VBG_1V.n4 3.32011
R6470 VBG_1V.n2 VBG_1V.n1 3.24089
R6471 VBG_1V.n1 VBG_1V.n0 3.23828
R6472 VBG_1V.n9 VBG_1V.n8 2.68001
R6473 VBG_1V.n11 VBG_1V.n10 2.16558
R6474 VBG_1V VBG_1V.n7 2.01685
R6475 VBG_1V.n7 VBG_1V.t9 1.85978
R6476 VBG_1V.n7 VBG_1V.t8 1.84253
R6477 VBG_1V VBG_1V.n13 1.76837
R6478 VBG_1V.n3 VBG_1V.n2 1.39576
R6479 VBG_1V.n6 VBG_1V.n5 0.63685
R6480 VBG_1V.n6 VBG_1V.n0 0.580976
R6481 VBG_1V VBG_1V.n11 0.526388
R6482 VBG_1V VBG_1V.n9 0.341724
R6483 VBG_1V.n11 VBG_1V 0.0577
R6484 VBG_1V.n10 VBG_1V 0.0335
R6485 VBG_1V.n10 VBG_1V 0.00947959
R6486 a_4693_228.t0 a_4693_228.t1 30.1559
R6487 a_5127_228.t0 a_5127_228.t1 30.1583
R6488 ldo_1v2_a_0.first_stage_0/diff_pairs_0.dmr.n1 ldo_1v2_a_0.first_stage_0/diff_pairs_0.dmr.t1 42.9178
R6489 ldo_1v2_a_0.first_stage_0/diff_pairs_0.dmr.n2 ldo_1v2_a_0.first_stage_0/diff_pairs_0.dmr 16.323
R6490 ldo_1v2_a_0.first_stage_0/diff_pairs_0.dmr.n0 ldo_1v2_a_0.first_stage_0/diff_pairs_0.dmr.t4 10.9656
R6491 ldo_1v2_a_0.first_stage_0/diff_pairs_0.dmr.n2 ldo_1v2_a_0.first_stage_0/diff_pairs_0.dmr.n0 8.89206
R6492 ldo_1v2_a_0.first_stage_0/diff_pairs_0.dmr.n3 ldo_1v2_a_0.first_stage_0/diff_pairs_0.dmr.t2 7.84467
R6493 ldo_1v2_a_0.first_stage_0/diff_pairs_0.dmr.n3 ldo_1v2_a_0.first_stage_0/diff_pairs_0.dmr.t0 4.58834
R6494 ldo_1v2_a_0.first_stage_0/diff_pairs_0.dmr ldo_1v2_a_0.first_stage_0/diff_pairs_0.dmr.n3 2.99419
R6495 ldo_1v2_a_0.first_stage_0/diff_pairs_0.dmr ldo_1v2_a_0.first_stage_0/diff_pairs_0.dmr.n1 1.4221
R6496 ldo_1v2_a_0.first_stage_0/diff_pairs_0.dmr.n0 ldo_1v2_a_0.first_stage_0/diff_pairs_0.dmr.t3 0.998067
R6497 ldo_1v2_a_0.first_stage_0/diff_pairs_0.dmr.n1 ldo_1v2_a_0.first_stage_0/diff_pairs_0.dmr.t5 0.599616
R6498 ldo_1v2_a_0.first_stage_0/diff_pairs_0.dmr ldo_1v2_a_0.first_stage_0/diff_pairs_0.dmr.n2 0.442192
R6499 VDD_1v2.n13 VDD_1v2.t0 24.8441
R6500 VDD_1v2.n7 VDD_1v2.n6 13.1395
R6501 VDD_1v2.n3 VDD_1v2.n2 13.1354
R6502 VDD_1v2.n11 VDD_1v2.n10 13.1354
R6503 VDD_1v2.n15 VDD_1v2 10.5819
R6504 VDD_1v2.n13 VDD_1v2.n12 9.48281
R6505 VDD_1v2.n10 VDD_1v2.n9 3.97235
R6506 VDD_1v2.n2 VDD_1v2.n1 3.97218
R6507 VDD_1v2.n4 VDD_1v2.n3 3.95309
R6508 VDD_1v2.n12 VDD_1v2.n11 3.47904
R6509 VDD_1v2.n14 VDD_1v2.n13 2.72132
R6510 VDD_1v2.n9 VDD_1v2.t3 2.19855
R6511 VDD_1v2.n1 VDD_1v2.t2 2.19855
R6512 VDD_1v2.n8 VDD_1v2.n7 2.18662
R6513 VDD_1v2.n4 VDD_1v2.t1 2.17868
R6514 VDD_1v2.n0 VDD_1v2.t8 2.17868
R6515 VDD_1v2.n6 VDD_1v2.n5 2.16646
R6516 VDD_1v2.n8 VDD_1v2.n1 1.78638
R6517 VDD_1v2.n9 VDD_1v2.n8 1.78638
R6518 VDD_1v2.n5 VDD_1v2.n4 1.78638
R6519 VDD_1v2.n5 VDD_1v2.n0 1.78638
R6520 VDD_1v2.n15 VDD_1v2.n14 1.20581
R6521 VDD_1v2.n14 VDD_1v2.t11 0.605406
R6522 VDD_1v2.n12 VDD_1v2.n0 0.438805
R6523 VDD_1v2 VDD_1v2.n15 0.02734
R6524 VDD_1v2.n7 VDD_1v2.t4 0.0129854
R6525 VDD_1v2.n11 VDD_1v2.t6 0.0129728
R6526 VDD_1v2.n3 VDD_1v2.t10 0.0129728
R6527 VDD_1v2.n10 VDD_1v2.t9 0.0127484
R6528 VDD_1v2.n2 VDD_1v2.t5 0.012748
R6529 VDD_1v2.n6 VDD_1v2.t7 0.012727
R6530 bgr_0.vp.n5 bgr_0.vp.n4 38.6982
R6531 bgr_0.vp.n0 bgr_0.vp.t1 26.174
R6532 bgr_0.vp.n3 bgr_0.vp.t5 25.1036
R6533 bgr_0.vp.n0 bgr_0.vp.t0 24.8309
R6534 bgr_0.vp.n3 bgr_0.vp.t4 24.5334
R6535 bgr_0.vp.n7 bgr_0.vp.n2 13.1218
R6536 bgr_0.vp.n5 bgr_0.vp.t6 6.06797
R6537 bgr_0.vp.n2 bgr_0.vp.n1 5.41913
R6538 bgr_0.vp.n1 bgr_0.vp.t3 5.05706
R6539 bgr_0.bgr_resistors_2_0.Vp bgr_0.vp.n7 4.87354
R6540 bgr_0.vp.n7 bgr_0.vp.n6 4.42695
R6541 bgr_0.bgr_ctat_ref_0.vp_vbg bgr_0.vp.n5 4.1101
R6542 bgr_0.opm_bgr_0.bgr_first_stage_0/bgr_diff_0.vp_VBG bgr_0.vp.n3 2.20707
R6543 bgr_0.vp.n4 bgr_0.opm_bgr_0.bgr_first_stage_0/bgr_diff_0.vp_VBG 2.10412
R6544 bgr_0.bgr_resistors_2_0.Vp bgr_0.vp.n0 1.85727
R6545 bgr_0.vp.n1 bgr_0.vp.t2 1.80938
R6546 bgr_0.vp.n4 bgr_0.opm_bgr_0.vp_vbg1v 0.7485
R6547 bgr_0.vp.n6 bgr_0.bgr_ctat_ref_0.vp_vbg 0.0907
R6548 bgr_0.vp.n2 bgr_0.bgr_ctat_mirror_0.Vmir 0.0511
R6549 bgr_0.vp.n2 bgr_0.bgr_ctat_mirror_0.Vmir 0.0414302
R6550 bgr_0.vp.n6 bgr_0.bgr_ctat_ref_0.vp_vbg 0.0300738
R6551 a_12893_15554.t0 a_12893_15554.t1 30.3122
R6552 a_13360_15724.t0 a_13360_15724.t1 30.3122
R6553 a_12893_11222.t0 a_12893_11222.t1 30.3122
R6554 a_13360_11052.t0 a_13360_11052.t1 30.3122
R6555 a_12834_14386.t0 a_12834_14386.t1 30.3122
R6556 bgr_0.opm_bgr_0.bgr_first_stage_0/bgr_diff_0.ref.n0 bgr_0.opm_bgr_0.bgr_first_stage_0/bgr_diff_0.ref.t3 14.8927
R6557 bgr_0.opm_bgr_0.bgr_first_stage_0/bgr_diff_0.ref.n1 bgr_0.opm_bgr_0.bgr_first_stage_0/bgr_diff_0.ref.t2 6.32784
R6558 bgr_0.opm_bgr_0.bgr_first_stage_0/bgr_diff_0.ref bgr_0.opm_bgr_0.bgr_first_stage_0/bgr_diff_0.ref.n0 6.07986
R6559 bgr_0.opm_bgr_0.bgr_first_stage_0/bgr_diff_0.ref bgr_0.opm_bgr_0.bgr_first_stage_0/bgr_diff_0.ref.n2 5.71627
R6560 bgr_0.opm_bgr_0.bgr_first_stage_0/bgr_diff_0.ref.n2 bgr_0.opm_bgr_0.bgr_first_stage_0/bgr_diff_0.ref.n1 4.37921
R6561 bgr_0.opm_bgr_0.bgr_first_stage_0/bgr_diff_0.ref.n2 bgr_0.opm_bgr_0.bgr_first_stage_0/bgr_diff_0.ref.t1 2.37346
R6562 bgr_0.opm_bgr_0.bgr_first_stage_0/bgr_diff_0.ref.n0 bgr_0.opm_bgr_0.bgr_first_stage_0/bgr_diff_0.ref.t4 1.23995
R6563 bgr_0.opm_bgr_0.bgr_first_stage_0/bgr_diff_0.ref.n1 bgr_0.opm_bgr_0.bgr_first_stage_0/bgr_diff_0.ref.t0 0.785814
R6564 bgr_0.opm_bgr_0.bgr_second_stage_0.bgr_second_stage_cs_0.Vos1.n28 bgr_0.opm_bgr_0.bgr_second_stage_0.bgr_second_stage_cs_0.Vos1.t0 24.7623
R6565 bgr_0.opm_bgr_0.bgr_second_stage_0.bgr_second_stage_cs_0.Vos1 bgr_0.opm_bgr_0.bgr_second_stage_0.bgr_second_stage_cs_0.Vos1.t5 12.408
R6566 bgr_0.opm_bgr_0.bgr_second_stage_0.bgr_second_stage_cs_0.Vos1.n0 bgr_0.opm_bgr_0.bgr_second_stage_0.bgr_second_stage_cs_0.Vos1.t3 7.07488
R6567 bgr_0.opm_bgr_0.bgr_second_stage_0.bgr_second_stage_cs_0.Vos1.n1 bgr_0.opm_bgr_0.bgr_second_stage_0.bgr_second_stage_cs_0.Vos1.t2 7.05386
R6568 bgr_0.opm_bgr_0.bgr_second_stage_0.bgr_second_stage_cs_0.Vos1 bgr_0.opm_bgr_0.bgr_second_stage_0.bgr_second_stage_cs_0.Vos1.n28 6.12926
R6569 bgr_0.opm_bgr_0.bgr_second_stage_0.bgr_second_stage_cs_0.Vos1.n1 bgr_0.opm_bgr_0.bgr_second_stage_0.bgr_second_stage_cs_0.Vos1.n0 5.29096
R6570 bgr_0.opm_bgr_0.bgr_second_stage_0.bgr_second_stage_cs_0.Vos1 bgr_0.opm_bgr_0.bgr_second_stage_0.bgr_second_stage_cs_0.Vos1.n27 2.0795
R6571 bgr_0.opm_bgr_0.bgr_second_stage_0.bgr_second_stage_cs_0.Vos1.n0 bgr_0.opm_bgr_0.bgr_second_stage_0.bgr_second_stage_cs_0.Vos1 1.51897
R6572 bgr_0.opm_bgr_0.bgr_second_stage_0.bgr_second_stage_cs_0.Vos1.n18 bgr_0.opm_bgr_0.bgr_second_stage_0.bgr_second_stage_cs_0.Vos1.n17 1.5104
R6573 bgr_0.opm_bgr_0.bgr_second_stage_0.bgr_second_stage_cs_0.Vos1.n17 bgr_0.opm_bgr_0.bgr_second_stage_0.bgr_second_stage_cs_0.Vos1.n16 1.51033
R6574 bgr_0.opm_bgr_0.bgr_second_stage_0.bgr_second_stage_cs_0.Vos1.n15 bgr_0.opm_bgr_0.bgr_second_stage_0.bgr_second_stage_cs_0.Vos1.n8 1.5005
R6575 bgr_0.opm_bgr_0.bgr_second_stage_0.bgr_second_stage_cs_0.Vos1.n14 bgr_0.opm_bgr_0.bgr_second_stage_0.bgr_second_stage_cs_0.Vos1.n7 1.5005
R6576 bgr_0.opm_bgr_0.bgr_second_stage_0.bgr_second_stage_cs_0.Vos1.n13 bgr_0.opm_bgr_0.bgr_second_stage_0.bgr_second_stage_cs_0.Vos1.n12 1.5005
R6577 bgr_0.opm_bgr_0.bgr_second_stage_0.bgr_second_stage_cs_0.Vos1.n11 bgr_0.opm_bgr_0.bgr_second_stage_0.bgr_second_stage_cs_0.Vos1.n10 1.5005
R6578 bgr_0.opm_bgr_0.bgr_second_stage_0.bgr_second_stage_cs_0.Vos1.n20 bgr_0.opm_bgr_0.bgr_second_stage_0.bgr_second_stage_cs_0.Vos1.n9 1.5005
R6579 bgr_0.opm_bgr_0.bgr_second_stage_0.bgr_second_stage_cs_0.Vos1.n21 bgr_0.opm_bgr_0.bgr_second_stage_0.bgr_second_stage_cs_0.Vos1.n8 1.5005
R6580 bgr_0.opm_bgr_0.bgr_second_stage_0.bgr_second_stage_cs_0.Vos1.n22 bgr_0.opm_bgr_0.bgr_second_stage_0.bgr_second_stage_cs_0.Vos1.n7 1.5005
R6581 bgr_0.opm_bgr_0.bgr_second_stage_0.bgr_second_stage_cs_0.Vos1.n12 bgr_0.opm_bgr_0.bgr_second_stage_0.bgr_second_stage_cs_0.Vos1.n6 1.5005
R6582 bgr_0.opm_bgr_0.bgr_second_stage_0.bgr_second_stage_cs_0.Vos1.n11 bgr_0.opm_bgr_0.bgr_second_stage_0.bgr_second_stage_cs_0.Vos1.n2 1.5005
R6583 bgr_0.opm_bgr_0.bgr_second_stage_0.bgr_second_stage_cs_0.Vos1.n5 bgr_0.opm_bgr_0.bgr_second_stage_0.bgr_second_stage_cs_0.Vos1.n4 1.5005
R6584 bgr_0.opm_bgr_0.bgr_second_stage_0.bgr_second_stage_cs_0.Vos1.n24 bgr_0.opm_bgr_0.bgr_second_stage_0.bgr_second_stage_cs_0.Vos1.n23 1.5005
R6585 bgr_0.opm_bgr_0.bgr_second_stage_0.bgr_second_stage_cs_0.Vos1.n20 bgr_0.opm_bgr_0.bgr_second_stage_0.bgr_second_stage_cs_0.Vos1.n19 1.5005
R6586 bgr_0.opm_bgr_0.bgr_second_stage_0.bgr_second_stage_cs_0.Vos1.n21 bgr_0.opm_bgr_0.bgr_second_stage_0.bgr_second_stage_cs_0.Vos1.n5 1.5005
R6587 bgr_0.opm_bgr_0.bgr_second_stage_0.bgr_second_stage_cs_0.Vos1.n23 bgr_0.opm_bgr_0.bgr_second_stage_0.bgr_second_stage_cs_0.Vos1.n22 1.5005
R6588 bgr_0.opm_bgr_0.bgr_second_stage_0.bgr_second_stage_cs_0.Vos1.n6 bgr_0.opm_bgr_0.bgr_second_stage_0.bgr_second_stage_cs_0.Vos1.n3 1.5005
R6589 bgr_0.opm_bgr_0.bgr_second_stage_0.bgr_second_stage_cs_0.Vos1.n26 bgr_0.opm_bgr_0.bgr_second_stage_0.bgr_second_stage_cs_0.Vos1.n2 1.5005
R6590 bgr_0.opm_bgr_0.bgr_second_stage_0.bgr_second_stage_cs_0.Vos1.n28 bgr_0.opm_bgr_0.bgr_second_stage_0.bgr_second_stage_cs_0.Vos1.t1 1.18115
R6591 bgr_0.opm_bgr_0.bgr_second_stage_0.bgr_second_stage_cs_0.Vos1 bgr_0.opm_bgr_0.bgr_second_stage_0.bgr_second_stage_cs_0.Vos1.n1 0.993838
R6592 bgr_0.opm_bgr_0.bgr_second_stage_0.bgr_second_stage_cs_0.Vos1.n25 bgr_0.opm_bgr_0.bgr_second_stage_0.bgr_second_stage_cs_0.Vos1.n24 0.775494
R6593 bgr_0.opm_bgr_0.bgr_second_stage_0.bgr_second_stage_cs_0.Vos1.n18 bgr_0.opm_bgr_0.bgr_second_stage_0.bgr_second_stage_cs_0.Vos1.n4 0.775494
R6594 bgr_0.opm_bgr_0.bgr_second_stage_0.bgr_second_stage_cs_0.Vos1.n16 bgr_0.opm_bgr_0.bgr_second_stage_0.bgr_second_stage_cs_0.Vos1.n15 0.747617
R6595 bgr_0.opm_bgr_0.bgr_second_stage_0.bgr_second_stage_cs_0.Vos1.n27 bgr_0.opm_bgr_0.bgr_second_stage_0.bgr_second_stage_cs_0.Vos1.n26 0.333971
R6596 bgr_0.opm_bgr_0.bgr_second_stage_0.bgr_second_stage_cs_0.Vos1.n27 bgr_0.opm_bgr_0.bgr_second_stage_0.bgr_second_stage_cs_0.Vos1 0.0731
R6597 bgr_0.opm_bgr_0.bgr_second_stage_0.bgr_second_stage_cs_0.Vos1.n10 bgr_0.opm_bgr_0.bgr_second_stage_0.bgr_second_stage_cs_0.Vos1.t4 0.0306699
R6598 bgr_0.opm_bgr_0.bgr_second_stage_0.bgr_second_stage_cs_0.Vos1.n24 bgr_0.opm_bgr_0.bgr_second_stage_0.bgr_second_stage_cs_0.Vos1.n4 0.0238628
R6599 bgr_0.opm_bgr_0.bgr_second_stage_0.bgr_second_stage_cs_0.Vos1.n12 bgr_0.opm_bgr_0.bgr_second_stage_0.bgr_second_stage_cs_0.Vos1.n11 0.0192733
R6600 bgr_0.opm_bgr_0.bgr_second_stage_0.bgr_second_stage_cs_0.Vos1.n12 bgr_0.opm_bgr_0.bgr_second_stage_0.bgr_second_stage_cs_0.Vos1.n7 0.0192733
R6601 bgr_0.opm_bgr_0.bgr_second_stage_0.bgr_second_stage_cs_0.Vos1.n8 bgr_0.opm_bgr_0.bgr_second_stage_0.bgr_second_stage_cs_0.Vos1.n7 0.0192733
R6602 bgr_0.opm_bgr_0.bgr_second_stage_0.bgr_second_stage_cs_0.Vos1.n9 bgr_0.opm_bgr_0.bgr_second_stage_0.bgr_second_stage_cs_0.Vos1.n8 0.0192733
R6603 bgr_0.opm_bgr_0.bgr_second_stage_0.bgr_second_stage_cs_0.Vos1.n6 bgr_0.opm_bgr_0.bgr_second_stage_0.bgr_second_stage_cs_0.Vos1.n2 0.0192733
R6604 bgr_0.opm_bgr_0.bgr_second_stage_0.bgr_second_stage_cs_0.Vos1.n22 bgr_0.opm_bgr_0.bgr_second_stage_0.bgr_second_stage_cs_0.Vos1.n6 0.0192733
R6605 bgr_0.opm_bgr_0.bgr_second_stage_0.bgr_second_stage_cs_0.Vos1.n22 bgr_0.opm_bgr_0.bgr_second_stage_0.bgr_second_stage_cs_0.Vos1.n21 0.0192733
R6606 bgr_0.opm_bgr_0.bgr_second_stage_0.bgr_second_stage_cs_0.Vos1.n21 bgr_0.opm_bgr_0.bgr_second_stage_0.bgr_second_stage_cs_0.Vos1.n20 0.0192733
R6607 bgr_0.opm_bgr_0.bgr_second_stage_0.bgr_second_stage_cs_0.Vos1.n20 bgr_0.opm_bgr_0.bgr_second_stage_0.bgr_second_stage_cs_0.Vos1.n17 0.0192733
R6608 bgr_0.opm_bgr_0.bgr_second_stage_0.bgr_second_stage_cs_0.Vos1.n23 bgr_0.opm_bgr_0.bgr_second_stage_0.bgr_second_stage_cs_0.Vos1.n3 0.0192733
R6609 bgr_0.opm_bgr_0.bgr_second_stage_0.bgr_second_stage_cs_0.Vos1.n23 bgr_0.opm_bgr_0.bgr_second_stage_0.bgr_second_stage_cs_0.Vos1.n5 0.0192733
R6610 bgr_0.opm_bgr_0.bgr_second_stage_0.bgr_second_stage_cs_0.Vos1.n19 bgr_0.opm_bgr_0.bgr_second_stage_0.bgr_second_stage_cs_0.Vos1.n5 0.0192733
R6611 bgr_0.opm_bgr_0.bgr_second_stage_0.bgr_second_stage_cs_0.Vos1.n26 bgr_0.opm_bgr_0.bgr_second_stage_0.bgr_second_stage_cs_0.Vos1.n25 0.0104008
R6612 bgr_0.opm_bgr_0.bgr_second_stage_0.bgr_second_stage_cs_0.Vos1.n16 bgr_0.opm_bgr_0.bgr_second_stage_0.bgr_second_stage_cs_0.Vos1.n9 0.0103251
R6613 bgr_0.opm_bgr_0.bgr_second_stage_0.bgr_second_stage_cs_0.Vos1.n19 bgr_0.opm_bgr_0.bgr_second_stage_0.bgr_second_stage_cs_0.Vos1.n18 0.0102566
R6614 bgr_0.opm_bgr_0.bgr_second_stage_0.bgr_second_stage_cs_0.Vos1.n25 bgr_0.opm_bgr_0.bgr_second_stage_0.bgr_second_stage_cs_0.Vos1.n3 0.0102566
R6615 bgr_0.opm_bgr_0.bgr_second_stage_0.bgr_second_stage_cs_0.Vos1.n13 bgr_0.opm_bgr_0.bgr_second_stage_0.bgr_second_stage_cs_0.Vos1.n10 0.00152524
R6616 bgr_0.opm_bgr_0.bgr_second_stage_0.bgr_second_stage_cs_0.Vos1.n14 bgr_0.opm_bgr_0.bgr_second_stage_0.bgr_second_stage_cs_0.Vos1.n13 0.00152524
R6617 bgr_0.opm_bgr_0.bgr_second_stage_0.bgr_second_stage_cs_0.Vos1.n15 bgr_0.opm_bgr_0.bgr_second_stage_0.bgr_second_stage_cs_0.Vos1.n14 0.00152524
R6618 a_13967_13898.t0 a_13967_13898.t1 30.3122
R6619 a_14434_13728.t0 a_14434_13728.t1 30.3122
R6620 a_12834_13558.t0 a_12834_13558.t1 30.3122
R6621 a_13360_13388.t0 a_13360_13388.t1 30.3122
R6622 ldo_1v5_y_0.first_stage$1_0/bias_cur$1_0.i_ref.n1 ldo_1v5_y_0.first_stage$1_0/bias_cur$1_0.i_ref.n0 39.4206
R6623 ldo_1v5_y_0.first_stage$1_0/bias_cur$1_0.i_ref.n0 ldo_1v5_y_0.first_stage$1_0/bias_cur$1_0.i_ref.t3 17.0031
R6624 ldo_1v5_y_0.first_stage$1_0/bias_cur$1_0.i_ref.n1 ldo_1v5_y_0.first_stage$1_0/bias_cur$1_0.i_ref.t1 3.47832
R6625 ldo_1v5_y_0.first_stage$1_0/bias_cur$1_0.i_ref.n0 ldo_1v5_y_0.first_stage$1_0/bias_cur$1_0.i_ref.t2 2.53715
R6626 ldo_1v5_y_0.first_stage$1_0/bias_cur$1_0.i_ref.t0 ldo_1v5_y_0.first_stage$1_0/bias_cur$1_0.i_ref.n1 2.36746
R6627 a_3979_915.t0 a_3979_915.t1 30.3643
R6628 bgr_0.opm_bgr_0.bgr_second_stage_0.bgr_second_stage_al_0.Vbias bgr_0.opm_bgr_0.bgr_second_stage_0.bgr_second_stage_al_0.Vbias.n5 17.0239
R6629 bgr_0.opm_bgr_0.bgr_second_stage_0.bgr_second_stage_al_0.Vbias bgr_0.opm_bgr_0.bgr_second_stage_0.bgr_second_stage_al_0.Vbias.t10 6.52768
R6630 bgr_0.opm_bgr_0.bgr_second_stage_0.bgr_second_stage_al_0.Vbias.n7 bgr_0.opm_bgr_0.bgr_second_stage_0.bgr_second_stage_al_0.Vbias.t2 5.5119
R6631 bgr_0.opm_bgr_0.bgr_second_stage_0.bgr_second_stage_al_0.Vbias bgr_0.opm_bgr_0.bgr_second_stage_0.bgr_second_stage_al_0.Vbias.n8 3.81638
R6632 bgr_0.opm_bgr_0.bgr_second_stage_0.bgr_second_stage_al_0.Vbias.n3 bgr_0.opm_bgr_0.bgr_second_stage_0.bgr_second_stage_al_0.Vbias.t4 3.66454
R6633 bgr_0.opm_bgr_0.bgr_second_stage_0.bgr_second_stage_al_0.Vbias.n0 bgr_0.opm_bgr_0.bgr_second_stage_0.bgr_second_stage_al_0.Vbias.t8 3.19125
R6634 bgr_0.opm_bgr_0.bgr_second_stage_0.bgr_second_stage_al_0.Vbias.n6 bgr_0.opm_bgr_0.bgr_second_stage_0.bgr_second_stage_al_0.Vbias.t1 3.05452
R6635 bgr_0.opm_bgr_0.bgr_second_stage_0.bgr_second_stage_al_0.Vbias.n2 bgr_0.opm_bgr_0.bgr_second_stage_0.bgr_second_stage_al_0.Vbias.t6 2.95979
R6636 bgr_0.opm_bgr_0.bgr_second_stage_0.bgr_second_stage_al_0.Vbias.n5 bgr_0.opm_bgr_0.bgr_second_stage_0.bgr_second_stage_al_0.Vbias 2.8231
R6637 bgr_0.opm_bgr_0.bgr_second_stage_0.bgr_second_stage_al_0.Vbias.n1 bgr_0.opm_bgr_0.bgr_second_stage_0.bgr_second_stage_al_0.Vbias.t5 2.31261
R6638 bgr_0.opm_bgr_0.bgr_second_stage_0.bgr_second_stage_al_0.Vbias.t4 bgr_0.opm_bgr_0.bgr_second_stage_0.bgr_second_stage_al_0.Vbias.n0 1.70322
R6639 bgr_0.opm_bgr_0.bgr_second_stage_0.bgr_second_stage_al_0.Vbias.t4 bgr_0.opm_bgr_0.bgr_second_stage_0.bgr_second_stage_al_0.Vbias.n2 1.5933
R6640 bgr_0.opm_bgr_0.bgr_second_stage_0.bgr_second_stage_al_0.Vbias.n2 bgr_0.opm_bgr_0.bgr_second_stage_0.bgr_second_stage_al_0.Vbias.n1 1.20914
R6641 bgr_0.opm_bgr_0.bgr_second_stage_0.bgr_second_stage_al_0.Vbias.n8 bgr_0.opm_bgr_0.bgr_second_stage_0.bgr_second_stage_al_0.Vbias.n7 1.16207
R6642 bgr_0.opm_bgr_0.bgr_second_stage_0.bgr_second_stage_al_0.Vbias.n5 bgr_0.opm_bgr_0.bgr_second_stage_0.bgr_second_stage_al_0.Vbias.n4 0.9789
R6643 bgr_0.opm_bgr_0.bgr_second_stage_0.bgr_second_stage_al_0.Vbias.n8 bgr_0.opm_bgr_0.bgr_second_stage_0.bgr_second_stage_al_0.Vbias.n6 0.82641
R6644 bgr_0.opm_bgr_0.bgr_second_stage_0.bgr_second_stage_al_0.Vbias.t0 bgr_0.opm_bgr_0.bgr_second_stage_0.bgr_second_stage_al_0.Vbias.n6 0.764678
R6645 bgr_0.opm_bgr_0.bgr_second_stage_0.bgr_second_stage_al_0.Vbias.n4 bgr_0.opm_bgr_0.bgr_second_stage_0.bgr_second_stage_al_0.Vbias.n0 0.472467
R6646 bgr_0.opm_bgr_0.bgr_second_stage_0.bgr_second_stage_al_0.Vbias.n7 bgr_0.opm_bgr_0.bgr_second_stage_0.bgr_second_stage_al_0.Vbias.t0 0.41362
R6647 bgr_0.opm_bgr_0.bgr_second_stage_0.bgr_second_stage_al_0.Vbias.n4 bgr_0.opm_bgr_0.bgr_second_stage_0.bgr_second_stage_al_0.Vbias.n3 0.35116
R6648 bgr_0.opm_bgr_0.bgr_second_stage_0.bgr_second_stage_al_0.Vbias.n3 bgr_0.opm_bgr_0.bgr_second_stage_0.bgr_second_stage_al_0.Vbias.n1 0.250236
R6649 a_12834_12390.t0 a_12834_12390.t1 30.3122
R6650 a_13360_12560.t0 a_13360_12560.t1 30.3122
R6651 a_13967_12050.t0 a_13967_12050.t1 30.3122
R6652 a_3979_572.t0 a_3979_572.t1 30.3622
R6653 a_4257_743.t0 a_4257_743.t1 30.1583
R6654 a_5285_400.t0 a_5285_400.t1 30.3643
R6655 a_5563_228.t0 a_5563_228.t1 30.3643
R6656 bgr_0.inv_out.n0 bgr_0.inv_out.t4 22.4506
R6657 bgr_0.inv_out.t3 bgr_0.inv_out.n3 7.96977
R6658 bgr_0.inv_out.n1 bgr_0.inv_out.t0 6.2991
R6659 bgr_0.inv_out.n3 bgr_0.inv_out.t2 6.07327
R6660 bgr_0.inv_out.n2 bgr_0.inv_out.t1 6.07327
R6661 bgr_0.inv_out.n1 bgr_0.inv_out.n0 4.5005
R6662 bgr_0.inv_out.n0 bgr_0.inv_out.t5 3.0423
R6663 bgr_0.inv_out.n3 bgr_0.inv_out.n2 1.898
R6664 bgr_0.inv_out.n2 bgr_0.inv_out.n1 1.5257
R6665 a_15041_14896.t0 a_15041_14896.t1 30.3122
R6666 a_15508_15066.t0 a_15508_15066.t1 30.3122
R6667 bgr_0.vn.n4 bgr_0.vn.n3 35.7644
R6668 bgr_0.vn.n2 bgr_0.vn.t4 25.4505
R6669 bgr_0.vn.n2 bgr_0.vn.t3 24.3765
R6670 bgr_0.bgr_startup_0.Vstart_out bgr_0.vn.t2 13.5848
R6671 bgr_0.bgr_ctat_ref_0.vn_vbg bgr_0.vn.t0 12.1334
R6672 bgr_0.vn.n1 bgr_0.bgr_ctat_mirror_0.Vref 9.91255
R6673 bgr_0.vn.n0 bgr_0.vn.t1 7.23021
R6674 bgr_0.vn.n4 bgr_0.vn.n1 4.05637
R6675 bgr_0.vn.n3 bgr_0.opm_bgr_0.bgr_first_stage_0/bgr_diff_0.vn_VBG 2.6426
R6676 bgr_0.vn.n1 bgr_0.bgr_startup_0.Vstart_out 2.31699
R6677 bgr_0.bgr_ctat_ref_0.vn_vbg bgr_0.vn.n4 2.2703
R6678 bgr_0.opm_bgr_0.bgr_first_stage_0/bgr_diff_0.vn_VBG bgr_0.vn.n2 1.91764
R6679 bgr_0.vn.n3 bgr_0.opm_bgr_0.vn_vbg1v 0.210024
R6680 bgr_0.vn.n0 bgr_0.bgr_ctat_mirror_0.Vref 0.0489
R6681 bgr_0.bgr_ctat_mirror_0.Vref bgr_0.vn.n0 0.0405
R6682 bgr_0.opm_bgr_0.bgr_first_stage_0/bgr_bias_0.VbD.n11 bgr_0.opm_bgr_0.bgr_first_stage_0/bgr_bias_0.VbD.t1 17.0005
R6683 bgr_0.opm_bgr_0.bgr_first_stage_0/bgr_bias_0.VbD.t1 bgr_0.opm_bgr_0.bgr_first_stage_0/bgr_bias_0.VbD.n10 17.0005
R6684 bgr_0.opm_bgr_0.bgr_first_stage_0/bgr_bias_0.VbD.t2 bgr_0.opm_bgr_0.bgr_first_stage_0/bgr_bias_0.VbD.n2 8.49502
R6685 bgr_0.opm_bgr_0.bgr_first_stage_0/bgr_bias_0.VbD.t2 bgr_0.opm_bgr_0.bgr_first_stage_0/bgr_bias_0.VbD.n6 8.49502
R6686 bgr_0.opm_bgr_0.bgr_first_stage_0/bgr_bias_0.VbD.t2 bgr_0.opm_bgr_0.bgr_first_stage_0/bgr_bias_0.VbD.n7 8.49502
R6687 bgr_0.opm_bgr_0.bgr_first_stage_0/bgr_bias_0.VbD.n8 bgr_0.opm_bgr_0.bgr_first_stage_0/bgr_bias_0.VbD.t2 8.49502
R6688 bgr_0.opm_bgr_0.bgr_first_stage_0/bgr_bias_0.VbD.t1 bgr_0.opm_bgr_0.bgr_first_stage_0/bgr_bias_0.VbD.n3 8.49502
R6689 bgr_0.opm_bgr_0.bgr_first_stage_0/bgr_bias_0.VbD.t1 bgr_0.opm_bgr_0.bgr_first_stage_0/bgr_bias_0.VbD.n4 8.49502
R6690 bgr_0.opm_bgr_0.bgr_first_stage_0/bgr_bias_0.VbD.t1 bgr_0.opm_bgr_0.bgr_first_stage_0/bgr_bias_0.VbD.n5 8.49502
R6691 bgr_0.opm_bgr_0.bgr_first_stage_0/bgr_bias_0.VbD.n0 bgr_0.opm_bgr_0.bgr_first_stage_0/bgr_bias_0.VbD.t4 5.71891
R6692 bgr_0.opm_bgr_0.bgr_first_stage_0/bgr_bias_0.VbD.t2 bgr_0.opm_bgr_0.bgr_first_stage_0/bgr_bias_0.VbD.n1 5.66867
R6693 bgr_0.opm_bgr_0.bgr_first_stage_0/bgr_bias_0.VbD.t1 bgr_0.opm_bgr_0.bgr_first_stage_0/bgr_bias_0.VbD.n1 5.66811
R6694 bgr_0.opm_bgr_0.bgr_first_stage_0/bgr_bias_0.VbD bgr_0.opm_bgr_0.bgr_first_stage_0/bgr_bias_0.VbD.n0 3.01206
R6695 bgr_0.opm_bgr_0.bgr_first_stage_0/bgr_bias_0.VbD bgr_0.opm_bgr_0.bgr_first_stage_0/bgr_bias_0.VbD.n12 2.50493
R6696 bgr_0.opm_bgr_0.bgr_first_stage_0/bgr_bias_0.VbD.n9 bgr_0.opm_bgr_0.bgr_first_stage_0/bgr_bias_0.VbD.t3 1.54848
R6697 bgr_0.opm_bgr_0.bgr_first_stage_0/bgr_bias_0.VbD.n9 bgr_0.opm_bgr_0.bgr_first_stage_0/bgr_bias_0.VbD.t0 1.54837
R6698 bgr_0.opm_bgr_0.bgr_first_stage_0/bgr_bias_0.VbD.n10 bgr_0.opm_bgr_0.bgr_first_stage_0/bgr_bias_0.VbD.n9 0.259493
R6699 bgr_0.opm_bgr_0.bgr_first_stage_0/bgr_bias_0.VbD.n0 bgr_0.opm_bgr_0.bgr_first_stage_0/bgr_bias_0.VbD 0.0511
R6700 bgr_0.opm_bgr_0.bgr_first_stage_0/bgr_bias_0.VbD.n0 bgr_0.opm_bgr_0.bgr_first_stage_0/bgr_bias_0.VbD 0.0357
R6701 bgr_0.opm_bgr_0.bgr_first_stage_0/bgr_bias_0.VbD.n6 bgr_0.opm_bgr_0.bgr_first_stage_0/bgr_bias_0.VbD.n3 0.0254243
R6702 bgr_0.opm_bgr_0.bgr_first_stage_0/bgr_bias_0.VbD.n7 bgr_0.opm_bgr_0.bgr_first_stage_0/bgr_bias_0.VbD.n4 0.0254243
R6703 bgr_0.opm_bgr_0.bgr_first_stage_0/bgr_bias_0.VbD.n8 bgr_0.opm_bgr_0.bgr_first_stage_0/bgr_bias_0.VbD.n5 0.0254243
R6704 bgr_0.opm_bgr_0.bgr_first_stage_0/bgr_bias_0.VbD.n3 bgr_0.opm_bgr_0.bgr_first_stage_0/bgr_bias_0.VbD.n2 0.0254243
R6705 bgr_0.opm_bgr_0.bgr_first_stage_0/bgr_bias_0.VbD.n6 bgr_0.opm_bgr_0.bgr_first_stage_0/bgr_bias_0.VbD.n4 0.0254243
R6706 bgr_0.opm_bgr_0.bgr_first_stage_0/bgr_bias_0.VbD.n7 bgr_0.opm_bgr_0.bgr_first_stage_0/bgr_bias_0.VbD.n5 0.0254243
R6707 bgr_0.opm_bgr_0.bgr_first_stage_0/bgr_bias_0.VbD.n12 bgr_0.opm_bgr_0.bgr_first_stage_0/bgr_bias_0.VbD.n11 0.0225
R6708 bgr_0.opm_bgr_0.bgr_first_stage_0/bgr_bias_0.VbD.n12 bgr_0.opm_bgr_0.bgr_first_stage_0/bgr_bias_0.VbD.n1 0.0170926
R6709 bgr_0.opm_bgr_0.bgr_first_stage_0/bgr_bias_0.VbD.n11 bgr_0.opm_bgr_0.bgr_first_stage_0/bgr_bias_0.VbD.n2 0.0129622
R6710 bgr_0.opm_bgr_0.bgr_first_stage_0/bgr_bias_0.VbD.n10 bgr_0.opm_bgr_0.bgr_first_stage_0/bgr_bias_0.VbD.n8 0.0129622
R6711 a_4693_915.t0 a_4693_915.t1 30.1559
R6712 a_5127_400.t0 a_5127_400.t1 48.8813
R6713 a_14982_13218.t0 a_14982_13218.t1 30.3122
R6714 a_15508_13388.t0 a_15508_13388.t1 30.3122
R6715 a_4693_743.t0 a_4693_743.t1 30.1559
R6716 a_5127_572.t0 a_5127_572.t1 30.3622
R6717 a_4257_1087.t0 a_4257_1087.t1 30.1583
R6718 a_4693_1087.t0 a_4693_1087.t1 30.1559
R6719 a_12893_11562.t0 a_12893_11562.t1 30.3122
R6720 a_13360_11732.n0 a_13360_11732.t2 23.8534
R6721 a_13360_11732.t0 a_13360_11732.n0 22.3269
R6722 a_13360_11732.n0 a_13360_11732.t1 19.8284
R6723 a_12834_14726.t0 a_12834_14726.t1 30.3122
R6724 a_13360_14896.t0 a_13360_14896.t1 30.3122
R6725 a_13967_14386.t0 a_13967_14386.t1 30.3122
R6726 a_13360_13218.n0 a_13360_13218.t3 17.7652
R6727 a_13360_13218.n2 a_13360_13218.t2 15.5075
R6728 a_13360_13218.n1 a_13360_13218.t1 15.4863
R6729 a_13360_13218.t0 a_13360_13218.n2 15.1882
R6730 a_13360_13218.n0 a_13360_13218.t4 15.0005
R6731 a_13360_13218.n2 a_13360_13218.n1 11.8119
R6732 a_13360_13218.n1 a_13360_13218.n0 0.180396
R6733 a_13967_13558.t0 a_13967_13558.t1 30.3122
R6734 a_14434_13388.t0 a_14434_13388.t1 30.3122
R6735 a_3979_228.t0 a_3979_228.t1 30.3643
R6736 a_4257_400.t0 a_4257_400.t1 30.3643
R6737 a_15041_14556.t0 a_15041_14556.t1 30.3122
R6738 a_15508_14726.t0 a_15508_14726.t1 30.3122
R6739 a_12834_13218.t0 a_12834_13218.t1 30.3122
R6740 a_13967_12390.t0 a_13967_12390.t1 30.3122
R6741 a_14434_12560.t0 a_14434_12560.t1 30.3122
R6742 a_12893_16234.t0 a_12893_16234.t1 30.3122
R6743 a_13360_16064.t0 a_13360_16064.t1 30.3122
R6744 a_12834_12050.t0 a_12834_12050.t1 30.3122
R6745 a_13360_12220.t0 a_13360_12220.t1 30.3122
R6746 a_15508_12730.t0 a_15508_12730.t1 30.3122
R6747 ldo_1v2_a_0.first_stage_0/bias_cur_0.i_ref.n1 ldo_1v2_a_0.first_stage_0/bias_cur_0.i_ref.n0 39.4206
R6748 ldo_1v2_a_0.first_stage_0/bias_cur_0.i_ref.n0 ldo_1v2_a_0.first_stage_0/bias_cur_0.i_ref.t3 17.0031
R6749 ldo_1v2_a_0.first_stage_0/bias_cur_0.i_ref.n1 ldo_1v2_a_0.first_stage_0/bias_cur_0.i_ref.t1 3.47832
R6750 ldo_1v2_a_0.first_stage_0/bias_cur_0.i_ref.n0 ldo_1v2_a_0.first_stage_0/bias_cur_0.i_ref.t2 2.53715
R6751 ldo_1v2_a_0.first_stage_0/bias_cur_0.i_ref.t0 ldo_1v2_a_0.first_stage_0/bias_cur_0.i_ref.n1 2.36746
R6752 a_4257_228.t0 a_4257_228.t1 30.1583
R6753 a_5127_1087.t0 a_5127_1087.t1 30.1583
R6754 a_12834_13898.t0 a_12834_13898.t1 30.3122
R6755 ldo_1v2_a_0.first_stage_0/diff_pairs_0.dmv.n2 ldo_1v2_a_0.first_stage_0/diff_pairs_0.dmv.t4 9.66562
R6756 ldo_1v2_a_0.first_stage_0/diff_pairs_0.dmv.n1 ldo_1v2_a_0.first_stage_0/diff_pairs_0.dmv.n0 6.49971
R6757 ldo_1v2_a_0.first_stage_0/diff_pairs_0.dmv.n0 ldo_1v2_a_0.first_stage_0/diff_pairs_0.dmv.t1 5.82875
R6758 ldo_1v2_a_0.first_stage_0/diff_pairs_0.dmv.n0 ldo_1v2_a_0.first_stage_0/diff_pairs_0.dmv.t2 5.81272
R6759 ldo_1v2_a_0.first_stage_0/diff_pairs_0.dmv ldo_1v2_a_0.first_stage_0/diff_pairs_0.dmv.n1 4.57318
R6760 ldo_1v2_a_0.first_stage_0/diff_pairs_0.dmv.n2 ldo_1v2_a_0.first_stage_0/diff_pairs_0.dmv.t0 4.11384
R6761 ldo_1v2_a_0.first_stage_0/diff_pairs_0.dmv ldo_1v2_a_0.first_stage_0/diff_pairs_0.dmv.n2 2.6405
R6762 ldo_1v2_a_0.first_stage_0/diff_pairs_0.dmv.n1 ldo_1v2_a_0.first_stage_0/diff_pairs_0.dmv.t3 0.828547
R6763 a_13717_1480.t0 a_13717_1480.t1 30.3643
R6764 a_13717_1344.t0 a_13717_1344.t1 33.2489
R6765 a_4693_400.t0 a_4693_400.t1 30.1559
R6766 a_14982_13898.t0 a_14982_13898.t1 30.3122
R6767 a_15508_13728.t0 a_15508_13728.t1 30.3122
R6768 a_13717_2404.t0 a_13717_2404.t1 30.3643
R6769 a_13717_2096.t0 a_13717_2096.t1 30.3643
R6770 a_13967_14726.t0 a_13967_14726.t1 30.3122
R6771 a_14434_14896.t0 a_14434_14896.t1 30.3122
R6772 a_15041_12220.t0 a_15041_12220.t1 30.3122
R6773 a_15508_12390.t0 a_15508_12390.t1 30.3122
R6774 a_13360_14556.t0 a_13360_14556.t1 30.3122
R6775 a_13360_13728.t0 a_13360_13728.t1 30.3122
R6776 a_13967_13218.t0 a_13967_13218.t1 30.3122
R6777 a_14434_12220.t0 a_14434_12220.t1 30.3122
R6778 a_13717_1788.t0 a_13717_1788.t1 30.3643
R6779 a_12834_12730.t0 a_12834_12730.t1 30.3122
R6780 a_12893_10882.t0 a_12893_10882.t1 30.3122
R6781 a_13215_2712.t0 a_13215_2712.t1 31.8684
R6782 a_12713_1480.t0 a_12713_1480.t1 30.3643
R6783 a_12713_1344.t0 a_12713_1344.t1 51.5682
R6784 a_12713_2404.t0 a_12713_2404.t1 30.3643
R6785 a_12713_2096.t0 a_12713_2096.t1 30.3643
R6786 a_14721_1480.t0 a_14721_1480.t1 30.3643
R6787 a_6428_228.t0 a_6428_228.t1 30.3728
R6788 a_14721_2404.t0 a_14721_2404.t1 30.3643
R6789 a_14721_2096.t0 a_14721_2096.t1 30.3643
R6790 a_14982_13558.t0 a_14982_13558.t1 30.3122
R6791 a_5563_915.t0 a_5563_915.t1 30.3643
R6792 a_15852_1685.t0 a_15852_1685.n20 16.791
R6793 a_15852_1685.n12 a_15852_1685.t1 2.27014
R6794 a_15852_1685.n7 a_15852_1685.n6 1.52027
R6795 a_15852_1685.n15 a_15852_1685.n14 1.52027
R6796 a_15852_1685.n13 a_15852_1685.n4 1.5005
R6797 a_15852_1685.n12 a_15852_1685.n3 1.5005
R6798 a_15852_1685.n11 a_15852_1685.n10 1.5005
R6799 a_15852_1685.n16 a_15852_1685.n5 1.5005
R6800 a_15852_1685.n17 a_15852_1685.n4 1.5005
R6801 a_15852_1685.n18 a_15852_1685.n3 1.5005
R6802 a_15852_1685.n10 a_15852_1685.n2 1.5005
R6803 a_15852_1685.n9 a_15852_1685.n8 1.5005
R6804 a_15852_1685.n17 a_15852_1685.n1 1.5005
R6805 a_15852_1685.n19 a_15852_1685.n18 1.5005
R6806 a_15852_1685.n2 a_15852_1685.n0 1.5005
R6807 a_15852_1685.n7 a_15852_1685.n0 0.769773
R6808 a_15852_1685.n15 a_15852_1685.n1 0.769773
R6809 a_15852_1685.n11 a_15852_1685.n6 0.769773
R6810 a_15852_1685.n14 a_15852_1685.n13 0.769773
R6811 a_15852_1685.n12 a_15852_1685.n11 0.0192733
R6812 a_15852_1685.n13 a_15852_1685.n12 0.0192733
R6813 a_15852_1685.n10 a_15852_1685.n9 0.0192733
R6814 a_15852_1685.n10 a_15852_1685.n3 0.0192733
R6815 a_15852_1685.n4 a_15852_1685.n3 0.0192733
R6816 a_15852_1685.n5 a_15852_1685.n4 0.0192733
R6817 a_15852_1685.n8 a_15852_1685.n2 0.0192733
R6818 a_15852_1685.n18 a_15852_1685.n2 0.0192733
R6819 a_15852_1685.n18 a_15852_1685.n17 0.0192733
R6820 a_15852_1685.n17 a_15852_1685.n16 0.0192733
R6821 a_15852_1685.n19 a_15852_1685.n1 0.0192733
R6822 a_15852_1685.n20 a_15852_1685.n19 0.0188822
R6823 a_15852_1685.n8 a_15852_1685.n7 0.0102706
R6824 a_15852_1685.n16 a_15852_1685.n15 0.0102706
R6825 a_15852_1685.n14 a_15852_1685.n5 0.0102706
R6826 a_15852_1685.n9 a_15852_1685.n6 0.0102706
R6827 a_15852_1685.n20 a_15852_1685.n0 0.000891111
R6828 ldo_1v5_y_0.first_stage$1_0/diff_pairs$1_0.dmv.n3 ldo_1v5_y_0.first_stage$1_0/diff_pairs$1_0.dmv.t3 9.66562
R6829 ldo_1v5_y_0.first_stage$1_0/diff_pairs$1_0.dmv.n2 ldo_1v5_y_0.first_stage$1_0/diff_pairs$1_0.dmv.t2 8.59029
R6830 ldo_1v5_y_0.first_stage$1_0/diff_pairs$1_0.dmv.n1 ldo_1v5_y_0.first_stage$1_0/diff_pairs$1_0.dmv.n0 6.38123
R6831 ldo_1v5_y_0.first_stage$1_0/diff_pairs$1_0.dmv.n0 ldo_1v5_y_0.first_stage$1_0/diff_pairs$1_0.dmv.t0 5.82875
R6832 ldo_1v5_y_0.first_stage$1_0/diff_pairs$1_0.dmv.n0 ldo_1v5_y_0.first_stage$1_0/diff_pairs$1_0.dmv.t1 5.81272
R6833 ldo_1v5_y_0.first_stage$1_0/diff_pairs$1_0.dmv.n3 ldo_1v5_y_0.first_stage$1_0/diff_pairs$1_0.dmv.t4 4.10808
R6834 ldo_1v5_y_0.first_stage$1_0/diff_pairs$1_0.dmv ldo_1v5_y_0.first_stage$1_0/diff_pairs$1_0.dmv.n2 3.5923
R6835 ldo_1v5_y_0.first_stage$1_0/diff_pairs$1_0.dmv ldo_1v5_y_0.first_stage$1_0/diff_pairs$1_0.dmv.n3 2.6405
R6836 ldo_1v5_y_0.first_stage$1_0/diff_pairs$1_0.dmv.n2 ldo_1v5_y_0.first_stage$1_0/diff_pairs$1_0.dmv.n1 1.24121
R6837 ldo_1v5_y_0.first_stage$1_0/diff_pairs$1_0.dmv.t2 ldo_1v5_y_0.first_stage$1_0/diff_pairs$1_0.dmv.n1 1.04957
R6838 a_15508_12050.t0 a_15508_12050.t1 30.3122
R6839 a_12713_1788.t0 a_12713_1788.t1 30.3643
R6840 a_14434_14556.t0 a_14434_14556.t1 30.3122
R6841 a_4693_572.t0 a_4693_572.t1 30.1559
R6842 a_14721_1788.t0 a_14721_1788.t1 30.3643
R6843 a_13967_12730.t0 a_13967_12730.t1 30.3122
R6844 ldo_1v2_a_0.first_stage_0/diff_pairs_0.vn1v2.n0 ldo_1v2_a_0.first_stage_0/diff_pairs_0.vn1v2.t0 15.1951
R6845 ldo_1v2_a_0.first_stage_0/diff_pairs_0.vn1v2.n0 ldo_1v2_a_0.first_stage_0/diff_pairs_0.vn1v2.t1 15.1697
R6846 ldo_1v2_a_0.first_stage_0/diff_pairs_0.vn1v2 ldo_1v2_a_0.first_stage_0/diff_pairs_0.vn1v2.t2 10.6098
R6847 ldo_1v2_a_0.first_stage_0/diff_pairs_0.vn1v2 ldo_1v2_a_0.first_stage_0/diff_pairs_0.vn1v2.n0 4.82336
R6848 ldo_1v2_a_0.first_stage_0/bias_cur_0.d_t ldo_1v2_a_0.first_stage_0/bias_cur_0.d_t.t3 20.705
R6849 ldo_1v2_a_0.first_stage_0/bias_cur_0.d_t.n1 ldo_1v2_a_0.first_stage_0/bias_cur_0.d_t.t2 17.0005
R6850 ldo_1v2_a_0.first_stage_0/bias_cur_0.d_t.n1 ldo_1v2_a_0.first_stage_0/bias_cur_0.d_t.t1 17.0005
R6851 ldo_1v2_a_0.first_stage_0/bias_cur_0.d_t.t4 ldo_1v2_a_0.first_stage_0/bias_cur_0.d_t.n4 17.0005
R6852 ldo_1v2_a_0.first_stage_0/bias_cur_0.d_t.t0 ldo_1v2_a_0.first_stage_0/bias_cur_0.d_t.n4 17.0005
R6853 ldo_1v2_a_0.first_stage_0/bias_cur_0.d_t ldo_1v2_a_0.first_stage_0/bias_cur_0.d_t.n2 4.7073
R6854 ldo_1v2_a_0.first_stage_0/bias_cur_0.d_t.n7 ldo_1v2_a_0.first_stage_0/bias_cur_0.d_t.n6 4.5005
R6855 ldo_1v2_a_0.first_stage_0/bias_cur_0.d_t.n7 ldo_1v2_a_0.first_stage_0/bias_cur_0.d_t.n3 4.0592
R6856 ldo_1v2_a_0.first_stage_0/bias_cur_0.d_t.t1 ldo_1v2_a_0.first_stage_0/bias_cur_0.d_t.n0 0.61289
R6857 ldo_1v2_a_0.first_stage_0/bias_cur_0.d_t.n5 ldo_1v2_a_0.first_stage_0/bias_cur_0.d_t.t4 0.612889
R6858 ldo_1v2_a_0.first_stage_0/bias_cur_0.d_t.t2 ldo_1v2_a_0.first_stage_0/bias_cur_0.d_t.n0 0.612837
R6859 ldo_1v2_a_0.first_stage_0/bias_cur_0.d_t.n5 ldo_1v2_a_0.first_stage_0/bias_cur_0.d_t.t0 0.612837
R6860 ldo_1v2_a_0.first_stage_0/bias_cur_0.d_t.n6 ldo_1v2_a_0.first_stage_0/bias_cur_0.d_t.n5 0.417347
R6861 ldo_1v2_a_0.first_stage_0/bias_cur_0.d_t.n2 ldo_1v2_a_0.first_stage_0/bias_cur_0.d_t.n0 0.413309
R6862 ldo_1v2_a_0.first_stage_0/bias_cur_0.d_t ldo_1v2_a_0.first_stage_0/bias_cur_0.d_t.n7 0.0407286
R6863 ldo_1v2_a_0.first_stage_0/bias_cur_0.d_t.n2 ldo_1v2_a_0.first_stage_0/bias_cur_0.d_t.n1 0.0300522
R6864 ldo_1v2_a_0.first_stage_0/bias_cur_0.d_t.n6 ldo_1v2_a_0.first_stage_0/bias_cur_0.d_t.n4 0.0267687
R6865 ldo_1v2_a_0.first_stage_0/bias_cur_0.d_t.n3 ldo_1v2_a_0.first_stage_0/bias_cur_0.d_t 0.0203
R6866 ldo_1v2_a_0.first_stage_0/bias_cur_0.d_t.n3 ldo_1v2_a_0.first_stage_0/bias_cur_0.d_t 0.0177174
R6867 ldo_1v5_y_0.second_stage_1v5_0.vfb.n0 ldo_1v5_y_0.second_stage_1v5_0.vfb.t1 16.0534
R6868 ldo_1v5_y_0.second_stage_1v5_0.vfb.n0 ldo_1v5_y_0.second_stage_1v5_0.vfb.t0 16.0149
R6869 ldo_1v5_y_0.second_stage_1v5_0.vfb ldo_1v5_y_0.second_stage_1v5_0.vfb.n0 13.4407
R6870 ldo_1v5_y_0.second_stage_1v5_0.vfb ldo_1v5_y_0.second_stage_1v5_0.vfb.n1 6.88243
R6871 ldo_1v5_y_0.second_stage_1v5_0.vfb.n1 ldo_1v5_y_0.second_stage_1v5_0.vfb.t3 5.46151
R6872 ldo_1v5_y_0.second_stage_1v5_0.vfb.n1 ldo_1v5_y_0.second_stage_1v5_0.vfb.t2 3.72888
R6873 a_12834_15066.t0 a_12834_15066.t1 30.3122
R6874 a_14219_1480.t0 a_14219_1480.t1 30.3643
R6875 a_12893_15894.t0 a_12893_15894.t1 30.3122
R6876 a_13360_11392.t0 a_13360_11392.t1 30.3122
R6877 a_14219_2404.t0 a_14219_2404.t1 30.3643
R6878 a_14219_2096.t0 a_14219_2096.t1 30.3643
R6879 a_13360_12050.t0 a_13360_12050.t1 35.3797
R6880 a_15508_14386.t0 a_15508_14386.t1 30.3122
R6881 a_15041_12560.t0 a_15041_12560.t1 30.3122
R6882 a_13360_15236.t0 a_13360_15236.t1 35.3716
R6883 a_6604_1101.t0 a_6604_1101.t1 28.1987
R6884 a_14219_1788.t0 a_14219_1788.t1 30.3643
R6885 a_13215_1480.t0 a_13215_1480.t1 30.3643
R6886 a_12211_1344.t0 a_12211_1344.t1 33.2489
R6887 a_13215_2404.t0 a_13215_2404.t1 30.3643
R6888 a_13215_2096.t0 a_13215_2096.t1 30.3643
R6889 ldo_1v5_y_0.first_stage$1_0/bias_cur$1_0.d_t ldo_1v5_y_0.first_stage$1_0/bias_cur$1_0.d_t.t2 20.705
R6890 ldo_1v5_y_0.first_stage$1_0/bias_cur$1_0.d_t.n1 ldo_1v5_y_0.first_stage$1_0/bias_cur$1_0.d_t.t3 17.0005
R6891 ldo_1v5_y_0.first_stage$1_0/bias_cur$1_0.d_t.n1 ldo_1v5_y_0.first_stage$1_0/bias_cur$1_0.d_t.t0 17.0005
R6892 ldo_1v5_y_0.first_stage$1_0/bias_cur$1_0.d_t.t4 ldo_1v5_y_0.first_stage$1_0/bias_cur$1_0.d_t.n4 17.0005
R6893 ldo_1v5_y_0.first_stage$1_0/bias_cur$1_0.d_t.t1 ldo_1v5_y_0.first_stage$1_0/bias_cur$1_0.d_t.n4 17.0005
R6894 ldo_1v5_y_0.first_stage$1_0/bias_cur$1_0.d_t ldo_1v5_y_0.first_stage$1_0/bias_cur$1_0.d_t.n2 4.7073
R6895 ldo_1v5_y_0.first_stage$1_0/bias_cur$1_0.d_t.n7 ldo_1v5_y_0.first_stage$1_0/bias_cur$1_0.d_t.n6 4.5005
R6896 ldo_1v5_y_0.first_stage$1_0/bias_cur$1_0.d_t.n7 ldo_1v5_y_0.first_stage$1_0/bias_cur$1_0.d_t.n3 4.0592
R6897 ldo_1v5_y_0.first_stage$1_0/bias_cur$1_0.d_t.t0 ldo_1v5_y_0.first_stage$1_0/bias_cur$1_0.d_t.n0 0.61289
R6898 ldo_1v5_y_0.first_stage$1_0/bias_cur$1_0.d_t.n5 ldo_1v5_y_0.first_stage$1_0/bias_cur$1_0.d_t.t4 0.612889
R6899 ldo_1v5_y_0.first_stage$1_0/bias_cur$1_0.d_t.t3 ldo_1v5_y_0.first_stage$1_0/bias_cur$1_0.d_t.n0 0.612837
R6900 ldo_1v5_y_0.first_stage$1_0/bias_cur$1_0.d_t.n5 ldo_1v5_y_0.first_stage$1_0/bias_cur$1_0.d_t.t1 0.612837
R6901 ldo_1v5_y_0.first_stage$1_0/bias_cur$1_0.d_t.n6 ldo_1v5_y_0.first_stage$1_0/bias_cur$1_0.d_t.n5 0.417347
R6902 ldo_1v5_y_0.first_stage$1_0/bias_cur$1_0.d_t.n2 ldo_1v5_y_0.first_stage$1_0/bias_cur$1_0.d_t.n0 0.413309
R6903 ldo_1v5_y_0.first_stage$1_0/bias_cur$1_0.d_t ldo_1v5_y_0.first_stage$1_0/bias_cur$1_0.d_t.n7 0.0407286
R6904 ldo_1v5_y_0.first_stage$1_0/bias_cur$1_0.d_t.n2 ldo_1v5_y_0.first_stage$1_0/bias_cur$1_0.d_t.n1 0.0300522
R6905 ldo_1v5_y_0.first_stage$1_0/bias_cur$1_0.d_t.n6 ldo_1v5_y_0.first_stage$1_0/bias_cur$1_0.d_t.n4 0.0267687
R6906 ldo_1v5_y_0.first_stage$1_0/bias_cur$1_0.d_t.n3 ldo_1v5_y_0.first_stage$1_0/bias_cur$1_0.d_t 0.0203
R6907 ldo_1v5_y_0.first_stage$1_0/bias_cur$1_0.d_t.n3 ldo_1v5_y_0.first_stage$1_0/bias_cur$1_0.d_t 0.0177174
R6908 a_13215_1788.t0 a_13215_1788.t1 30.3643
R6909 a_12211_1480.t0 a_12211_1480.t1 30.3643
R6910 a_12211_2404.t0 a_12211_2404.t1 30.3643
C293 IOVDD IOVSS 35.1623f
C294 VDD_1v5 IOVSS 78.6139f
C295 VDD_1v2 IOVSS 69.07653f
C296 VBG_1V IOVSS 48.36414f
C297 a_15676_1771# IOVSS 1.66816f
C298 a_15489_1500# IOVSS 0.01861f $ **FLOATING
C299 a_14883_1344# IOVSS 0.3601f
C300 a_14381_1344# IOVSS 0.31262f
C301 a_13879_1344# IOVSS 0.31613f
C302 a_13377_1344# IOVSS 0.33205f
C303 a_12875_1344# IOVSS 0.31278f
C304 a_12373_1344# IOVSS 0.31285f
C305 a_11871_1344# IOVSS 0.3266f
C306 a_11451_1344# IOVSS 0.35774f
C307 a_6604_314# IOVSS 0.4753f
C308 a_6428_314# IOVSS 0.50842f
C309 a_6247_59# IOVSS 0.01508f $ **FLOATING
C310 a_5804_228# IOVSS 0.1589f
C311 a_5371_228# IOVSS 0.11499f
C312 a_4935_228# IOVSS 0.11482f
C313 a_4501_228# IOVSS 0.11481f
C314 a_4065_228# IOVSS 0.11481f
C315 a_3629_228# IOVSS 0.14903f
C316 a_5804_400# IOVSS 0.12494f
C317 a_5371_400# IOVSS 0.07733f
C318 a_4935_400# IOVSS 0.07712f
C319 a_4501_400# IOVSS 0.07712f
C320 a_4065_400# IOVSS 0.07732f
C321 a_3629_400# IOVSS 0.12494f
C322 a_5804_572# IOVSS 0.12468f
C323 a_5371_572# IOVSS 0.07563f
C324 a_4935_572# IOVSS 0.07543f
C325 a_4501_572# IOVSS 0.07543f
C326 a_4065_572# IOVSS 0.0757f
C327 a_3629_572# IOVSS 0.12468f
C328 a_5804_743# IOVSS 0.12468f
C329 a_5371_743# IOVSS 0.07551f
C330 a_4935_743# IOVSS 0.07532f
C331 a_4501_743# IOVSS 0.07534f
C332 a_4065_743# IOVSS 0.07561f
C333 a_3629_743# IOVSS 0.12468f
C334 a_5804_915# IOVSS 0.12494f
C335 a_5371_915# IOVSS 0.07696f
C336 a_4935_915# IOVSS 0.07677f
C337 a_4501_915# IOVSS 0.07679f
C338 a_4065_915# IOVSS 0.09401f
C339 a_3629_915# IOVSS 0.12494f
C340 a_5804_1087# IOVSS 0.1375f
C341 a_5371_1087# IOVSS 0.10228f
C342 a_4935_1087# IOVSS 0.10227f
C343 a_4501_1087# IOVSS 0.10228f
C344 a_4065_1087# IOVSS 0.10794f
C345 a_3629_1087# IOVSS 0.14903f
C346 a_14883_1652# IOVSS 0.3012f
C347 a_14381_1652# IOVSS 0.26146f
C348 a_13879_1652# IOVSS 0.26221f
C349 a_13377_1652# IOVSS 0.26471f
C350 a_12875_1652# IOVSS 0.26217f
C351 a_12373_1652# IOVSS 0.26225f
C352 a_11871_1652# IOVSS 0.26694f
C353 a_11451_1652# IOVSS 0.29664f
C354 a_14883_1960# IOVSS 0.29998f
C355 a_14381_1960# IOVSS 0.26146f
C356 a_13879_1960# IOVSS 0.26287f
C357 a_13377_1960# IOVSS 0.26283f
C358 a_12875_1960# IOVSS 0.26283f
C359 a_12373_1960# IOVSS 0.26291f
C360 a_11871_1960# IOVSS 0.26609f
C361 a_11451_1960# IOVSS 0.29542f
C362 a_14883_2268# IOVSS 0.30109f
C363 a_14381_2268# IOVSS 0.26146f
C364 a_13879_2268# IOVSS 0.26466f
C365 a_13377_2268# IOVSS 0.26215f
C366 a_12875_2268# IOVSS 0.26462f
C367 a_12373_2268# IOVSS 0.2647f
C368 a_11871_2268# IOVSS 0.2688f
C369 a_11451_2268# IOVSS 0.29653f
C370 a_14883_2576# IOVSS 0.34636f
C371 a_14381_2576# IOVSS 0.29941f
C372 a_13879_2576# IOVSS 0.31089f
C373 a_13377_2576# IOVSS 0.29957f
C374 a_12875_2576# IOVSS 0.31085f
C375 a_12373_2576# IOVSS 0.338f
C376 a_11871_2576# IOVSS 0.35135f
C377 a_11451_2576# IOVSS 0.3451f
C378 a_7843_1495# IOVSS 0.03429f $ **FLOATING
C379 a_96_1459# IOVSS 0.03429f $ **FLOATING
C380 ldo_1v5_y_0.first_stage$1_0/bias_cur$1_0.d_t IOVSS 1.61875f $ **FLOATING
C381 ldo_1v5_y_0.second_stage_1v5_0.vfb IOVSS 8.2839f $ **FLOATING
C382 ldo_1v5_y_0.first_stage$1_0/diff_pairs$1_0.dmv IOVSS 5.78795f $ **FLOATING
C383 ldo_1v2_a_0.first_stage_0/diff_pairs_0.vn1v2 IOVSS 5.63524f $ **FLOATING
C384 ldo_1v2_a_0.first_stage_0/bias_cur_0.d_t IOVSS 1.59054f $ **FLOATING
C385 a_1494_3927# IOVSS 2.90198f $ **FLOATING
C386 a_916_3927# IOVSS 3.00046f $ **FLOATING
C387 ldo_1v5_y_0.second_stage_1v5_0.dmv IOVSS 42.87549f $ **FLOATING
C388 ldo_1v2_a_0.first_stage_0/diff_pairs_0.dmr IOVSS 39.05587f $ **FLOATING
C389 ldo_1v2_a_0.first_stage_0/diff_pairs_0.dmv IOVSS 5.70184f $ **FLOATING
C390 a_15127_10882# IOVSS 0.23576f
C391 a_14053_10882# IOVSS 0.23412f
C392 a_12979_10882# IOVSS 0.20066f
C393 a_15127_11052# IOVSS 0.18087f
C394 a_14053_11052# IOVSS 0.17923f
C395 a_12979_11052# IOVSS 0.14571f
C396 a_15127_11222# IOVSS 0.17963f
C397 a_14053_11222# IOVSS 0.17799f
C398 a_12979_11222# IOVSS 0.14447f
C399 a_15127_11392# IOVSS 0.17904f
C400 a_14053_11392# IOVSS 0.1774f
C401 a_12979_11392# IOVSS 0.14389f
C402 a_15127_11562# IOVSS 0.17872f
C403 a_14053_11562# IOVSS 0.17708f
C404 a_12979_11562# IOVSS 0.14356f
C405 a_15127_11732# IOVSS 0.20636f
C406 a_14053_11732# IOVSS 0.20463f
C407 a_12979_11732# IOVSS 0.17245f
C408 a_15127_12050# IOVSS 0.19492f
C409 a_14053_12050# IOVSS 0.19127f
C410 a_12920_12050# IOVSS 0.19888f
C411 a_15127_12220# IOVSS 0.14921f
C412 a_14053_12220# IOVSS 0.14658f
C413 a_12920_12220# IOVSS 0.16494f
C414 a_15127_12390# IOVSS 0.14921f
C415 a_14053_12390# IOVSS 0.14658f
C416 a_12920_12390# IOVSS 0.16494f
C417 a_15127_12560# IOVSS 0.14921f
C418 a_14053_12560# IOVSS 0.14658f
C419 a_12920_12560# IOVSS 0.16494f
C420 a_15127_12730# IOVSS 0.14921f
C421 a_14053_12730# IOVSS 0.14658f
C422 a_12920_12730# IOVSS 0.16494f
C423 a_15127_12900# IOVSS 0.17822f
C424 a_14053_12900# IOVSS 0.17245f
C425 a_12920_12900# IOVSS 0.19852f
C426 a_15068_13218# IOVSS 0.20649f
C427 a_14053_13218# IOVSS 0.17169f
C428 a_12920_13218# IOVSS 0.19852f
C429 a_15068_13388# IOVSS 0.17291f
C430 a_14053_13388# IOVSS 0.14261f
C431 a_12920_13388# IOVSS 0.16494f
C432 a_15068_13558# IOVSS 0.17291f
C433 a_14053_13558# IOVSS 0.14261f
C434 a_12920_13558# IOVSS 0.16494f
C435 a_15068_13728# IOVSS 0.17295f
C436 a_14053_13728# IOVSS 0.14261f
C437 a_12920_13728# IOVSS 0.16494f
C438 a_15068_13898# IOVSS 0.17296f
C439 a_14053_13898# IOVSS 0.14261f
C440 a_12920_13898# IOVSS 0.16494f
C441 a_15068_14068# IOVSS 0.20677f
C442 a_14053_14068# IOVSS 0.18851f
C443 a_12920_14068# IOVSS 0.19853f
C444 a_15127_14386# IOVSS 0.17829f
C445 a_14053_14386# IOVSS 0.1722f
C446 a_12920_14386# IOVSS 0.19852f
C447 a_15127_14556# IOVSS 0.14921f
C448 a_14053_14556# IOVSS 0.14658f
C449 a_12920_14556# IOVSS 0.16494f
C450 a_15127_14726# IOVSS 0.14921f
C451 a_14053_14726# IOVSS 0.14658f
C452 a_12920_14726# IOVSS 0.16494f
C453 a_899_12078# IOVSS 0.0698f $ **FLOATING
C454 a_9148_14721# IOVSS 0.04607f $ **FLOATING
C455 a_15127_14896# IOVSS 0.14921f
C456 a_14053_14896# IOVSS 0.14658f
C457 a_12920_14896# IOVSS 0.16494f
C458 a_15127_15066# IOVSS 0.14921f
C459 a_14053_15066# IOVSS 0.14658f
C460 a_12920_15066# IOVSS 0.16494f
C461 a_15127_15236# IOVSS 0.19324f
C462 a_14053_15236# IOVSS 0.19112f
C463 a_12920_15236# IOVSS 0.19888f
C464 a_15127_15554# IOVSS 0.21501f
C465 a_14053_15554# IOVSS 0.20819f
C466 a_12979_15554# IOVSS 0.17245f
C467 a_15127_15724# IOVSS 0.18737f
C468 a_14053_15724# IOVSS 0.18069f
C469 a_12979_15724# IOVSS 0.14357f
C470 a_15127_15894# IOVSS 0.18588f
C471 a_14053_15894# IOVSS 0.18053f
C472 a_12979_15894# IOVSS 0.14389f
C473 a_15127_16064# IOVSS 0.17963f
C474 a_14053_16064# IOVSS 0.1793f
C475 a_12979_16064# IOVSS 0.14448f
C476 a_15127_16234# IOVSS 0.18089f
C477 a_14053_16234# IOVSS 0.18056f
C478 a_12979_16234# IOVSS 0.14574f
C479 a_15127_16404# IOVSS 0.23342f
C480 a_14053_16404# IOVSS 0.23009f
C481 a_12979_16404# IOVSS 0.19816f
C482 bgr_0.opm_bgr_0.bgr_second_stage_0.bgr_second_stage_cs_0.Vos1 IOVSS 40.10869f $ **FLOATING
C483 bgr_0.opm_bgr_0.bgr_first_stage_0/bgr_diff_0.ref IOVSS 12.31483f $ **FLOATING
C484 bgr_0.opm_bgr_0.bgr_first_stage_0/bgr_bias_0.VbD IOVSS 0.47815f $ **FLOATING
C485 bgr_0.opm_bgr_0.bgr_second_stage_0.bgr_second_stage_al_0.Vbias IOVSS 25.85967f $ **FLOATING
C486 ldo_1v2_a_0.VDD IOVSS 58.49066f $ **FLOATING
C487 a_6604_1101.t1 IOVSS 70.8425f $ **FLOATING
C488 a_6604_1101.t0 IOVSS 0.05753f $ **FLOATING
C489 ldo_1v2_a_0.first_stage_0/diff_pairs_0.vn1v2.t0 IOVSS 0.01361f $ **FLOATING
C490 ldo_1v2_a_0.first_stage_0/diff_pairs_0.vn1v2.t1 IOVSS 0.01359f $ **FLOATING
C491 ldo_1v2_a_0.first_stage_0/diff_pairs_0.vn1v2.n0 IOVSS 0.03741f $ **FLOATING
C492 ldo_1v2_a_0.first_stage_0/diff_pairs_0.vn1v2.t2 IOVSS 1.32627f $ **FLOATING
C493 ldo_1v5_y_0.first_stage$1_0/diff_pairs$1_0.dmv.t1 IOVSS 0.32082f $ **FLOATING
C494 ldo_1v5_y_0.first_stage$1_0/diff_pairs$1_0.dmv.t0 IOVSS 2.72358f $ **FLOATING
C495 ldo_1v5_y_0.first_stage$1_0/diff_pairs$1_0.dmv.n0 IOVSS 0.20102f $ **FLOATING
C496 ldo_1v5_y_0.first_stage$1_0/diff_pairs$1_0.dmv.n1 IOVSS 0.07031f $ **FLOATING
C497 ldo_1v5_y_0.first_stage$1_0/diff_pairs$1_0.dmv.t2 IOVSS 0.22309f $ **FLOATING
C498 ldo_1v5_y_0.first_stage$1_0/diff_pairs$1_0.dmv.n2 IOVSS 0.05241f $ **FLOATING
C499 ldo_1v5_y_0.first_stage$1_0/diff_pairs$1_0.dmv.t3 IOVSS 0.77687f $ **FLOATING
C500 ldo_1v5_y_0.first_stage$1_0/diff_pairs$1_0.dmv.t4 IOVSS 0.63078f $ **FLOATING
C501 ldo_1v5_y_0.first_stage$1_0/diff_pairs$1_0.dmv.n3 IOVSS 0.45767f $ **FLOATING
C502 a_15852_1685.n0 IOVSS 0.05422f $ **FLOATING
C503 a_15852_1685.n1 IOVSS 0.06598f $ **FLOATING
C504 a_15852_1685.n2 IOVSS 0.024f $ **FLOATING
C505 a_15852_1685.n3 IOVSS 0.024f $ **FLOATING
C506 a_15852_1685.n4 IOVSS 0.024f $ **FLOATING
C507 a_15852_1685.n5 IOVSS 0.024f $ **FLOATING
C508 a_15852_1685.n6 IOVSS 0.02054f $ **FLOATING
C509 a_15852_1685.n7 IOVSS 0.02054f $ **FLOATING
C510 a_15852_1685.n8 IOVSS 0.024f $ **FLOATING
C511 a_15852_1685.n9 IOVSS 0.024f $ **FLOATING
C512 a_15852_1685.n10 IOVSS 0.024f $ **FLOATING
C513 a_15852_1685.n11 IOVSS 0.06598f $ **FLOATING
C514 a_15852_1685.t1 IOVSS 69.7373f $ **FLOATING
C515 a_15852_1685.n12 IOVSS 0.02849f $ **FLOATING
C516 a_15852_1685.n13 IOVSS 0.06598f $ **FLOATING
C517 a_15852_1685.n14 IOVSS 0.02054f $ **FLOATING
C518 a_15852_1685.n15 IOVSS 0.02054f $ **FLOATING
C519 a_15852_1685.n16 IOVSS 0.024f $ **FLOATING
C520 a_15852_1685.n17 IOVSS 0.024f $ **FLOATING
C521 a_15852_1685.n18 IOVSS 0.024f $ **FLOATING
C522 a_15852_1685.n19 IOVSS 0.02375f $ **FLOATING
C523 a_15852_1685.n20 IOVSS 0.02719f $ **FLOATING
C524 ldo_1v2_a_0.first_stage_0/diff_pairs_0.dmv.t2 IOVSS 0.32082f $ **FLOATING
C525 ldo_1v2_a_0.first_stage_0/diff_pairs_0.dmv.t1 IOVSS 2.72358f $ **FLOATING
C526 ldo_1v2_a_0.first_stage_0/diff_pairs_0.dmv.n0 IOVSS 0.20231f $ **FLOATING
C527 ldo_1v2_a_0.first_stage_0/diff_pairs_0.dmv.t3 IOVSS 0.22309f $ **FLOATING
C528 ldo_1v2_a_0.first_stage_0/diff_pairs_0.dmv.n1 IOVSS 0.11019f $ **FLOATING
C529 ldo_1v2_a_0.first_stage_0/diff_pairs_0.dmv.t4 IOVSS 0.77687f $ **FLOATING
C530 ldo_1v2_a_0.first_stage_0/diff_pairs_0.dmv.t0 IOVSS 0.63068f $ **FLOATING
C531 ldo_1v2_a_0.first_stage_0/diff_pairs_0.dmv.n2 IOVSS 0.45777f $ **FLOATING
C532 ldo_1v2_a_0.first_stage_0/bias_cur_0.i_ref.t1 IOVSS 2.80039f $ **FLOATING
C533 ldo_1v2_a_0.first_stage_0/bias_cur_0.i_ref.t3 IOVSS 0.01475f $ **FLOATING
C534 ldo_1v2_a_0.first_stage_0/bias_cur_0.i_ref.t2 IOVSS 0.79968f $ **FLOATING
C535 ldo_1v2_a_0.first_stage_0/bias_cur_0.i_ref.n0 IOVSS 0.49165f $ **FLOATING
C536 ldo_1v2_a_0.first_stage_0/bias_cur_0.i_ref.n1 IOVSS 0.51702f $ **FLOATING
C537 ldo_1v2_a_0.first_stage_0/bias_cur_0.i_ref.t0 IOVSS 0.1765f $ **FLOATING
C538 a_13360_11732.t2 IOVSS 0.22865f $ **FLOATING
C539 a_13360_11732.t1 IOVSS 0.09344f $ **FLOATING
C540 a_13360_11732.n0 IOVSS 2.31435f $ **FLOATING
C541 a_13360_11732.t0 IOVSS 0.16356f $ **FLOATING
C542 bgr_0.vn.t0 IOVSS 0.4795f $ **FLOATING
C543 bgr_0.vn.t1 IOVSS 0.83843f $ **FLOATING
C544 bgr_0.bgr_ctat_mirror_0.Vref IOVSS 0.30384f $ **FLOATING
C545 bgr_0.vn.n0 IOVSS 0.1671f $ **FLOATING
C546 bgr_0.vn.t2 IOVSS 0.18802f $ **FLOATING
C547 bgr_0.bgr_startup_0.Vstart_out IOVSS 0.57061f $ **FLOATING
C548 bgr_0.vn.n1 IOVSS 1.06727f $ **FLOATING
C549 bgr_0.vn.t4 IOVSS 1.10891f $ **FLOATING
C550 bgr_0.vn.t3 IOVSS 1.11681f $ **FLOATING
C551 bgr_0.vn.n2 IOVSS 0.37348f $ **FLOATING
C552 bgr_0.opm_bgr_0.bgr_first_stage_0/bgr_diff_0.vn_VBG IOVSS 0.30349f $ **FLOATING
C553 bgr_0.vn.n3 IOVSS 2.55937f $ **FLOATING
C554 bgr_0.vn.n4 IOVSS 3.21255f $ **FLOATING
C555 bgr_0.bgr_ctat_ref_0.vn_vbg IOVSS 0.41048f $ **FLOATING
C556 bgr_0.opm_bgr_0.bgr_second_stage_0.bgr_second_stage_al_0.Vbias.t8 IOVSS 0.25453f $ **FLOATING
C557 bgr_0.opm_bgr_0.bgr_second_stage_0.bgr_second_stage_al_0.Vbias.n0 IOVSS 0.09993f $ **FLOATING
C558 bgr_0.opm_bgr_0.bgr_second_stage_0.bgr_second_stage_al_0.Vbias.t5 IOVSS 0.25354f $ **FLOATING
C559 bgr_0.opm_bgr_0.bgr_second_stage_0.bgr_second_stage_al_0.Vbias.n1 IOVSS 0.12361f $ **FLOATING
C560 bgr_0.opm_bgr_0.bgr_second_stage_0.bgr_second_stage_al_0.Vbias.t6 IOVSS 0.29334f $ **FLOATING
C561 bgr_0.opm_bgr_0.bgr_second_stage_0.bgr_second_stage_al_0.Vbias.n2 IOVSS 0.1549f $ **FLOATING
C562 bgr_0.opm_bgr_0.bgr_second_stage_0.bgr_second_stage_al_0.Vbias.t4 IOVSS 8.94069f $ **FLOATING
C563 bgr_0.opm_bgr_0.bgr_second_stage_0.bgr_second_stage_al_0.Vbias.n3 IOVSS 0.01551f $ **FLOATING
C564 bgr_0.opm_bgr_0.bgr_second_stage_0.bgr_second_stage_al_0.Vbias.n4 IOVSS 0.06921f $ **FLOATING
C565 bgr_0.opm_bgr_0.bgr_second_stage_0.bgr_second_stage_al_0.Vbias.t10 IOVSS 10.4558f $ **FLOATING
C566 bgr_0.opm_bgr_0.bgr_second_stage_0.bgr_second_stage_al_0.Vbias.n5 IOVSS 0.84694f $ **FLOATING
C567 bgr_0.opm_bgr_0.bgr_second_stage_0.bgr_second_stage_al_0.Vbias.t1 IOVSS 0.17294f $ **FLOATING
C568 bgr_0.opm_bgr_0.bgr_second_stage_0.bgr_second_stage_al_0.Vbias.n6 IOVSS 0.15397f $ **FLOATING
C569 bgr_0.opm_bgr_0.bgr_second_stage_0.bgr_second_stage_al_0.Vbias.t2 IOVSS 0.20853f $ **FLOATING
C570 bgr_0.opm_bgr_0.bgr_second_stage_0.bgr_second_stage_al_0.Vbias.t0 IOVSS 7.43609f $ **FLOATING
C571 bgr_0.opm_bgr_0.bgr_second_stage_0.bgr_second_stage_al_0.Vbias.n7 IOVSS 0.19701f $ **FLOATING
C572 bgr_0.opm_bgr_0.bgr_second_stage_0.bgr_second_stage_al_0.Vbias.n8 IOVSS 0.34286f $ **FLOATING
C573 ldo_1v5_y_0.first_stage$1_0/bias_cur$1_0.i_ref.t1 IOVSS 2.85873f $ **FLOATING
C574 ldo_1v5_y_0.first_stage$1_0/bias_cur$1_0.i_ref.t3 IOVSS 0.01506f $ **FLOATING
C575 ldo_1v5_y_0.first_stage$1_0/bias_cur$1_0.i_ref.t2 IOVSS 0.81634f $ **FLOATING
C576 ldo_1v5_y_0.first_stage$1_0/bias_cur$1_0.i_ref.n0 IOVSS 0.50189f $ **FLOATING
C577 ldo_1v5_y_0.first_stage$1_0/bias_cur$1_0.i_ref.n1 IOVSS 0.52779f $ **FLOATING
C578 ldo_1v5_y_0.first_stage$1_0/bias_cur$1_0.i_ref.t0 IOVSS 0.18018f $ **FLOATING
C579 bgr_0.opm_bgr_0.bgr_second_stage_0.bgr_second_stage_cs_0.Vos1.t5 IOVSS 9.45336f $ **FLOATING
C580 bgr_0.opm_bgr_0.bgr_second_stage_0.bgr_second_stage_cs_0.Vos1.t3 IOVSS 0.04942f $ **FLOATING
C581 bgr_0.opm_bgr_0.bgr_second_stage_0.bgr_second_stage_cs_0.Vos1.n0 IOVSS 0.14434f $ **FLOATING
C582 bgr_0.opm_bgr_0.bgr_second_stage_0.bgr_second_stage_cs_0.Vos1.t2 IOVSS 0.04931f $ **FLOATING
C583 bgr_0.opm_bgr_0.bgr_second_stage_0.bgr_second_stage_cs_0.Vos1.n1 IOVSS 0.12704f $ **FLOATING
C584 bgr_0.opm_bgr_0.bgr_second_stage_0.bgr_second_stage_cs_0.Vos1.n2 IOVSS 0.03765f $ **FLOATING
C585 bgr_0.opm_bgr_0.bgr_second_stage_0.bgr_second_stage_cs_0.Vos1.n3 IOVSS 0.04694f $ **FLOATING
C586 bgr_0.opm_bgr_0.bgr_second_stage_0.bgr_second_stage_cs_0.Vos1.n4 IOVSS 0.12898f $ **FLOATING
C587 bgr_0.opm_bgr_0.bgr_second_stage_0.bgr_second_stage_cs_0.Vos1.n5 IOVSS 0.04694f $ **FLOATING
C588 bgr_0.opm_bgr_0.bgr_second_stage_0.bgr_second_stage_cs_0.Vos1.n6 IOVSS 0.04694f $ **FLOATING
C589 bgr_0.opm_bgr_0.bgr_second_stage_0.bgr_second_stage_cs_0.Vos1.n7 IOVSS 0.04694f $ **FLOATING
C590 bgr_0.opm_bgr_0.bgr_second_stage_0.bgr_second_stage_cs_0.Vos1.n8 IOVSS 0.04694f $ **FLOATING
C591 bgr_0.opm_bgr_0.bgr_second_stage_0.bgr_second_stage_cs_0.Vos1.n9 IOVSS 0.04694f $ **FLOATING
C592 bgr_0.opm_bgr_0.bgr_second_stage_0.bgr_second_stage_cs_0.Vos1.t4 IOVSS 49.5306f $ **FLOATING
C593 bgr_0.opm_bgr_0.bgr_second_stage_0.bgr_second_stage_cs_0.Vos1.n10 IOVSS 13.0754f $ **FLOATING
C594 bgr_0.opm_bgr_0.bgr_second_stage_0.bgr_second_stage_cs_0.Vos1.n11 IOVSS 0.03765f $ **FLOATING
C595 bgr_0.opm_bgr_0.bgr_second_stage_0.bgr_second_stage_cs_0.Vos1.n12 IOVSS 0.04694f $ **FLOATING
C596 bgr_0.opm_bgr_0.bgr_second_stage_0.bgr_second_stage_cs_0.Vos1.n13 IOVSS 0.85946f $ **FLOATING
C597 bgr_0.opm_bgr_0.bgr_second_stage_0.bgr_second_stage_cs_0.Vos1.n14 IOVSS 0.85946f $ **FLOATING
C598 bgr_0.opm_bgr_0.bgr_second_stage_0.bgr_second_stage_cs_0.Vos1.n15 IOVSS 9.42801f $ **FLOATING
C599 bgr_0.opm_bgr_0.bgr_second_stage_0.bgr_second_stage_cs_0.Vos1.n16 IOVSS 0.05442f $ **FLOATING
C600 bgr_0.opm_bgr_0.bgr_second_stage_0.bgr_second_stage_cs_0.Vos1.n17 IOVSS 0.03818f $ **FLOATING
C601 bgr_0.opm_bgr_0.bgr_second_stage_0.bgr_second_stage_cs_0.Vos1.n18 IOVSS 0.04052f $ **FLOATING
C602 bgr_0.opm_bgr_0.bgr_second_stage_0.bgr_second_stage_cs_0.Vos1.n19 IOVSS 0.04694f $ **FLOATING
C603 bgr_0.opm_bgr_0.bgr_second_stage_0.bgr_second_stage_cs_0.Vos1.n20 IOVSS 0.04694f $ **FLOATING
C604 bgr_0.opm_bgr_0.bgr_second_stage_0.bgr_second_stage_cs_0.Vos1.n21 IOVSS 0.04694f $ **FLOATING
C605 bgr_0.opm_bgr_0.bgr_second_stage_0.bgr_second_stage_cs_0.Vos1.n22 IOVSS 0.04694f $ **FLOATING
C606 bgr_0.opm_bgr_0.bgr_second_stage_0.bgr_second_stage_cs_0.Vos1.n23 IOVSS 0.04694f $ **FLOATING
C607 bgr_0.opm_bgr_0.bgr_second_stage_0.bgr_second_stage_cs_0.Vos1.n24 IOVSS 0.12898f $ **FLOATING
C608 bgr_0.opm_bgr_0.bgr_second_stage_0.bgr_second_stage_cs_0.Vos1.n26 IOVSS 0.04129f $ **FLOATING
C609 bgr_0.opm_bgr_0.bgr_second_stage_0.bgr_second_stage_cs_0.Vos1.n27 IOVSS 0.02467f $ **FLOATING
C610 bgr_0.opm_bgr_0.bgr_second_stage_0.bgr_second_stage_cs_0.Vos1.t1 IOVSS 0.05912f $ **FLOATING
C611 bgr_0.opm_bgr_0.bgr_second_stage_0.bgr_second_stage_cs_0.Vos1.t0 IOVSS 0.11875f $ **FLOATING
C612 bgr_0.opm_bgr_0.bgr_second_stage_0.bgr_second_stage_cs_0.Vos1.n28 IOVSS 0.05756f $ **FLOATING
C613 bgr_0.opm_bgr_0.bgr_first_stage_0/bgr_diff_0.ref.t3 IOVSS 0.1045f $ **FLOATING
C614 bgr_0.opm_bgr_0.bgr_first_stage_0/bgr_diff_0.ref.t4 IOVSS 0.05068f $ **FLOATING
C615 bgr_0.opm_bgr_0.bgr_first_stage_0/bgr_diff_0.ref.n0 IOVSS 0.06305f $ **FLOATING
C616 bgr_0.opm_bgr_0.bgr_first_stage_0/bgr_diff_0.ref.t1 IOVSS 0.032f $ **FLOATING
C617 bgr_0.opm_bgr_0.bgr_first_stage_0/bgr_diff_0.ref.t2 IOVSS 0.06763f $ **FLOATING
C618 bgr_0.opm_bgr_0.bgr_first_stage_0/bgr_diff_0.ref.t0 IOVSS 2.72942f $ **FLOATING
C619 bgr_0.opm_bgr_0.bgr_first_stage_0/bgr_diff_0.ref.n1 IOVSS 0.11938f $ **FLOATING
C620 bgr_0.opm_bgr_0.bgr_first_stage_0/bgr_diff_0.ref.n2 IOVSS 0.06132f $ **FLOATING
C621 bgr_0.vp.t0 IOVSS 0.06272f $ **FLOATING
C622 bgr_0.vp.t1 IOVSS 0.14152f $ **FLOATING
C623 bgr_0.vp.n0 IOVSS 0.38144f $ **FLOATING
C624 bgr_0.vp.t3 IOVSS 0.6249f $ **FLOATING
C625 bgr_0.vp.t2 IOVSS 0.49966f $ **FLOATING
C626 bgr_0.vp.n1 IOVSS 0.2848f $ **FLOATING
C627 bgr_0.vp.n2 IOVSS 0.472f $ **FLOATING
C628 bgr_0.vp.t5 IOVSS 0.76566f $ **FLOATING
C629 bgr_0.vp.t4 IOVSS 0.76957f $ **FLOATING
C630 bgr_0.vp.n3 IOVSS 0.23887f $ **FLOATING
C631 bgr_0.opm_bgr_0.bgr_first_stage_0/bgr_diff_0.vp_VBG IOVSS 0.19888f $ **FLOATING
C632 bgr_0.opm_bgr_0.vp_vbg1v IOVSS 0.03451f $ **FLOATING
C633 bgr_0.vp.n4 IOVSS 2.02975f $ **FLOATING
C634 bgr_0.vp.t6 IOVSS 1.14804f $ **FLOATING
C635 bgr_0.vp.n5 IOVSS 2.30179f $ **FLOATING
C636 bgr_0.bgr_ctat_ref_0.vp_vbg IOVSS 0.16425f $ **FLOATING
C637 bgr_0.vp.n6 IOVSS 0.22852f $ **FLOATING
C638 bgr_0.vp.n7 IOVSS 1.12265f $ **FLOATING
C639 bgr_0.bgr_resistors_2_0.Vp IOVSS 0.13061f $ **FLOATING
C640 VDD_1v2.t11 IOVSS 76.5699f $ **FLOATING
C641 VDD_1v2.t8 IOVSS 0.41609f $ **FLOATING
C642 VDD_1v2.n0 IOVSS 0.03509f $ **FLOATING
C643 VDD_1v2.t6 IOVSS 0.30665f $ **FLOATING
C644 VDD_1v2.t9 IOVSS 0.30665f $ **FLOATING
C645 VDD_1v2.t3 IOVSS 0.41565f $ **FLOATING
C646 VDD_1v2.t2 IOVSS 0.41565f $ **FLOATING
C647 VDD_1v2.n1 IOVSS 0.06174f $ **FLOATING
C648 VDD_1v2.t4 IOVSS 0.30665f $ **FLOATING
C649 VDD_1v2.t7 IOVSS 0.30665f $ **FLOATING
C650 VDD_1v2.t1 IOVSS 0.41609f $ **FLOATING
C651 VDD_1v2.t10 IOVSS 0.30665f $ **FLOATING
C652 VDD_1v2.t5 IOVSS 0.30665f $ **FLOATING
C653 VDD_1v2.n2 IOVSS 0.13703f $ **FLOATING
C654 VDD_1v2.n3 IOVSS 0.13705f $ **FLOATING
C655 VDD_1v2.n4 IOVSS 0.06105f $ **FLOATING
C656 VDD_1v2.n5 IOVSS 0.04271f $ **FLOATING
C657 VDD_1v2.n6 IOVSS 0.12236f $ **FLOATING
C658 VDD_1v2.n7 IOVSS 0.12227f $ **FLOATING
C659 VDD_1v2.n8 IOVSS 0.04305f $ **FLOATING
C660 VDD_1v2.n9 IOVSS 0.06174f $ **FLOATING
C661 VDD_1v2.n10 IOVSS 0.13703f $ **FLOATING
C662 VDD_1v2.n11 IOVSS 0.13354f $ **FLOATING
C663 VDD_1v2.n12 IOVSS 0.03049f $ **FLOATING
C664 VDD_1v2.t0 IOVSS 0.01269f $ **FLOATING
C665 VDD_1v2.n13 IOVSS 0.09968f $ **FLOATING
C666 VDD_1v2.n14 IOVSS 2.27685f $ **FLOATING
C667 VDD_1v2.n15 IOVSS 9.67514f $ **FLOATING
C668 ldo_1v2_a_0.first_stage_0/diff_pairs_0.dmr.t4 IOVSS 0.52258f $ **FLOATING
C669 ldo_1v2_a_0.first_stage_0/diff_pairs_0.dmr.t3 IOVSS 0.24924f $ **FLOATING
C670 ldo_1v2_a_0.first_stage_0/diff_pairs_0.dmr.n0 IOVSS 0.45463f $ **FLOATING
C671 ldo_1v2_a_0.first_stage_0/diff_pairs_0.dmr.t1 IOVSS 0.33649f $ **FLOATING
C672 ldo_1v2_a_0.first_stage_0/diff_pairs_0.dmr.t5 IOVSS 55.4548f $ **FLOATING
C673 ldo_1v2_a_0.first_stage_0/diff_pairs_0.dmr.n1 IOVSS 2.48885f $ **FLOATING
C674 ldo_1v2_a_0.first_stage_0/diff_pairs_0.dmr.n2 IOVSS 0.30684f $ **FLOATING
C675 ldo_1v2_a_0.first_stage_0/diff_pairs_0.dmr.t2 IOVSS 0.76876f $ **FLOATING
C676 ldo_1v2_a_0.first_stage_0/diff_pairs_0.dmr.t0 IOVSS 0.69224f $ **FLOATING
C677 ldo_1v2_a_0.first_stage_0/diff_pairs_0.dmr.n3 IOVSS 0.49801f $ **FLOATING
C678 VBG_1V.t10 IOVSS 1.37244f $ **FLOATING
C679 VBG_1V.t4 IOVSS 0.0276f $ **FLOATING
C680 VBG_1V.n0 IOVSS 0.0339f $ **FLOATING
C681 VBG_1V.t6 IOVSS 0.0276f $ **FLOATING
C682 VBG_1V.t3 IOVSS 0.03179f $ **FLOATING
C683 VBG_1V.t7 IOVSS 0.0276f $ **FLOATING
C684 VBG_1V.t2 IOVSS 0.03179f $ **FLOATING
C685 VBG_1V.n1 IOVSS 0.07653f $ **FLOATING
C686 VBG_1V.t5 IOVSS 0.0276f $ **FLOATING
C687 VBG_1V.n2 IOVSS 0.04018f $ **FLOATING
C688 VBG_1V.n3 IOVSS 0.03973f $ **FLOATING
C689 VBG_1V.n4 IOVSS 0.07473f $ **FLOATING
C690 VBG_1V.n5 IOVSS 0.03387f $ **FLOATING
C691 VBG_1V.n6 IOVSS 0.02487f $ **FLOATING
C692 VBG_1V.t0 IOVSS 0.08088f $ **FLOATING
C693 VBG_1V.t8 IOVSS 1.1262f $ **FLOATING
C694 VBG_1V.t9 IOVSS 0.52086f $ **FLOATING
C695 VBG_1V.n7 IOVSS 0.24147f $ **FLOATING
C696 VBG_1V.n8 IOVSS 0.44142f $ **FLOATING
C697 VBG_1V.t1 IOVSS 0.01831f $ **FLOATING
C698 VBG_1V.n9 IOVSS 0.14899f $ **FLOATING
C699 VBG_1V.n10 IOVSS 0.08238f $ **FLOATING
C700 VBG_1V.n11 IOVSS 0.15012f $ **FLOATING
C701 VBG_1V.t12 IOVSS 1.35893f $ **FLOATING
C702 VBG_1V.t11 IOVSS 1.35266f $ **FLOATING
C703 VBG_1V.n12 IOVSS 0.10685f $ **FLOATING
C704 VBG_1V.n13 IOVSS 7.45119f $ **FLOATING
C705 bgr_0.out_opm.t9 IOVSS 1.90469f $ **FLOATING
C706 bgr_0.out_opm.t8 IOVSS 0.4949f $ **FLOATING
C707 bgr_0.out_opm.t10 IOVSS 0.14965f $ **FLOATING
C708 bgr_0.out_opm.n0 IOVSS 0.02574f $ **FLOATING
C709 bgr_0.out_opm.n1 IOVSS 0.0668f $ **FLOATING
C710 bgr_0.out_opm.n2 IOVSS 0.02008f $ **FLOATING
C711 bgr_0.out_opm.n3 IOVSS 0.01713f $ **FLOATING
C712 bgr_0.out_opm.n4 IOVSS 0.02008f $ **FLOATING
C713 bgr_0.out_opm.n5 IOVSS 0.02008f $ **FLOATING
C714 bgr_0.out_opm.n6 IOVSS 0.02008f $ **FLOATING
C715 bgr_0.out_opm.n7 IOVSS 0.02008f $ **FLOATING
C716 bgr_0.out_opm.n8 IOVSS 0.02008f $ **FLOATING
C717 bgr_0.out_opm.n9 IOVSS 0.02008f $ **FLOATING
C718 bgr_0.out_opm.n10 IOVSS 0.02008f $ **FLOATING
C719 bgr_0.out_opm.n11 IOVSS 0.02008f $ **FLOATING
C720 bgr_0.out_opm.n12 IOVSS 0.05515f $ **FLOATING
C721 bgr_0.out_opm.n13 IOVSS 0.02008f $ **FLOATING
C722 bgr_0.out_opm.n14 IOVSS 0.02008f $ **FLOATING
C723 bgr_0.out_opm.n15 IOVSS 0.02008f $ **FLOATING
C724 bgr_0.out_opm.n16 IOVSS 0.05515f $ **FLOATING
C725 bgr_0.out_opm.n17 IOVSS 0.02008f $ **FLOATING
C726 bgr_0.out_opm.n18 IOVSS 0.02008f $ **FLOATING
C727 bgr_0.out_opm.n19 IOVSS 0.02008f $ **FLOATING
C728 bgr_0.out_opm.n20 IOVSS 0.01506f $ **FLOATING
C729 bgr_0.out_opm.t11 IOVSS 92.4747f $ **FLOATING
C730 bgr_0.out_opm.n21 IOVSS 0.06403f $ **FLOATING
C731 bgr_0.out_opm.n22 IOVSS 0.01506f $ **FLOATING
C732 bgr_0.out_opm.n23 IOVSS 0.02008f $ **FLOATING
C733 bgr_0.out_opm.n24 IOVSS 0.02008f $ **FLOATING
C734 bgr_0.out_opm.n25 IOVSS 0.02008f $ **FLOATING
C735 bgr_0.out_opm.n26 IOVSS 0.05515f $ **FLOATING
C736 bgr_0.out_opm.n27 IOVSS 0.01724f $ **FLOATING
C737 bgr_0.out_opm.n28 IOVSS 0.01724f $ **FLOATING
C738 bgr_0.out_opm.n29 IOVSS 0.02008f $ **FLOATING
C739 bgr_0.out_opm.n30 IOVSS 0.02008f $ **FLOATING
C740 bgr_0.out_opm.n31 IOVSS 0.02008f $ **FLOATING
C741 bgr_0.out_opm.n32 IOVSS 0.02008f $ **FLOATING
C742 bgr_0.out_opm.n33 IOVSS 0.02008f $ **FLOATING
C743 bgr_0.out_opm.n34 IOVSS 0.02008f $ **FLOATING
C744 bgr_0.out_opm.n35 IOVSS 0.02008f $ **FLOATING
C745 bgr_0.out_opm.n36 IOVSS 0.02008f $ **FLOATING
C746 bgr_0.out_opm.n37 IOVSS 0.02008f $ **FLOATING
C747 bgr_0.out_opm.n38 IOVSS 0.02008f $ **FLOATING
C748 bgr_0.out_opm.n39 IOVSS 0.02008f $ **FLOATING
C749 bgr_0.out_opm.n40 IOVSS 0.02008f $ **FLOATING
C750 bgr_0.out_opm.n41 IOVSS 0.02008f $ **FLOATING
C751 bgr_0.out_opm.n42 IOVSS 0.02008f $ **FLOATING
C752 bgr_0.out_opm.n43 IOVSS 0.01622f $ **FLOATING
C753 bgr_0.out_opm.n44 IOVSS 0.21339f $ **FLOATING
C754 bgr_0.out_opm.n45 IOVSS 0.31476f $ **FLOATING
C755 bgr_0.out_opm.n46 IOVSS 0.19751f $ **FLOATING
C756 bgr_0.bgr_ctat_mirror_0.opm_out IOVSS 0.05816f $ **FLOATING
C757 bgr_0.out_opm.n47 IOVSS 0.05935f $ **FLOATING
C758 bgr_0.opm_bgr_0.bgr_second_stage_0.vout_opm IOVSS 0.02869f $ **FLOATING
C759 bgr_0.out_opm.t4 IOVSS 0.10586f $ **FLOATING
C760 bgr_0.out_opm.t6 IOVSS 0.09708f $ **FLOATING
C761 bgr_0.out_opm.t2 IOVSS 0.09706f $ **FLOATING
C762 bgr_0.out_opm.n48 IOVSS 0.05223f $ **FLOATING
C763 bgr_0.out_opm.t7 IOVSS 0.09706f $ **FLOATING
C764 bgr_0.out_opm.t3 IOVSS 0.09706f $ **FLOATING
C765 bgr_0.out_opm.n49 IOVSS 0.05224f $ **FLOATING
C766 bgr_0.out_opm.n50 IOVSS 0.07155f $ **FLOATING
C767 bgr_0.out_opm.t5 IOVSS 0.08342f $ **FLOATING
C768 bgr_0.out_opm.n51 IOVSS 0.02582f $ **FLOATING
C769 bgr_0.opm_bgr_0.bgr_second_stage_0.bgr_second_stage_al_0.Vout_opm IOVSS 0.0192f $ **FLOATING
C770 bgr_0.out_opm.n52 IOVSS 0.02657f $ **FLOATING
C771 bgr_0.out_opm.t1 IOVSS 0.09736f $ **FLOATING
C772 bgr_0.out_opm.t0 IOVSS 0.14351f $ **FLOATING
C773 bgr_0.out_opm.n53 IOVSS 0.02911f $ **FLOATING
C774 bgr_0.out_opm.n54 IOVSS 0.02668f $ **FLOATING
C775 bgr_0.opm_bgr_0.bgr_second_stage_0.bgr_second_stage_cs_0.vout_opm IOVSS 0.01875f $ **FLOATING
C776 VDD_1v5.t16 IOVSS 77.259f $ **FLOATING
C777 VDD_1v5.t17 IOVSS 0.01795f $ **FLOATING
C778 VDD_1v5.n0 IOVSS 0.24941f $ **FLOATING
C779 VDD_1v5.n1 IOVSS 0.05906f $ **FLOATING
C780 VDD_1v5.t12 IOVSS 0.22837f $ **FLOATING
C781 VDD_1v5.n2 IOVSS 0.08142f $ **FLOATING
C782 VDD_1v5.t8 IOVSS 0.22837f $ **FLOATING
C783 VDD_1v5.n3 IOVSS 0.08142f $ **FLOATING
C784 VDD_1v5.t4 IOVSS 0.22837f $ **FLOATING
C785 VDD_1v5.n4 IOVSS 0.08142f $ **FLOATING
C786 VDD_1v5.t6 IOVSS 0.22837f $ **FLOATING
C787 VDD_1v5.n5 IOVSS 0.08142f $ **FLOATING
C788 VDD_1v5.t3 IOVSS 0.22837f $ **FLOATING
C789 VDD_1v5.n6 IOVSS 0.08142f $ **FLOATING
C790 VDD_1v5.t2 IOVSS 0.22837f $ **FLOATING
C791 VDD_1v5.t9 IOVSS 0.22837f $ **FLOATING
C792 VDD_1v5.t10 IOVSS 0.22837f $ **FLOATING
C793 VDD_1v5.n7 IOVSS 0.08152f $ **FLOATING
C794 VDD_1v5.t14 IOVSS 0.22837f $ **FLOATING
C795 VDD_1v5.n8 IOVSS 0.08152f $ **FLOATING
C796 VDD_1v5.t13 IOVSS 0.22837f $ **FLOATING
C797 VDD_1v5.n9 IOVSS 0.08152f $ **FLOATING
C798 VDD_1v5.t1 IOVSS 0.22837f $ **FLOATING
C799 VDD_1v5.n10 IOVSS 0.08152f $ **FLOATING
C800 VDD_1v5.t0 IOVSS 0.22837f $ **FLOATING
C801 VDD_1v5.n11 IOVSS 0.08152f $ **FLOATING
C802 VDD_1v5.t11 IOVSS 0.22837f $ **FLOATING
C803 VDD_1v5.n12 IOVSS 0.08142f $ **FLOATING
C804 VDD_1v5.t7 IOVSS 0.22837f $ **FLOATING
C805 VDD_1v5.n13 IOVSS 0.08152f $ **FLOATING
C806 VDD_1v5.t15 IOVSS 0.20433f $ **FLOATING
C807 VDD_1v5.n14 IOVSS 0.0947f $ **FLOATING
C808 VDD_1v5.t5 IOVSS 0.20433f $ **FLOATING
C809 VDD_1v5.n15 IOVSS 0.09557f $ **FLOATING
C810 VDD_1v5.n16 IOVSS 0.05775f $ **FLOATING
C811 VDD_1v5.n17 IOVSS 0.04088f $ **FLOATING
C812 VDD_1v5.n18 IOVSS 0.04088f $ **FLOATING
C813 VDD_1v5.n19 IOVSS 0.04088f $ **FLOATING
C814 VDD_1v5.n20 IOVSS 0.04088f $ **FLOATING
C815 VDD_1v5.n21 IOVSS 0.05775f $ **FLOATING
C816 VDD_1v5.n22 IOVSS 0.09557f $ **FLOATING
C817 VDD_1v5.n23 IOVSS 0.0947f $ **FLOATING
C818 VDD_1v5.n24 IOVSS 0.06966f $ **FLOATING
C819 VDD_1v5.n25 IOVSS 0.04821f $ **FLOATING
C820 VDD_1v5.n26 IOVSS 0.04821f $ **FLOATING
C821 VDD_1v5.n27 IOVSS 0.04821f $ **FLOATING
C822 VDD_1v5.n28 IOVSS 0.0445f $ **FLOATING
C823 VDD_1v5.n29 IOVSS 0.04144f $ **FLOATING
C824 VDD_1v5.n30 IOVSS 0.14375f $ **FLOATING
C825 ldo_1v2_a_0.VDD.n0 IOVSS 0.08862f $ **FLOATING
C826 ldo_1v2_a_0.VDD.n1 IOVSS 0.01545f $ **FLOATING
C827 ldo_1v2_a_0.VDD.n2 IOVSS 0.4366f $ **FLOATING
C828 ldo_1v2_a_0.VDD.n3 IOVSS 0.06991f $ **FLOATING
C829 ldo_1v2_a_0.VDD.n4 IOVSS 0.0283f $ **FLOATING
C830 ldo_1v2_a_0.VDD.n5 IOVSS 0.73787f $ **FLOATING
C831 ldo_1v2_a_0.VDD.t119 IOVSS 0.10616f $ **FLOATING
C832 ldo_1v2_a_0.VDD.t122 IOVSS 0.10619f $ **FLOATING
C833 ldo_1v2_a_0.VDD.t118 IOVSS 0.10616f $ **FLOATING
C834 ldo_1v2_a_0.VDD.t121 IOVSS 0.10619f $ **FLOATING
C835 ldo_1v2_a_0.VDD.n6 IOVSS 0.05083f $ **FLOATING
C836 ldo_1v2_a_0.VDD.t117 IOVSS 0.52177f $ **FLOATING
C837 ldo_1v2_a_0.VDD.n8 IOVSS 0.05592f $ **FLOATING
C838 ldo_1v2_a_0.VDD.t92 IOVSS 0.10619f $ **FLOATING
C839 ldo_1v2_a_0.VDD.t98 IOVSS 0.10616f $ **FLOATING
C840 ldo_1v2_a_0.VDD.t93 IOVSS 0.10619f $ **FLOATING
C841 ldo_1v2_a_0.VDD.t99 IOVSS 0.10616f $ **FLOATING
C842 ldo_1v2_a_0.VDD.n9 IOVSS 0.05073f $ **FLOATING
C843 ldo_1v2_a_0.VDD.t90 IOVSS 0.52177f $ **FLOATING
C844 ldo_1v2_a_0.VDD.n11 IOVSS 0.05597f $ **FLOATING
C845 ldo_1v2_a_0.VDD.n12 IOVSS 0.07554f $ **FLOATING
C846 ldo_1v2_a_0.VDD.n14 IOVSS 0.01387f $ **FLOATING
C847 ldo_1v2_a_0.VDD.n15 IOVSS 0.01378f $ **FLOATING
C848 ldo_1v2_a_0.VDD.n16 IOVSS 0.01387f $ **FLOATING
C849 ldo_1v2_a_0.VDD.n17 IOVSS 0.01387f $ **FLOATING
C850 ldo_1v2_a_0.VDD.n18 IOVSS 0.01378f $ **FLOATING
C851 ldo_1v2_a_0.VDD.n19 IOVSS 0.01378f $ **FLOATING
C852 ldo_1v2_a_0.VDD.n20 IOVSS 0.01387f $ **FLOATING
C853 ldo_1v2_a_0.VDD.n21 IOVSS 0.01387f $ **FLOATING
C854 ldo_1v2_a_0.VDD.n22 IOVSS 0.01378f $ **FLOATING
C855 ldo_1v2_a_0.VDD.n23 IOVSS 0.01387f $ **FLOATING
C856 ldo_1v2_a_0.VDD.n24 IOVSS 0.01387f $ **FLOATING
C857 ldo_1v2_a_0.VDD.t145 IOVSS 0.08675f $ **FLOATING
C858 ldo_1v2_a_0.VDD.t148 IOVSS 0.09569f $ **FLOATING
C859 ldo_1v2_a_0.VDD.t146 IOVSS 0.09572f $ **FLOATING
C860 ldo_1v2_a_0.VDD.n26 IOVSS 0.14603f $ **FLOATING
C861 ldo_1v2_a_0.VDD.n27 IOVSS 0.06244f $ **FLOATING
C862 ldo_1v2_a_0.VDD.t147 IOVSS 0.08675f $ **FLOATING
C863 ldo_1v2_a_0.VDD.n28 IOVSS 0.03224f $ **FLOATING
C864 ldo_1v2_a_0.VDD.n29 IOVSS 0.07667f $ **FLOATING
C865 ldo_1v2_a_0.VDD.n30 IOVSS 0.02367f $ **FLOATING
C866 ldo_1v2_a_0.VDD.n31 IOVSS 0.07124f $ **FLOATING
C867 ldo_1v2_a_0.VDD.n32 IOVSS 0.03885f $ **FLOATING
C868 ldo_1v2_a_0.VDD.n33 IOVSS 0.06394f $ **FLOATING
C869 ldo_1v2_a_0.VDD.n34 IOVSS 0.03406f $ **FLOATING
C870 ldo_1v2_a_0.VDD.n40 IOVSS 0.01041f $ **FLOATING
C871 ldo_1v2_a_0.VDD.t91 IOVSS 10.5713f $ **FLOATING
C872 ldo_1v2_a_0.VDD.n120 IOVSS 0.02204f $ **FLOATING
C873 ldo_1v2_a_0.VDD.n141 IOVSS 0.01041f $ **FLOATING
C874 ldo_1v2_a_0.VDD.n142 IOVSS 0.01041f $ **FLOATING
C875 ldo_1v2_a_0.VDD.n143 IOVSS 0.01102f $ **FLOATING
C876 ldo_1v2_a_0.VDD.n144 IOVSS 0.01041f $ **FLOATING
C877 ldo_1v2_a_0.VDD.n145 IOVSS 0.01041f $ **FLOATING
C878 ldo_1v2_a_0.VDD.n146 IOVSS 0.01041f $ **FLOATING
C879 ldo_1v2_a_0.VDD.n147 IOVSS 0.01041f $ **FLOATING
C880 ldo_1v2_a_0.VDD.n148 IOVSS 0.01041f $ **FLOATING
C881 ldo_1v2_a_0.VDD.n149 IOVSS 0.01041f $ **FLOATING
C882 ldo_1v2_a_0.VDD.n150 IOVSS 0.01041f $ **FLOATING
C883 ldo_1v2_a_0.VDD.n151 IOVSS 0.01041f $ **FLOATING
C884 ldo_1v2_a_0.VDD.n152 IOVSS 0.01041f $ **FLOATING
C885 ldo_1v2_a_0.VDD.n153 IOVSS 0.01041f $ **FLOATING
C886 ldo_1v2_a_0.VDD.n154 IOVSS 0.01041f $ **FLOATING
C887 ldo_1v2_a_0.VDD.n155 IOVSS 0.01041f $ **FLOATING
C888 ldo_1v2_a_0.VDD.n156 IOVSS 0.01041f $ **FLOATING
C889 ldo_1v2_a_0.VDD.n157 IOVSS 0.01041f $ **FLOATING
C890 ldo_1v2_a_0.VDD.n158 IOVSS 0.01041f $ **FLOATING
C891 ldo_1v2_a_0.VDD.n159 IOVSS 0.01041f $ **FLOATING
C892 ldo_1v2_a_0.VDD.n160 IOVSS 0.01041f $ **FLOATING
C893 ldo_1v2_a_0.VDD.n161 IOVSS 0.01041f $ **FLOATING
C894 ldo_1v2_a_0.VDD.n162 IOVSS 0.01041f $ **FLOATING
C895 ldo_1v2_a_0.VDD.n163 IOVSS 0.01041f $ **FLOATING
C896 ldo_1v2_a_0.VDD.n164 IOVSS 0.01041f $ **FLOATING
C897 ldo_1v2_a_0.VDD.n165 IOVSS 0.01041f $ **FLOATING
C898 ldo_1v2_a_0.VDD.n166 IOVSS 0.01041f $ **FLOATING
C899 ldo_1v2_a_0.VDD.n167 IOVSS 0.01041f $ **FLOATING
C900 ldo_1v2_a_0.VDD.n168 IOVSS 0.01041f $ **FLOATING
C901 ldo_1v2_a_0.VDD.n169 IOVSS 0.01041f $ **FLOATING
C902 ldo_1v2_a_0.VDD.n170 IOVSS 0.01041f $ **FLOATING
C903 ldo_1v2_a_0.VDD.n171 IOVSS 0.01041f $ **FLOATING
C904 ldo_1v2_a_0.VDD.n172 IOVSS 0.01041f $ **FLOATING
C905 ldo_1v2_a_0.VDD.n173 IOVSS 0.01041f $ **FLOATING
C906 ldo_1v2_a_0.VDD.n174 IOVSS 0.01041f $ **FLOATING
C907 ldo_1v2_a_0.VDD.n175 IOVSS 0.01041f $ **FLOATING
C908 ldo_1v2_a_0.VDD.n176 IOVSS 0.01041f $ **FLOATING
C909 ldo_1v2_a_0.VDD.n177 IOVSS 0.01041f $ **FLOATING
C910 ldo_1v2_a_0.VDD.n178 IOVSS 0.01041f $ **FLOATING
C911 ldo_1v2_a_0.VDD.n179 IOVSS 0.01041f $ **FLOATING
C912 ldo_1v2_a_0.VDD.n180 IOVSS 0.01041f $ **FLOATING
C913 ldo_1v2_a_0.VDD.n181 IOVSS 0.01041f $ **FLOATING
C914 ldo_1v2_a_0.VDD.n182 IOVSS 0.01041f $ **FLOATING
C915 ldo_1v2_a_0.VDD.n185 IOVSS 0.40231f $ **FLOATING
C916 ldo_1v2_a_0.VDD.n186 IOVSS 0.24159f $ **FLOATING
C917 ldo_1v2_a_0.VDD.n187 IOVSS 0.01614f $ **FLOATING
C918 ldo_1v2_a_0.VDD.n188 IOVSS 0.0179f $ **FLOATING
C919 ldo_1v2_a_0.VDD.n189 IOVSS 0.01555f $ **FLOATING
C920 ldo_1v2_a_0.VDD.n190 IOVSS 0.01937f $ **FLOATING
C921 ldo_1v2_a_0.VDD.n192 IOVSS 14.288f $ **FLOATING
C922 ldo_1v2_a_0.VDD.n193 IOVSS 0.07654f $ **FLOATING
C923 ldo_1v2_a_0.VDD.n194 IOVSS 0.0491f $ **FLOATING
C924 ldo_1v2_a_0.VDD.n196 IOVSS 0.04497f $ **FLOATING
C925 ldo_1v2_a_0.VDD.n197 IOVSS 0.02028f $ **FLOATING
C926 ldo_1v2_a_0.VDD.n198 IOVSS 0.02028f $ **FLOATING
C927 ldo_1v2_a_0.VDD.n199 IOVSS 0.04057f $ **FLOATING
C928 ldo_1v2_a_0.VDD.n200 IOVSS 0.02867f $ **FLOATING
C929 ldo_1v2_a_0.VDD.n201 IOVSS 0.0403f $ **FLOATING
C930 ldo_1v2_a_0.VDD.n202 IOVSS 0.03196f $ **FLOATING
C931 ldo_1v2_a_0.VDD.n203 IOVSS 0.04057f $ **FLOATING
C932 ldo_1v2_a_0.VDD.n204 IOVSS 0.02028f $ **FLOATING
C933 ldo_1v2_a_0.VDD.t124 IOVSS 0.05717f $ **FLOATING
C934 ldo_1v2_a_0.VDD.n205 IOVSS 0.02028f $ **FLOATING
C935 ldo_1v2_a_0.VDD.n206 IOVSS 0.03218f $ **FLOATING
C936 ldo_1v2_a_0.VDD.t125 IOVSS 0.05717f $ **FLOATING
C937 ldo_1v2_a_0.VDD.n207 IOVSS 0.04273f $ **FLOATING
C938 ldo_1v2_a_0.VDD.t123 IOVSS 0.08774f $ **FLOATING
C939 ldo_1v2_a_0.VDD.n208 IOVSS 0.14196f $ **FLOATING
C940 ldo_1v2_a_0.VDD.n209 IOVSS 0.03316f $ **FLOATING
C941 ldo_1v2_a_0.VDD.t68 IOVSS 0.02428f $ **FLOATING
C942 ldo_1v2_a_0.VDD.n210 IOVSS 0.01939f $ **FLOATING
C943 ldo_1v2_a_0.VDD.t66 IOVSS 0.02428f $ **FLOATING
C944 ldo_1v2_a_0.VDD.n211 IOVSS 0.01797f $ **FLOATING
C945 ldo_1v2_a_0.VDD.t65 IOVSS 0.02428f $ **FLOATING
C946 ldo_1v2_a_0.VDD.n212 IOVSS 0.0415f $ **FLOATING
C947 ldo_1v2_a_0.VDD.n213 IOVSS 0.01967f $ **FLOATING
C948 ldo_1v2_a_0.VDD.n214 IOVSS 0.04233f $ **FLOATING
C949 ldo_1v2_a_0.VDD.n215 IOVSS 0.04233f $ **FLOATING
C950 ldo_1v2_a_0.VDD.t67 IOVSS 0.02428f $ **FLOATING
C951 ldo_1v2_a_0.VDD.n216 IOVSS 0.01946f $ **FLOATING
C952 ldo_1v2_a_0.VDD.n217 IOVSS 0.07232f $ **FLOATING
C953 ldo_1v2_a_0.VDD.n218 IOVSS 0.06234f $ **FLOATING
C954 ldo_1v2_a_0.VDD.t87 IOVSS 0.08774f $ **FLOATING
C955 ldo_1v2_a_0.VDD.n219 IOVSS 0.14292f $ **FLOATING
C956 ldo_1v2_a_0.VDD.n220 IOVSS 0.0309f $ **FLOATING
C957 ldo_1v2_a_0.VDD.n221 IOVSS 0.02171f $ **FLOATING
C958 ldo_1v2_a_0.VDD.n222 IOVSS 0.02201f $ **FLOATING
C959 ldo_1v2_a_0.VDD.n223 IOVSS 0.02201f $ **FLOATING
C960 ldo_1v2_a_0.VDD.n224 IOVSS 0.02201f $ **FLOATING
C961 ldo_1v2_a_0.VDD.n225 IOVSS 0.02201f $ **FLOATING
C962 ldo_1v2_a_0.VDD.n226 IOVSS 0.01995f $ **FLOATING
C963 ldo_1v2_a_0.VDD.t89 IOVSS 0.05717f $ **FLOATING
C964 ldo_1v2_a_0.VDD.n227 IOVSS 0.03756f $ **FLOATING
C965 ldo_1v2_a_0.VDD.n228 IOVSS 0.01995f $ **FLOATING
C966 ldo_1v2_a_0.VDD.n229 IOVSS 0.01995f $ **FLOATING
C967 ldo_1v2_a_0.VDD.n230 IOVSS 0.01995f $ **FLOATING
C968 ldo_1v2_a_0.VDD.t88 IOVSS 0.05717f $ **FLOATING
C969 ldo_1v2_a_0.VDD.n231 IOVSS 0.01995f $ **FLOATING
C970 ldo_1v2_a_0.VDD.n232 IOVSS 0.02201f $ **FLOATING
C971 ldo_1v2_a_0.VDD.n233 IOVSS 0.02201f $ **FLOATING
C972 ldo_1v2_a_0.VDD.n235 IOVSS 0.01041f $ **FLOATING
C973 ldo_1v2_a_0.VDD.n236 IOVSS 0.14237f $ **FLOATING
C974 ldo_1v2_a_0.VDD.n237 IOVSS 0.06766f $ **FLOATING
C975 ldo_1v2_a_0.VDD.n238 IOVSS 0.01041f $ **FLOATING
C976 ldo_1v2_a_0.VDD.n239 IOVSS 0.49783f $ **FLOATING
C977 ldo_1v2_a_0.VDD.n243 IOVSS 0.01733f $ **FLOATING
C978 ldo_1v2_a_0.VDD.n244 IOVSS 0.0201f $ **FLOATING
C979 ldo_1v2_a_0.VDD.n245 IOVSS 0.01175f $ **FLOATING
C980 ldo_1v2_a_0.VDD.n247 IOVSS 0.08879f $ **FLOATING
C981 ldo_1v2_a_0.VDD.t71 IOVSS 0.22044f $ **FLOATING
C982 ldo_1v2_a_0.VDD.n248 IOVSS 0.38118f $ **FLOATING
C983 ldo_1v2_a_0.VDD.n250 IOVSS 0.16183f $ **FLOATING
C984 ldo_1v2_a_0.VDD.n251 IOVSS 0.01041f $ **FLOATING
C985 ldo_1v2_a_0.VDD.n255 IOVSS 0.02733f $ **FLOATING
C986 ldo_1v2_a_0.VDD.n257 IOVSS 0.01578f $ **FLOATING
C987 ldo_1v2_a_0.VDD.n258 IOVSS 0.03872f $ **FLOATING
C988 ldo_1v2_a_0.VDD.n260 IOVSS 0.03366f $ **FLOATING
C989 ldo_1v2_a_0.VDD.n262 IOVSS 0.02835f $ **FLOATING
C990 ldo_1v2_a_0.VDD.t86 IOVSS 0.1041f $ **FLOATING
C991 ldo_1v2_a_0.VDD.n263 IOVSS 0.26647f $ **FLOATING
C992 ldo_1v2_a_0.VDD.n266 IOVSS 0.03439f $ **FLOATING
C993 ldo_1v2_a_0.VDD.n267 IOVSS 0.13533f $ **FLOATING
C994 ldo_1v2_a_0.VDD.n270 IOVSS 0.01041f $ **FLOATING
C995 ldo_1v2_a_0.VDD.n271 IOVSS 0.01041f $ **FLOATING
C996 ldo_1v2_a_0.VDD.n272 IOVSS 0.01041f $ **FLOATING
C997 ldo_1v2_a_0.VDD.n273 IOVSS 0.01041f $ **FLOATING
C998 ldo_1v2_a_0.VDD.n274 IOVSS 0.01041f $ **FLOATING
C999 ldo_1v2_a_0.VDD.n275 IOVSS 0.01041f $ **FLOATING
C1000 ldo_1v2_a_0.VDD.n276 IOVSS 0.01041f $ **FLOATING
C1001 ldo_1v2_a_0.VDD.n277 IOVSS 0.0147f $ **FLOATING
C1002 ldo_1v2_a_0.VDD.n278 IOVSS 0.01041f $ **FLOATING
C1003 ldo_1v2_a_0.VDD.n279 IOVSS 0.01041f $ **FLOATING
C1004 ldo_1v2_a_0.VDD.n280 IOVSS 0.01041f $ **FLOATING
C1005 ldo_1v2_a_0.VDD.n281 IOVSS 0.01041f $ **FLOATING
C1006 ldo_1v2_a_0.VDD.n282 IOVSS 0.01041f $ **FLOATING
C1007 ldo_1v2_a_0.VDD.n283 IOVSS 0.01041f $ **FLOATING
C1008 ldo_1v2_a_0.VDD.n284 IOVSS 0.01041f $ **FLOATING
C1009 ldo_1v2_a_0.VDD.n285 IOVSS 0.01041f $ **FLOATING
C1010 ldo_1v2_a_0.VDD.n286 IOVSS 0.01041f $ **FLOATING
C1011 ldo_1v2_a_0.VDD.n287 IOVSS 0.01041f $ **FLOATING
C1012 ldo_1v2_a_0.VDD.n288 IOVSS 0.01041f $ **FLOATING
C1013 ldo_1v2_a_0.VDD.n289 IOVSS 0.01041f $ **FLOATING
C1014 ldo_1v2_a_0.VDD.n296 IOVSS 0.01041f $ **FLOATING
C1015 ldo_1v2_a_0.VDD.n301 IOVSS 0.02082f $ **FLOATING
C1016 ldo_1v2_a_0.VDD.n329 IOVSS 0.24769f $ **FLOATING
C1017 ldo_1v2_a_0.VDD.n330 IOVSS 0.25596f $ **FLOATING
C1018 ldo_1v2_a_0.VDD.n335 IOVSS 0.01041f $ **FLOATING
C1019 ldo_1v2_a_0.VDD.n336 IOVSS 0.02057f $ **FLOATING
C1020 ldo_1v2_a_0.VDD.n337 IOVSS 0.01041f $ **FLOATING
C1021 ldo_1v2_a_0.VDD.n338 IOVSS 0.01378f $ **FLOATING
C1022 ldo_1v2_a_0.VDD.n339 IOVSS 0.01041f $ **FLOATING
C1023 ldo_1v2_a_0.VDD.n340 IOVSS 0.01041f $ **FLOATING
C1024 ldo_1v2_a_0.VDD.n341 IOVSS 0.01041f $ **FLOATING
C1025 ldo_1v2_a_0.VDD.n342 IOVSS 0.01041f $ **FLOATING
C1026 ldo_1v2_a_0.VDD.n343 IOVSS 0.01041f $ **FLOATING
C1027 ldo_1v2_a_0.VDD.n344 IOVSS 0.01041f $ **FLOATING
C1028 ldo_1v2_a_0.VDD.n345 IOVSS 0.01041f $ **FLOATING
C1029 ldo_1v2_a_0.VDD.n346 IOVSS 0.01041f $ **FLOATING
C1030 ldo_1v2_a_0.VDD.n347 IOVSS 0.01041f $ **FLOATING
C1031 ldo_1v2_a_0.VDD.n349 IOVSS 0.04694f $ **FLOATING
C1032 ldo_1v2_a_0.VDD.t137 IOVSS 0.14556f $ **FLOATING
C1033 ldo_1v2_a_0.VDD.t140 IOVSS 0.14549f $ **FLOATING
C1034 ldo_1v2_a_0.VDD.n350 IOVSS 0.04466f $ **FLOATING
C1035 ldo_1v2_a_0.VDD.n351 IOVSS 0.04011f $ **FLOATING
C1036 ldo_1v2_a_0.VDD.n352 IOVSS 0.01041f $ **FLOATING
C1037 ldo_1v2_a_0.VDD.n353 IOVSS 0.01041f $ **FLOATING
C1038 ldo_1v2_a_0.VDD.n354 IOVSS 0.01041f $ **FLOATING
C1039 ldo_1v2_a_0.VDD.n355 IOVSS 0.01041f $ **FLOATING
C1040 ldo_1v2_a_0.VDD.n357 IOVSS 0.01041f $ **FLOATING
C1041 ldo_1v2_a_0.VDD.n358 IOVSS 0.01041f $ **FLOATING
C1042 ldo_1v2_a_0.VDD.n359 IOVSS 0.01041f $ **FLOATING
C1043 ldo_1v2_a_0.VDD.n360 IOVSS 0.05266f $ **FLOATING
C1044 ldo_1v2_a_0.VDD.n361 IOVSS 0.08035f $ **FLOATING
C1045 ldo_1v2_a_0.VDD.n362 IOVSS 0.01128f $ **FLOATING
C1046 ldo_1v2_a_0.VDD.n363 IOVSS 0.01128f $ **FLOATING
C1047 ldo_1v2_a_0.VDD.n364 IOVSS 0.01128f $ **FLOATING
C1048 ldo_1v2_a_0.VDD.n365 IOVSS 0.02226f $ **FLOATING
C1049 ldo_1v2_a_0.VDD.n367 IOVSS 0.02135f $ **FLOATING
C1050 ldo_1v2_a_0.VDD.n368 IOVSS 0.01128f $ **FLOATING
C1051 ldo_1v2_a_0.VDD.n369 IOVSS 0.01128f $ **FLOATING
C1052 ldo_1v2_a_0.VDD.n370 IOVSS 0.01128f $ **FLOATING
C1053 ldo_1v2_a_0.VDD.n371 IOVSS 0.01128f $ **FLOATING
C1054 ldo_1v2_a_0.VDD.n372 IOVSS 0.01128f $ **FLOATING
C1055 ldo_1v2_a_0.VDD.n373 IOVSS 0.01128f $ **FLOATING
C1056 ldo_1v2_a_0.VDD.n374 IOVSS 0.01128f $ **FLOATING
C1057 ldo_1v2_a_0.VDD.n375 IOVSS 0.01128f $ **FLOATING
C1058 ldo_1v2_a_0.VDD.n376 IOVSS 0.01128f $ **FLOATING
C1059 ldo_1v2_a_0.VDD.n377 IOVSS 0.01128f $ **FLOATING
C1060 ldo_1v2_a_0.VDD.n378 IOVSS 0.01128f $ **FLOATING
C1061 ldo_1v2_a_0.VDD.n379 IOVSS 0.01128f $ **FLOATING
C1062 ldo_1v2_a_0.VDD.n380 IOVSS 0.01128f $ **FLOATING
C1063 ldo_1v2_a_0.VDD.n382 IOVSS 0.04285f $ **FLOATING
C1064 ldo_1v2_a_0.VDD.n383 IOVSS 0.03599f $ **FLOATING
C1065 ldo_1v2_a_0.VDD.t57 IOVSS 0.11637f $ **FLOATING
C1066 ldo_1v2_a_0.VDD.t61 IOVSS 0.14197f $ **FLOATING
C1067 ldo_1v2_a_0.VDD.n384 IOVSS 0.10077f $ **FLOATING
C1068 ldo_1v2_a_0.VDD.t59 IOVSS 0.09524f $ **FLOATING
C1069 ldo_1v2_a_0.VDD.t63 IOVSS 0.09526f $ **FLOATING
C1070 ldo_1v2_a_0.VDD.n385 IOVSS 0.09364f $ **FLOATING
C1071 ldo_1v2_a_0.VDD.n386 IOVSS 0.0705f $ **FLOATING
C1072 ldo_1v2_a_0.VDD.n389 IOVSS 0.01271f $ **FLOATING
C1073 ldo_1v2_a_0.VDD.n390 IOVSS 0.01556f $ **FLOATING
C1074 ldo_1v2_a_0.VDD.n391 IOVSS 0.04114f $ **FLOATING
C1075 ldo_1v2_a_0.VDD.n392 IOVSS 0.0699f $ **FLOATING
C1076 ldo_1v2_a_0.VDD.n394 IOVSS 0.0692f $ **FLOATING
C1077 ldo_1v2_a_0.VDD.n395 IOVSS 0.01401f $ **FLOATING
C1078 ldo_1v2_a_0.VDD.n397 IOVSS 0.0716f $ **FLOATING
C1079 ldo_1v2_a_0.VDD.n398 IOVSS 0.02053f $ **FLOATING
C1080 ldo_1v2_a_0.VDD.n399 IOVSS 0.01041f $ **FLOATING
C1081 ldo_1v2_a_0.VDD.n400 IOVSS 0.02827f $ **FLOATING
C1082 ldo_1v2_a_0.VDD.n402 IOVSS 0.01387f $ **FLOATING
C1083 ldo_1v2_a_0.VDD.n403 IOVSS 0.01378f $ **FLOATING
C1084 ldo_1v2_a_0.VDD.n404 IOVSS 0.01387f $ **FLOATING
C1085 ldo_1v2_a_0.VDD.n405 IOVSS 0.01387f $ **FLOATING
C1086 ldo_1v2_a_0.VDD.n406 IOVSS 0.01378f $ **FLOATING
C1087 ldo_1v2_a_0.VDD.n407 IOVSS 0.01378f $ **FLOATING
C1088 ldo_1v2_a_0.VDD.n408 IOVSS 0.01387f $ **FLOATING
C1089 ldo_1v2_a_0.VDD.n409 IOVSS 0.01387f $ **FLOATING
C1090 ldo_1v2_a_0.VDD.n410 IOVSS 0.01378f $ **FLOATING
C1091 ldo_1v2_a_0.VDD.n411 IOVSS 0.01387f $ **FLOATING
C1092 ldo_1v2_a_0.VDD.n412 IOVSS 0.01387f $ **FLOATING
C1093 ldo_1v2_a_0.VDD.t150 IOVSS 0.08675f $ **FLOATING
C1094 ldo_1v2_a_0.VDD.t153 IOVSS 0.09569f $ **FLOATING
C1095 ldo_1v2_a_0.VDD.t151 IOVSS 0.09572f $ **FLOATING
C1096 ldo_1v2_a_0.VDD.n414 IOVSS 0.14603f $ **FLOATING
C1097 ldo_1v2_a_0.VDD.n415 IOVSS 0.06244f $ **FLOATING
C1098 ldo_1v2_a_0.VDD.t152 IOVSS 0.08675f $ **FLOATING
C1099 ldo_1v2_a_0.VDD.n416 IOVSS 0.03224f $ **FLOATING
C1100 ldo_1v2_a_0.VDD.n417 IOVSS 0.07676f $ **FLOATING
C1101 ldo_1v2_a_0.VDD.n418 IOVSS 0.02356f $ **FLOATING
C1102 ldo_1v2_a_0.VDD.n419 IOVSS 0.07784f $ **FLOATING
C1103 ldo_1v2_a_0.VDD.n420 IOVSS 0.07124f $ **FLOATING
C1104 ldo_1v2_a_0.VDD.n421 IOVSS 0.03885f $ **FLOATING
C1105 ldo_1v2_a_0.VDD.t112 IOVSS 0.10619f $ **FLOATING
C1106 ldo_1v2_a_0.VDD.t115 IOVSS 0.10616f $ **FLOATING
C1107 ldo_1v2_a_0.VDD.t113 IOVSS 0.10619f $ **FLOATING
C1108 ldo_1v2_a_0.VDD.t116 IOVSS 0.10616f $ **FLOATING
C1109 ldo_1v2_a_0.VDD.n422 IOVSS 0.05073f $ **FLOATING
C1110 ldo_1v2_a_0.VDD.t111 IOVSS 0.52177f $ **FLOATING
C1111 ldo_1v2_a_0.VDD.n424 IOVSS 0.05597f $ **FLOATING
C1112 ldo_1v2_a_0.VDD.n425 IOVSS 0.06512f $ **FLOATING
C1113 ldo_1v2_a_0.VDD.n426 IOVSS 0.03288f $ **FLOATING
C1114 ldo_1v2_a_0.VDD.n427 IOVSS 0.02674f $ **FLOATING
C1115 ldo_1v2_a_0.VDD.n428 IOVSS 1.62485f $ **FLOATING
C1116 ldo_1v2_a_0.VDD.n429 IOVSS 0.69462f $ **FLOATING
C1117 ldo_1v2_a_0.VDD.t42 IOVSS 0.42219f $ **FLOATING
C1118 ldo_1v2_a_0.VDD.t53 IOVSS 0.42222f $ **FLOATING
C1119 ldo_1v2_a_0.VDD.t40 IOVSS 0.46125f $ **FLOATING
C1120 ldo_1v2_a_0.VDD.t36 IOVSS 0.45998f $ **FLOATING
C1121 ldo_1v2_a_0.VDD.t37 IOVSS 0.46125f $ **FLOATING
C1122 ldo_1v2_a_0.VDD.t45 IOVSS 0.45998f $ **FLOATING
C1123 ldo_1v2_a_0.VDD.t38 IOVSS 0.46125f $ **FLOATING
C1124 ldo_1v2_a_0.VDD.t49 IOVSS 0.45998f $ **FLOATING
C1125 ldo_1v2_a_0.VDD.t46 IOVSS 0.46125f $ **FLOATING
C1126 ldo_1v2_a_0.VDD.t41 IOVSS 0.45998f $ **FLOATING
C1127 ldo_1v2_a_0.VDD.t52 IOVSS 0.42219f $ **FLOATING
C1128 ldo_1v2_a_0.VDD.t44 IOVSS 0.42222f $ **FLOATING
C1129 ldo_1v2_a_0.VDD.t35 IOVSS 36.1858f $ **FLOATING
C1130 ldo_1v2_a_0.VDD.n431 IOVSS 0.08481f $ **FLOATING
C1131 ldo_1v2_a_0.VDD.n433 IOVSS 0.12318f $ **FLOATING
C1132 ldo_1v2_a_0.VDD.n434 IOVSS 0.0948f $ **FLOATING
C1133 ldo_1v2_a_0.VDD.n435 IOVSS 0.07252f $ **FLOATING
C1134 ldo_1v2_a_0.VDD.n436 IOVSS 0.07279f $ **FLOATING
C1135 ldo_1v2_a_0.VDD.n437 IOVSS 0.07279f $ **FLOATING
C1136 ldo_1v2_a_0.VDD.n438 IOVSS 0.07252f $ **FLOATING
C1137 ldo_1v2_a_0.VDD.n439 IOVSS 0.0948f $ **FLOATING
C1138 ldo_1v2_a_0.VDD.n440 IOVSS 0.17405f $ **FLOATING
C1139 ldo_1v2_a_0.VDD.n441 IOVSS 0.43015f $ **FLOATING
C1140 ldo_1v2_a_0.VDD.n442 IOVSS 0.14769f $ **FLOATING
C1141 ldo_1v2_a_0.VDD.n443 IOVSS 0.11183f $ **FLOATING
C1142 ldo_1v2_a_0.VDD.n444 IOVSS 0.13804f $ **FLOATING
C1143 ldo_1v2_a_0.VDD.n445 IOVSS 0.148f $ **FLOATING
C1144 ldo_1v2_a_0.VDD.n446 IOVSS 0.15724f $ **FLOATING
C1145 ldo_1v2_a_0.VDD.n447 IOVSS 0.06324f $ **FLOATING
C1146 ldo_1v2_a_0.VDD.n448 IOVSS 0.06825f $ **FLOATING
C1147 ldo_1v2_a_0.VDD.t107 IOVSS 0.10616f $ **FLOATING
C1148 ldo_1v2_a_0.VDD.t110 IOVSS 0.10619f $ **FLOATING
C1149 ldo_1v2_a_0.VDD.t106 IOVSS 0.10616f $ **FLOATING
C1150 ldo_1v2_a_0.VDD.t109 IOVSS 0.10619f $ **FLOATING
C1151 ldo_1v2_a_0.VDD.n449 IOVSS 0.05083f $ **FLOATING
C1152 ldo_1v2_a_0.VDD.t104 IOVSS 0.52177f $ **FLOATING
C1153 ldo_1v2_a_0.VDD.n451 IOVSS 0.05592f $ **FLOATING
C1154 ldo_1v2_a_0.VDD.n452 IOVSS 0.09356f $ **FLOATING
C1155 ldo_1v2_a_0.VDD.n453 IOVSS 0.03842f $ **FLOATING
C1156 ldo_1v2_a_0.VDD.n454 IOVSS 0.73787f $ **FLOATING
C1157 ldo_1v2_a_0.VDD.t105 IOVSS 10.6824f $ **FLOATING
C1158 ldo_1v2_a_0.VDD.n456 IOVSS 0.42619f $ **FLOATING
C1159 ldo_1v2_a_0.VDD.n457 IOVSS 0.08879f $ **FLOATING
C1160 ldo_1v2_a_0.VDD.n458 IOVSS 1.08549f $ **FLOATING
C1161 ldo_1v2_a_0.VDD.n459 IOVSS 1.04387f $ **FLOATING
C1162 ldo_1v2_a_0.VDD.n460 IOVSS 0.02539f $ **FLOATING
C1163 ldo_1v2_a_0.VDD.n462 IOVSS 0.01041f $ **FLOATING
C1164 ldo_1v2_a_0.VDD.n465 IOVSS 0.12333f $ **FLOATING
C1165 ldo_1v2_a_0.VDD.n466 IOVSS 0.11695f $ **FLOATING
C1166 ldo_1v2_a_0.VDD.n467 IOVSS 0.03727f $ **FLOATING
C1167 ldo_1v2_a_0.VDD.t62 IOVSS 3.71825f $ **FLOATING
C1168 ldo_1v2_a_0.VDD.t95 IOVSS 0.0694f $ **FLOATING
C1169 ldo_1v2_a_0.VDD.n473 IOVSS 0.022f $ **FLOATING
C1170 ldo_1v2_a_0.VDD.n474 IOVSS 0.022f $ **FLOATING
C1171 ldo_1v2_a_0.VDD.n475 IOVSS 0.022f $ **FLOATING
C1172 ldo_1v2_a_0.VDD.n476 IOVSS 0.022f $ **FLOATING
C1173 ldo_1v2_a_0.VDD.n477 IOVSS 0.022f $ **FLOATING
C1174 ldo_1v2_a_0.VDD.n478 IOVSS 0.022f $ **FLOATING
C1175 ldo_1v2_a_0.VDD.n479 IOVSS 0.022f $ **FLOATING
C1176 ldo_1v2_a_0.VDD.n480 IOVSS 0.022f $ **FLOATING
C1177 ldo_1v2_a_0.VDD.n481 IOVSS 0.011f $ **FLOATING
C1178 ldo_1v2_a_0.VDD.t78 IOVSS 0.24915f $ **FLOATING
C1179 ldo_1v2_a_0.VDD.t80 IOVSS 0.0694f $ **FLOATING
C1180 ldo_1v2_a_0.VDD.n482 IOVSS 0.022f $ **FLOATING
C1181 ldo_1v2_a_0.VDD.n483 IOVSS 0.022f $ **FLOATING
C1182 ldo_1v2_a_0.VDD.n484 IOVSS 0.022f $ **FLOATING
C1183 ldo_1v2_a_0.VDD.n485 IOVSS 0.022f $ **FLOATING
C1184 ldo_1v2_a_0.VDD.n486 IOVSS 0.022f $ **FLOATING
C1185 ldo_1v2_a_0.VDD.n487 IOVSS 0.022f $ **FLOATING
C1186 ldo_1v2_a_0.VDD.n488 IOVSS 0.022f $ **FLOATING
C1187 ldo_1v2_a_0.VDD.n489 IOVSS 0.022f $ **FLOATING
C1188 ldo_1v2_a_0.VDD.n490 IOVSS 0.011f $ **FLOATING
C1189 ldo_1v2_a_0.VDD.n491 IOVSS 0.03745f $ **FLOATING
C1190 ldo_1v2_a_0.VDD.t81 IOVSS 0.0694f $ **FLOATING
C1191 ldo_1v2_a_0.VDD.n492 IOVSS 0.011f $ **FLOATING
C1192 ldo_1v2_a_0.VDD.n493 IOVSS 0.04826f $ **FLOATING
C1193 ldo_1v2_a_0.VDD.n494 IOVSS 0.07037f $ **FLOATING
C1194 ldo_1v2_a_0.VDD.n495 IOVSS 0.04753f $ **FLOATING
C1195 ldo_1v2_a_0.VDD.t96 IOVSS 0.0694f $ **FLOATING
C1196 ldo_1v2_a_0.VDD.n496 IOVSS 0.011f $ **FLOATING
C1197 ldo_1v2_a_0.VDD.n497 IOVSS 0.04028f $ **FLOATING
C1198 ldo_1v2_a_0.VDD.n498 IOVSS 0.05197f $ **FLOATING
C1199 ldo_1v2_a_0.VDD.n499 IOVSS 0.01039f $ **FLOATING
C1200 ldo_1v2_a_0.VDD.n507 IOVSS 0.0175f $ **FLOATING
C1201 ldo_1v2_a_0.VDD.t127 IOVSS 0.0694f $ **FLOATING
C1202 ldo_1v2_a_0.VDD.n509 IOVSS 0.02011f $ **FLOATING
C1203 ldo_1v2_a_0.VDD.n510 IOVSS 0.02011f $ **FLOATING
C1204 ldo_1v2_a_0.VDD.n511 IOVSS 0.02011f $ **FLOATING
C1205 ldo_1v2_a_0.VDD.n512 IOVSS 0.02011f $ **FLOATING
C1206 ldo_1v2_a_0.VDD.n513 IOVSS 0.02011f $ **FLOATING
C1207 ldo_1v2_a_0.VDD.n514 IOVSS 0.02011f $ **FLOATING
C1208 ldo_1v2_a_0.VDD.n515 IOVSS 0.02011f $ **FLOATING
C1209 ldo_1v2_a_0.VDD.n516 IOVSS 0.02011f $ **FLOATING
C1210 ldo_1v2_a_0.VDD.n517 IOVSS 0.01005f $ **FLOATING
C1211 ldo_1v2_a_0.VDD.t100 IOVSS 0.24915f $ **FLOATING
C1212 ldo_1v2_a_0.VDD.t102 IOVSS 0.0694f $ **FLOATING
C1213 ldo_1v2_a_0.VDD.n518 IOVSS 0.02011f $ **FLOATING
C1214 ldo_1v2_a_0.VDD.n519 IOVSS 0.02011f $ **FLOATING
C1215 ldo_1v2_a_0.VDD.n520 IOVSS 0.02011f $ **FLOATING
C1216 ldo_1v2_a_0.VDD.n521 IOVSS 0.02011f $ **FLOATING
C1217 ldo_1v2_a_0.VDD.n522 IOVSS 0.02011f $ **FLOATING
C1218 ldo_1v2_a_0.VDD.n523 IOVSS 0.02011f $ **FLOATING
C1219 ldo_1v2_a_0.VDD.n524 IOVSS 0.02011f $ **FLOATING
C1220 ldo_1v2_a_0.VDD.n525 IOVSS 0.02011f $ **FLOATING
C1221 ldo_1v2_a_0.VDD.n526 IOVSS 0.01005f $ **FLOATING
C1222 ldo_1v2_a_0.VDD.n527 IOVSS 0.12164f $ **FLOATING
C1223 ldo_1v2_a_0.VDD.n528 IOVSS 0.03424f $ **FLOATING
C1224 ldo_1v2_a_0.VDD.t103 IOVSS 0.0694f $ **FLOATING
C1225 ldo_1v2_a_0.VDD.n529 IOVSS 0.01005f $ **FLOATING
C1226 ldo_1v2_a_0.VDD.n530 IOVSS 0.0441f $ **FLOATING
C1227 ldo_1v2_a_0.VDD.n531 IOVSS 0.06435f $ **FLOATING
C1228 ldo_1v2_a_0.VDD.n532 IOVSS 0.04344f $ **FLOATING
C1229 ldo_1v2_a_0.VDD.t128 IOVSS 0.0694f $ **FLOATING
C1230 ldo_1v2_a_0.VDD.n533 IOVSS 0.01005f $ **FLOATING
C1231 ldo_1v2_a_0.VDD.n534 IOVSS 0.03274f $ **FLOATING
C1232 ldo_1v2_a_0.VDD.n535 IOVSS 0.07817f $ **FLOATING
C1233 ldo_1v2_a_0.VDD.t101 IOVSS 1.45044f $ **FLOATING
C1234 ldo_1v2_a_0.VDD.n539 IOVSS 0.0333f $ **FLOATING
C1235 ldo_1v2_a_0.VDD.n540 IOVSS 0.01692f $ **FLOATING
C1236 ldo_1v2_a_0.VDD.n542 IOVSS 0.72522f $ **FLOATING
C1237 ldo_1v2_a_0.VDD.n544 IOVSS 0.01041f $ **FLOATING
C1238 ldo_1v2_a_0.VDD.t58 IOVSS 0.83187f $ **FLOATING
C1239 ldo_1v2_a_0.VDD.n546 IOVSS 0.03914f $ **FLOATING
C1240 ldo_1v2_a_0.VDD.n547 IOVSS 0.02304f $ **FLOATING
C1241 ldo_1v2_a_0.VDD.t31 IOVSS 1.45044f $ **FLOATING
C1242 ldo_1v2_a_0.VDD.n549 IOVSS 0.01214f $ **FLOATING
C1243 ldo_1v2_a_0.VDD.t79 IOVSS 0.72522f $ **FLOATING
C1244 ldo_1v2_a_0.VDD.n551 IOVSS 0.72522f $ **FLOATING
C1245 ldo_1v2_a_0.VDD.n553 IOVSS 0.01041f $ **FLOATING
C1246 ldo_1v2_a_0.VDD.n554 IOVSS 0.72522f $ **FLOATING
C1247 ldo_1v2_a_0.VDD.n556 IOVSS 0.01041f $ **FLOATING
C1248 ldo_1v2_a_0.VDD.n558 IOVSS 0.01041f $ **FLOATING
C1249 ldo_1v2_a_0.VDD.n559 IOVSS 0.01041f $ **FLOATING
C1250 ldo_1v2_a_0.VDD.n560 IOVSS 0.72522f $ **FLOATING
C1251 ldo_1v2_a_0.VDD.n562 IOVSS 0.01041f $ **FLOATING
C1252 ldo_1v2_a_0.VDD.n563 IOVSS 0.72522f $ **FLOATING
C1253 ldo_1v2_a_0.VDD.n565 IOVSS 0.01561f $ **FLOATING
C1254 ldo_1v2_a_0.VDD.n566 IOVSS 0.01041f $ **FLOATING
C1255 ldo_1v2_a_0.VDD.n568 IOVSS 0.02716f $ **FLOATING
C1256 ldo_1v2_a_0.VDD.n569 IOVSS 0.01452f $ **FLOATING
C1257 ldo_1v2_a_0.VDD.n571 IOVSS 0.01561f $ **FLOATING
C1258 ldo_1v2_a_0.VDD.n572 IOVSS 0.79987f $ **FLOATING
C1259 ldo_1v2_a_0.VDD.n574 IOVSS 0.01347f $ **FLOATING
C1260 ldo_1v2_a_0.VDD.n577 IOVSS 0.01041f $ **FLOATING
C1261 ldo_1v2_a_0.VDD.n578 IOVSS 0.72522f $ **FLOATING
C1262 ldo_1v2_a_0.VDD.n580 IOVSS 0.01041f $ **FLOATING
C1263 ldo_1v2_a_0.VDD.t32 IOVSS 0.72522f $ **FLOATING
C1264 ldo_1v2_a_0.VDD.n582 IOVSS 0.01041f $ **FLOATING
C1265 ldo_1v2_a_0.VDD.n583 IOVSS 0.01041f $ **FLOATING
C1266 ldo_1v2_a_0.VDD.n585 IOVSS 0.01041f $ **FLOATING
C1267 ldo_1v2_a_0.VDD.t56 IOVSS 0.72522f $ **FLOATING
C1268 ldo_1v2_a_0.VDD.n587 IOVSS 0.01561f $ **FLOATING
C1269 ldo_1v2_a_0.VDD.n589 IOVSS 0.01128f $ **FLOATING
C1270 ldo_1v2_a_0.VDD.n590 IOVSS 0.07545f $ **FLOATING
C1271 ldo_1v2_a_0.VDD.n591 IOVSS 0.02122f $ **FLOATING
C1272 ldo_1v2_a_0.VDD.n593 IOVSS 0.01924f $ **FLOATING
C1273 ldo_1v2_a_0.VDD.n594 IOVSS 0.01911f $ **FLOATING
C1274 ldo_1v2_a_0.VDD.n595 IOVSS 0.01924f $ **FLOATING
C1275 ldo_1v2_a_0.VDD.n596 IOVSS 0.01924f $ **FLOATING
C1276 ldo_1v2_a_0.VDD.n597 IOVSS 0.01911f $ **FLOATING
C1277 ldo_1v2_a_0.VDD.n599 IOVSS 0.01924f $ **FLOATING
C1278 ldo_1v2_a_0.VDD.n600 IOVSS 0.01924f $ **FLOATING
C1279 ldo_1v2_a_0.VDD.n601 IOVSS 0.01911f $ **FLOATING
C1280 ldo_1v2_a_0.VDD.n602 IOVSS 0.01924f $ **FLOATING
C1281 ldo_1v2_a_0.VDD.t131 IOVSS 0.08675f $ **FLOATING
C1282 ldo_1v2_a_0.VDD.n603 IOVSS 0.01924f $ **FLOATING
C1283 ldo_1v2_a_0.VDD.n604 IOVSS 0.01911f $ **FLOATING
C1284 ldo_1v2_a_0.VDD.t130 IOVSS 0.08675f $ **FLOATING
C1285 ldo_1v2_a_0.VDD.n605 IOVSS 0.02202f $ **FLOATING
C1286 ldo_1v2_a_0.VDD.t129 IOVSS 0.13201f $ **FLOATING
C1287 ldo_1v2_a_0.VDD.n606 IOVSS 0.03317f $ **FLOATING
C1288 ldo_1v2_a_0.VDD.n607 IOVSS 0.07321f $ **FLOATING
C1289 ldo_1v2_a_0.VDD.n608 IOVSS 0.03096f $ **FLOATING
C1290 ldo_1v2_a_0.VDD.n609 IOVSS 0.03474f $ **FLOATING
C1291 ldo_1v2_a_0.VDD.n610 IOVSS 0.01561f $ **FLOATING
C1292 ldo_1v2_a_0.VDD.t64 IOVSS 0.72522f $ **FLOATING
C1293 ldo_1v2_a_0.VDD.n613 IOVSS 0.71644f $ **FLOATING
C1294 ldo_1v2_a_0.VDD.n614 IOVSS 0.10254f $ **FLOATING
C1295 ldo_1v2_a_0.VDD.n615 IOVSS 0.06448f $ **FLOATING
C1296 ldo_1v2_a_0.VDD.n616 IOVSS 0.01603f $ **FLOATING
C1297 ldo_1v2_a_0.VDD.n617 IOVSS 0.02491f $ **FLOATING
C1298 ldo_1v2_a_0.VDD.n619 IOVSS 0.01924f $ **FLOATING
C1299 ldo_1v2_a_0.VDD.n620 IOVSS 0.01911f $ **FLOATING
C1300 ldo_1v2_a_0.VDD.n621 IOVSS 0.01924f $ **FLOATING
C1301 ldo_1v2_a_0.VDD.n622 IOVSS 0.01924f $ **FLOATING
C1302 ldo_1v2_a_0.VDD.n623 IOVSS 0.01911f $ **FLOATING
C1303 ldo_1v2_a_0.VDD.n624 IOVSS 0.01911f $ **FLOATING
C1304 ldo_1v2_a_0.VDD.n625 IOVSS 0.01924f $ **FLOATING
C1305 ldo_1v2_a_0.VDD.n626 IOVSS 0.01924f $ **FLOATING
C1306 ldo_1v2_a_0.VDD.n627 IOVSS 0.01911f $ **FLOATING
C1307 ldo_1v2_a_0.VDD.n628 IOVSS 0.01924f $ **FLOATING
C1308 ldo_1v2_a_0.VDD.n629 IOVSS 0.01924f $ **FLOATING
C1309 ldo_1v2_a_0.VDD.t84 IOVSS 0.08675f $ **FLOATING
C1310 ldo_1v2_a_0.VDD.n631 IOVSS 0.03887f $ **FLOATING
C1311 ldo_1v2_a_0.VDD.t83 IOVSS 0.08675f $ **FLOATING
C1312 ldo_1v2_a_0.VDD.n632 IOVSS 0.02189f $ **FLOATING
C1313 ldo_1v2_a_0.VDD.t82 IOVSS 0.13193f $ **FLOATING
C1314 ldo_1v2_a_0.VDD.n633 IOVSS 0.03317f $ **FLOATING
C1315 ldo_1v2_a_0.VDD.n634 IOVSS 0.0601f $ **FLOATING
C1316 ldo_1v2_a_0.VDD.n635 IOVSS 0.02776f $ **FLOATING
C1317 ldo_1v2_a_0.VDD.n636 IOVSS 0.33403f $ **FLOATING
C1318 ldo_1v2_a_0.VDD.n637 IOVSS 15.424f $ **FLOATING
C1319 ldo_1v2_a_0.VDD.n638 IOVSS 0.0454f $ **FLOATING
C1320 ldo_1v2_a_0.VDD.n639 IOVSS 0.09715f $ **FLOATING
C1321 ldo_1v2_a_0.VDD.n640 IOVSS 0.01089f $ **FLOATING
C1322 ldo_1v2_a_0.VDD.n641 IOVSS 0.04598f $ **FLOATING
C1323 ldo_1v2_a_0.VDD.n642 IOVSS 0.01128f $ **FLOATING
C1324 ldo_1v2_a_0.VDD.n643 IOVSS 0.01128f $ **FLOATING
C1325 ldo_1v2_a_0.VDD.n644 IOVSS 0.01035f $ **FLOATING
C1326 ldo_1v2_a_0.VDD.n645 IOVSS 0.01041f $ **FLOATING
C1327 ldo_1v2_a_0.VDD.n646 IOVSS 0.01041f $ **FLOATING
C1328 ldo_1v2_a_0.VDD.t85 IOVSS 0.64199f $ **FLOATING
C1329 ldo_1v2_a_0.VDD.n648 IOVSS 0.23149f $ **FLOATING
C1330 ldo_1v2_a_0.VDD.n649 IOVSS 0.04825f $ **FLOATING
C1331 ldo_1v2_a_0.VDD.t72 IOVSS 0.14386f $ **FLOATING
C1332 ldo_1v2_a_0.VDD.n650 IOVSS 0.0969f $ **FLOATING
C1333 ldo_1v2_a_0.VDD.n651 IOVSS 0.06351f $ **FLOATING
C1334 ldo_1v2_a_0.VDD.t132 IOVSS 0.64185f $ **FLOATING
C1335 ldo_1v2_a_0.VDD.n652 IOVSS 0.27185f $ **FLOATING
C1336 ldo_1v2_a_0.VDD.n653 IOVSS 0.04752f $ **FLOATING
C1337 ldo_1v2_a_0.VDD.n654 IOVSS 0.07946f $ **FLOATING
C1338 ldo_1v2_a_0.VDD.t74 IOVSS 0.14369f $ **FLOATING
C1339 ldo_1v2_a_0.VDD.n655 IOVSS 0.05907f $ **FLOATING
C1340 ldo_1v2_a_0.VDD.n656 IOVSS 0.03907f $ **FLOATING
C1341 ldo_1v2_a_0.VDD.n657 IOVSS 0.01907f $ **FLOATING
C1342 ldo_1v2_a_0.VDD.n658 IOVSS 0.07008f $ **FLOATING
C1343 ldo_1v2_a_0.VDD.n660 IOVSS 0.08492f $ **FLOATING
C1344 ldo_1v2_a_0.VDD.n661 IOVSS 0.01041f $ **FLOATING
C1345 ldo_1v2_a_0.VDD.n662 IOVSS 0.03294f $ **FLOATING
C1346 ldo_1v2_a_0.VDD.n663 IOVSS 0.02418f $ **FLOATING
C1347 ldo_1v2_a_0.VDD.n664 IOVSS 0.02253f $ **FLOATING
C1348 ldo_1v2_a_0.VDD.n665 IOVSS 0.45528f $ **FLOATING
C1349 ldo_1v2_a_0.VDD.n667 IOVSS 0.04928f $ **FLOATING
C1350 ldo_1v2_a_0.VDD.t139 IOVSS 0.14549f $ **FLOATING
C1351 ldo_1v2_a_0.VDD.t138 IOVSS 0.14554f $ **FLOATING
C1352 ldo_1v2_a_0.VDD.n668 IOVSS 0.06561f $ **FLOATING
C1353 ldo_1v2_a_0.VDD.n669 IOVSS 0.06406f $ **FLOATING
C1354 ldo_1v2_a_0.VDD.n670 IOVSS 0.0456f $ **FLOATING
C1355 ldo_1v2_a_0.VDD.n671 IOVSS 0.04411f $ **FLOATING
C1356 ldo_1v2_a_0.VDD.n672 IOVSS 0.06424f $ **FLOATING
C1357 ldo_1v2_a_0.VDD.n673 IOVSS 0.06591f $ **FLOATING
C1358 ldo_1v2_a_0.VDD.n674 IOVSS 0.04396f $ **FLOATING
C1359 ldo_1v2_a_0.VDD.n675 IOVSS 0.01816f $ **FLOATING
C1360 ldo_1v2_a_0.VDD.n677 IOVSS 0.01109f $ **FLOATING
C1361 ldo_1v2_a_0.VDD.n678 IOVSS 0.01115f $ **FLOATING
C1362 ldo_1v2_a_0.VDD.n679 IOVSS 0.01057f $ **FLOATING
C1363 ldo_1v2_a_0.VDD.n681 IOVSS 0.01041f $ **FLOATING
C1364 ldo_1v2_a_0.VDD.t60 IOVSS 15.4814f $ **FLOATING
C1365 ldo_1v2_a_0.VDD.n684 IOVSS 0.01041f $ **FLOATING
C1366 ldo_1v2_a_0.VDD.n685 IOVSS 0.01169f $ **FLOATING
C1367 ldo_1v2_a_0.VDD.n687 IOVSS 0.01041f $ **FLOATING
C1368 ldo_1v2_a_0.VDD.n688 IOVSS 0.01041f $ **FLOATING
C1369 ldo_1v2_a_0.VDD.n689 IOVSS 0.01041f $ **FLOATING
C1370 ldo_1v2_a_0.VDD.n690 IOVSS 0.01041f $ **FLOATING
C1371 ldo_1v2_a_0.VDD.n691 IOVSS 0.01041f $ **FLOATING
C1372 ldo_1v2_a_0.VDD.n692 IOVSS 0.01041f $ **FLOATING
C1373 ldo_1v2_a_0.VDD.n693 IOVSS 0.01041f $ **FLOATING
C1374 ldo_1v2_a_0.VDD.n694 IOVSS 0.01041f $ **FLOATING
C1375 ldo_1v2_a_0.VDD.n695 IOVSS 0.01041f $ **FLOATING
C1376 ldo_1v2_a_0.VDD.n696 IOVSS 0.01041f $ **FLOATING
C1377 ldo_1v2_a_0.VDD.n697 IOVSS 0.0121f $ **FLOATING
C1378 ldo_1v2_a_0.VDD.n698 IOVSS 0.01132f $ **FLOATING
C1379 ldo_1v2_a_0.VDD.n699 IOVSS 0.0121f $ **FLOATING
C1380 ldo_1v2_a_0.VDD.n700 IOVSS 0.01041f $ **FLOATING
C1381 ldo_1v2_a_0.VDD.n701 IOVSS 0.01041f $ **FLOATING
C1382 ldo_1v2_a_0.VDD.n702 IOVSS 0.01041f $ **FLOATING
C1383 ldo_1v2_a_0.VDD.n703 IOVSS 0.01041f $ **FLOATING
C1384 ldo_1v2_a_0.VDD.n706 IOVSS 0.09673f $ **FLOATING
C1385 ldo_1v2_a_0.VDD.n707 IOVSS 0.1276f $ **FLOATING
C1386 ldo_1v2_a_0.VDD.n709 IOVSS 0.09951f $ **FLOATING
C1387 ldo_1v2_a_0.VDD.n712 IOVSS 1.458f $ **FLOATING
C1388 ldo_1v2_a_0.VDD.n714 IOVSS 0.01041f $ **FLOATING
C1389 ldo_1v2_a_0.VDD.n715 IOVSS 0.02949f $ **FLOATING
C1390 ldo_1v2_a_0.VDD.n716 IOVSS 0.24123f $ **FLOATING
C1391 ldo_1v2_a_0.VDD.n717 IOVSS 0.0157f $ **FLOATING
C1392 ldo_1v2_a_0.VDD.t135 IOVSS 0.01737f $ **FLOATING
C1393 ldo_1v2_a_0.VDD.t134 IOVSS 0.05121f $ **FLOATING
C1394 ldo_1v2_a_0.VDD.n719 IOVSS 0.12084f $ **FLOATING
C1395 ldo_1v2_a_0.VDD.n720 IOVSS 0.03257f $ **FLOATING
C1396 ldo_1v2_a_0.VDD.n721 IOVSS 0.03573f $ **FLOATING
C1397 ldo_1v2_a_0.VDD.n722 IOVSS 0.01119f $ **FLOATING
C1398 ldo_1v2_a_0.VDD.n723 IOVSS 0.08279f $ **FLOATING
C1399 ldo_1v2_a_0.VDD.n724 IOVSS 0.0891f $ **FLOATING
C1400 ldo_1v2_a_0.VDD.n725 IOVSS 0.13757f $ **FLOATING
C1401 ldo_1v2_a_0.VDD.n726 IOVSS 0.02798f $ **FLOATING
C1402 ldo_1v2_a_0.VDD.n727 IOVSS 0.03695f $ **FLOATING
C1403 ldo_1v2_a_0.VDD.n728 IOVSS 0.02728f $ **FLOATING
C1404 ldo_1v2_a_0.VDD.n730 IOVSS 0.02732f $ **FLOATING
C1405 ldo_1v2_a_0.VDD.n732 IOVSS 0.03164f $ **FLOATING
C1406 ldo_1v2_a_0.VDD.n734 IOVSS 0.03935f $ **FLOATING
C1407 ldo_1v2_a_0.VDD.n735 IOVSS 0.01468f $ **FLOATING
C1408 ldo_1v2_a_0.VDD.n736 IOVSS 0.03093f $ **FLOATING
C1409 ldo_1v2_a_0.VDD.n738 IOVSS 0.37521f $ **FLOATING
C1410 ldo_1v2_a_0.VDD.n739 IOVSS 0.03212f $ **FLOATING
C1411 ldo_1v2_a_0.VDD.n740 IOVSS 0.11326f $ **FLOATING
C1412 ldo_1v2_a_0.VDD.n741 IOVSS 0.05605f $ **FLOATING
C1413 ldo_1v2_a_0.VDD.n742 IOVSS 0.07253f $ **FLOATING
C1414 ldo_1v2_a_0.VDD.n744 IOVSS 0.26832f $ **FLOATING
C1415 ldo_1v2_a_0.VDD.t33 IOVSS 16.8277f $ **FLOATING
C1416 ldo_1v2_a_0.VDD.n745 IOVSS 0.63194f $ **FLOATING
C1417 ldo_1v2_a_0.VDD.n746 IOVSS 0.04222f $ **FLOATING
C1418 ldo_1v2_a_0.VDD.n747 IOVSS 0.15612f $ **FLOATING
C1419 ldo_1v2_a_0.VDD.n748 IOVSS 0.07598f $ **FLOATING
C1420 ldo_1v2_a_0.VDD.n749 IOVSS 0.01547f $ **FLOATING
C1421 ldo_1v2_a_0.VDD.n750 IOVSS 1.04492f $ **FLOATING
C1422 ldo_1v2_a_0.VDD.n751 IOVSS 0.88785f $ **FLOATING
C1423 ldo_1v2_a_0.VDD.n752 IOVSS 0.07652f $ **FLOATING
C1424 ldo_1v2_a_0.VDD.n753 IOVSS 0.01041f $ **FLOATING
C1425 ldo_1v2_a_0.VDD.n754 IOVSS 0.01735f $ **FLOATING
C1426 ldo_1v2_a_0.VDD.n755 IOVSS 0.01041f $ **FLOATING
C1427 ldo_1v2_a_0.VDD.n756 IOVSS 0.01041f $ **FLOATING
C1428 ldo_1v2_a_0.VDD.n757 IOVSS 0.01041f $ **FLOATING
C1429 ldo_1v2_a_0.VDD.n758 IOVSS 0.01041f $ **FLOATING
C1430 ldo_1v2_a_0.VDD.n759 IOVSS 0.01041f $ **FLOATING
C1431 ldo_1v2_a_0.VDD.n760 IOVSS 0.01041f $ **FLOATING
C1432 ldo_1v2_a_0.VDD.n761 IOVSS 0.01041f $ **FLOATING
C1433 ldo_1v2_a_0.VDD.n762 IOVSS 0.01041f $ **FLOATING
C1434 ldo_1v2_a_0.VDD.n763 IOVSS 0.01041f $ **FLOATING
C1435 ldo_1v2_a_0.VDD.n764 IOVSS 0.01041f $ **FLOATING
C1436 ldo_1v2_a_0.VDD.n765 IOVSS 0.01041f $ **FLOATING
C1437 ldo_1v2_a_0.VDD.n766 IOVSS 0.01041f $ **FLOATING
C1438 ldo_1v2_a_0.VDD.n767 IOVSS 0.01041f $ **FLOATING
C1439 ldo_1v2_a_0.VDD.n768 IOVSS 0.01041f $ **FLOATING
C1440 ldo_1v2_a_0.VDD.n769 IOVSS 0.01041f $ **FLOATING
C1441 ldo_1v2_a_0.VDD.n770 IOVSS 0.01041f $ **FLOATING
C1442 ldo_1v2_a_0.VDD.n771 IOVSS 0.01041f $ **FLOATING
C1443 ldo_1v2_a_0.VDD.n772 IOVSS 0.01041f $ **FLOATING
C1444 ldo_1v2_a_0.VDD.n773 IOVSS 0.01041f $ **FLOATING
C1445 ldo_1v2_a_0.VDD.n774 IOVSS 0.01041f $ **FLOATING
C1446 ldo_1v2_a_0.VDD.n775 IOVSS 0.01041f $ **FLOATING
C1447 ldo_1v2_a_0.VDD.n776 IOVSS 0.01041f $ **FLOATING
C1448 ldo_1v2_a_0.VDD.n777 IOVSS 0.01041f $ **FLOATING
C1449 ldo_1v2_a_0.VDD.n778 IOVSS 0.01041f $ **FLOATING
C1450 ldo_1v2_a_0.VDD.n779 IOVSS 0.01041f $ **FLOATING
C1451 ldo_1v2_a_0.VDD.n780 IOVSS 0.01041f $ **FLOATING
C1452 ldo_1v2_a_0.VDD.n781 IOVSS 0.01041f $ **FLOATING
C1453 ldo_1v2_a_0.VDD.n782 IOVSS 0.01041f $ **FLOATING
C1454 ldo_1v2_a_0.VDD.n783 IOVSS 0.01041f $ **FLOATING
C1455 ldo_1v2_a_0.VDD.n784 IOVSS 0.01041f $ **FLOATING
C1456 ldo_1v2_a_0.VDD.n785 IOVSS 0.01041f $ **FLOATING
C1457 ldo_1v2_a_0.VDD.n786 IOVSS 0.01041f $ **FLOATING
C1458 ldo_1v2_a_0.VDD.n787 IOVSS 0.01041f $ **FLOATING
C1459 ldo_1v2_a_0.VDD.n788 IOVSS 0.01041f $ **FLOATING
C1460 ldo_1v2_a_0.VDD.n789 IOVSS 0.01041f $ **FLOATING
C1461 ldo_1v2_a_0.VDD.n791 IOVSS 0.01041f $ **FLOATING
C1462 ldo_1v2_a_0.VDD.n814 IOVSS 0.01041f $ **FLOATING
C1463 ldo_1v2_a_0.VDD.n815 IOVSS 0.01041f $ **FLOATING
C1464 ldo_1v2_a_0.VDD.n816 IOVSS 0.01041f $ **FLOATING
C1465 ldo_1v2_a_0.VDD.n817 IOVSS 0.01041f $ **FLOATING
C1466 ldo_1v2_a_0.VDD.n818 IOVSS 0.01041f $ **FLOATING
C1467 ldo_1v2_a_0.VDD.n819 IOVSS 0.01041f $ **FLOATING
C1468 ldo_1v2_a_0.VDD.n820 IOVSS 0.01041f $ **FLOATING
C1469 ldo_1v2_a_0.VDD.n821 IOVSS 0.01041f $ **FLOATING
C1470 ldo_1v2_a_0.VDD.n822 IOVSS 0.01041f $ **FLOATING
C1471 ldo_1v2_a_0.VDD.n823 IOVSS 0.01041f $ **FLOATING
C1472 ldo_1v2_a_0.VDD.n824 IOVSS 0.01041f $ **FLOATING
C1473 ldo_1v2_a_0.VDD.n825 IOVSS 0.01041f $ **FLOATING
C1474 ldo_1v2_a_0.VDD.n826 IOVSS 0.01041f $ **FLOATING
C1475 ldo_1v2_a_0.VDD.n827 IOVSS 0.01041f $ **FLOATING
C1476 ldo_1v2_a_0.VDD.n828 IOVSS 0.01041f $ **FLOATING
C1477 ldo_1v2_a_0.VDD.n829 IOVSS 0.01041f $ **FLOATING
C1478 ldo_1v2_a_0.VDD.n830 IOVSS 0.01041f $ **FLOATING
C1479 ldo_1v2_a_0.VDD.n831 IOVSS 0.01041f $ **FLOATING
C1480 ldo_1v2_a_0.VDD.n832 IOVSS 0.01041f $ **FLOATING
C1481 ldo_1v2_a_0.VDD.n833 IOVSS 0.01041f $ **FLOATING
C1482 ldo_1v2_a_0.VDD.n834 IOVSS 0.01041f $ **FLOATING
C1483 ldo_1v2_a_0.VDD.n835 IOVSS 0.01041f $ **FLOATING
C1484 ldo_1v2_a_0.VDD.n836 IOVSS 0.01041f $ **FLOATING
C1485 ldo_1v2_a_0.VDD.n837 IOVSS 0.01041f $ **FLOATING
C1486 ldo_1v2_a_0.VDD.n838 IOVSS 0.01041f $ **FLOATING
C1487 ldo_1v2_a_0.VDD.n839 IOVSS 0.01041f $ **FLOATING
C1488 ldo_1v2_a_0.VDD.n840 IOVSS 0.01041f $ **FLOATING
C1489 ldo_1v2_a_0.VDD.n841 IOVSS 0.01041f $ **FLOATING
C1490 ldo_1v2_a_0.VDD.n842 IOVSS 0.01041f $ **FLOATING
C1491 ldo_1v2_a_0.VDD.n843 IOVSS 0.01041f $ **FLOATING
C1492 ldo_1v2_a_0.VDD.n844 IOVSS 0.01041f $ **FLOATING
C1493 ldo_1v2_a_0.VDD.n845 IOVSS 0.01041f $ **FLOATING
C1494 ldo_1v2_a_0.VDD.n846 IOVSS 0.01041f $ **FLOATING
C1495 ldo_1v2_a_0.VDD.n847 IOVSS 0.01041f $ **FLOATING
C1496 ldo_1v2_a_0.VDD.n848 IOVSS 0.01041f $ **FLOATING
C1497 ldo_1v2_a_0.VDD.n849 IOVSS 0.01041f $ **FLOATING
C1498 ldo_1v2_a_0.VDD.n850 IOVSS 0.01041f $ **FLOATING
C1499 ldo_1v2_a_0.VDD.n851 IOVSS 0.01041f $ **FLOATING
C1500 ldo_1v2_a_0.VDD.n852 IOVSS 0.01041f $ **FLOATING
C1501 ldo_1v2_a_0.VDD.n853 IOVSS 0.01041f $ **FLOATING
C1502 ldo_1v2_a_0.VDD.n854 IOVSS 0.01041f $ **FLOATING
C1503 ldo_1v2_a_0.VDD.n855 IOVSS 0.01149f $ **FLOATING
C1504 ldo_1v2_a_0.VDD.n856 IOVSS 0.01041f $ **FLOATING
C1505 ldo_1v2_a_0.VDD.n857 IOVSS 0.01041f $ **FLOATING
C1506 ldo_1v2_a_0.VDD.n858 IOVSS 0.01041f $ **FLOATING
C1507 ldo_1v2_a_0.VDD.n859 IOVSS 0.01041f $ **FLOATING
C1508 ldo_1v2_a_0.VDD.n860 IOVSS 0.01041f $ **FLOATING
C1509 ldo_1v2_a_0.VDD.n861 IOVSS 0.01041f $ **FLOATING
C1510 ldo_1v2_a_0.VDD.n862 IOVSS 0.01041f $ **FLOATING
C1511 ldo_1v2_a_0.VDD.n863 IOVSS 0.01041f $ **FLOATING
C1512 ldo_1v2_a_0.VDD.n864 IOVSS 0.01041f $ **FLOATING
C1513 ldo_1v2_a_0.VDD.n865 IOVSS 0.01041f $ **FLOATING
C1514 ldo_1v2_a_0.VDD.n866 IOVSS 0.01041f $ **FLOATING
C1515 ldo_1v2_a_0.VDD.n867 IOVSS 0.01041f $ **FLOATING
C1516 ldo_1v2_a_0.VDD.n868 IOVSS 0.01041f $ **FLOATING
C1517 ldo_1v2_a_0.VDD.n869 IOVSS 0.01041f $ **FLOATING
C1518 ldo_1v2_a_0.VDD.n870 IOVSS 0.01041f $ **FLOATING
C1519 ldo_1v2_a_0.VDD.n871 IOVSS 0.01041f $ **FLOATING
C1520 ldo_1v2_a_0.VDD.n872 IOVSS 0.01041f $ **FLOATING
C1521 ldo_1v2_a_0.VDD.n873 IOVSS 0.01041f $ **FLOATING
C1522 ldo_1v2_a_0.VDD.n874 IOVSS 0.01041f $ **FLOATING
C1523 ldo_1v2_a_0.VDD.n875 IOVSS 0.01041f $ **FLOATING
C1524 ldo_1v2_a_0.VDD.n876 IOVSS 0.01041f $ **FLOATING
C1525 ldo_1v2_a_0.VDD.n877 IOVSS 0.01041f $ **FLOATING
C1526 ldo_1v2_a_0.VDD.n879 IOVSS 0.01041f $ **FLOATING
C1527 ldo_1v2_a_0.VDD.n880 IOVSS 0.01041f $ **FLOATING
C1528 ldo_1v2_a_0.VDD.n881 IOVSS 0.01041f $ **FLOATING
C1529 ldo_1v2_a_0.VDD.n882 IOVSS 0.01041f $ **FLOATING
C1530 ldo_1v2_a_0.VDD.n883 IOVSS 0.01041f $ **FLOATING
C1531 ldo_1v2_a_0.VDD.n884 IOVSS 0.01041f $ **FLOATING
C1532 ldo_1v2_a_0.VDD.n885 IOVSS 0.01041f $ **FLOATING
C1533 ldo_1v2_a_0.VDD.n886 IOVSS 0.01041f $ **FLOATING
C1534 ldo_1v2_a_0.VDD.n887 IOVSS 0.01041f $ **FLOATING
C1535 ldo_1v2_a_0.VDD.n888 IOVSS 0.01041f $ **FLOATING
C1536 ldo_1v2_a_0.VDD.n889 IOVSS 0.01041f $ **FLOATING
C1537 ldo_1v2_a_0.VDD.n890 IOVSS 0.01041f $ **FLOATING
C1538 ldo_1v2_a_0.VDD.n891 IOVSS 0.01041f $ **FLOATING
C1539 ldo_1v2_a_0.VDD.n892 IOVSS 0.01041f $ **FLOATING
C1540 ldo_1v2_a_0.VDD.n893 IOVSS 0.01041f $ **FLOATING
C1541 ldo_1v2_a_0.VDD.n894 IOVSS 0.01041f $ **FLOATING
C1542 ldo_1v2_a_0.VDD.n895 IOVSS 0.01041f $ **FLOATING
C1543 ldo_1v2_a_0.VDD.n896 IOVSS 0.01041f $ **FLOATING
C1544 ldo_1v2_a_0.VDD.n897 IOVSS 0.01041f $ **FLOATING
C1545 ldo_1v2_a_0.VDD.n898 IOVSS 0.01041f $ **FLOATING
C1546 ldo_1v2_a_0.VDD.n899 IOVSS 0.01347f $ **FLOATING
C1547 ldo_1v2_a_0.VDD.n900 IOVSS 0.02082f $ **FLOATING
C1548 ldo_1v2_a_0.VDD.n901 IOVSS 0.01471f $ **FLOATING
C1549 ldo_1v2_a_0.VDD.n902 IOVSS 0.01041f $ **FLOATING
C1550 ldo_1v2_a_0.VDD.n903 IOVSS 0.01346f $ **FLOATING
C1551 ldo_1v2_a_0.VDD.n904 IOVSS 0.01041f $ **FLOATING
C1552 ldo_1v2_a_0.VDD.n905 IOVSS 0.01041f $ **FLOATING
C1553 ldo_1v2_a_0.VDD.n906 IOVSS 0.01041f $ **FLOATING
C1554 ldo_1v2_a_0.VDD.n907 IOVSS 0.01041f $ **FLOATING
C1555 ldo_1v2_a_0.VDD.n908 IOVSS 0.01041f $ **FLOATING
C1556 ldo_1v2_a_0.VDD.n909 IOVSS 0.01041f $ **FLOATING
C1557 ldo_1v2_a_0.VDD.n910 IOVSS 0.01041f $ **FLOATING
C1558 ldo_1v2_a_0.VDD.n911 IOVSS 0.01041f $ **FLOATING
C1559 ldo_1v2_a_0.VDD.n912 IOVSS 0.01041f $ **FLOATING
C1560 ldo_1v2_a_0.VDD.n913 IOVSS 0.01041f $ **FLOATING
C1561 ldo_1v2_a_0.VDD.n914 IOVSS 0.01041f $ **FLOATING
C1562 ldo_1v2_a_0.VDD.n915 IOVSS 0.01041f $ **FLOATING
C1563 ldo_1v2_a_0.VDD.n916 IOVSS 0.01041f $ **FLOATING
C1564 ldo_1v2_a_0.VDD.n917 IOVSS 0.01041f $ **FLOATING
C1565 ldo_1v2_a_0.VDD.n918 IOVSS 0.01041f $ **FLOATING
C1566 ldo_1v2_a_0.VDD.n919 IOVSS 0.01041f $ **FLOATING
C1567 ldo_1v2_a_0.VDD.n920 IOVSS 0.01041f $ **FLOATING
C1568 ldo_1v2_a_0.VDD.n921 IOVSS 0.01041f $ **FLOATING
C1569 ldo_1v2_a_0.VDD.n922 IOVSS 0.01041f $ **FLOATING
C1570 ldo_1v2_a_0.VDD.n923 IOVSS 0.01041f $ **FLOATING
C1571 ldo_1v2_a_0.VDD.n924 IOVSS 0.01041f $ **FLOATING
C1572 ldo_1v2_a_0.VDD.n925 IOVSS 0.01041f $ **FLOATING
C1573 ldo_1v2_a_0.VDD.n926 IOVSS 0.01041f $ **FLOATING
C1574 ldo_1v2_a_0.VDD.n927 IOVSS 0.01041f $ **FLOATING
C1575 ldo_1v2_a_0.VDD.n928 IOVSS 0.01041f $ **FLOATING
C1576 ldo_1v2_a_0.VDD.n929 IOVSS 0.01041f $ **FLOATING
C1577 ldo_1v2_a_0.VDD.n930 IOVSS 0.01041f $ **FLOATING
C1578 ldo_1v2_a_0.VDD.n931 IOVSS 0.01041f $ **FLOATING
C1579 ldo_1v2_a_0.VDD.n932 IOVSS 0.01118f $ **FLOATING
C1580 ldo_1v2_a_0.VDD.n933 IOVSS 0.01118f $ **FLOATING
C1581 ldo_1v2_a_0.VDD.n934 IOVSS 0.01118f $ **FLOATING
C1582 ldo_1v2_a_0.VDD.n935 IOVSS 0.01118f $ **FLOATING
C1583 ldo_1v2_a_0.VDD.n936 IOVSS 0.01041f $ **FLOATING
C1584 ldo_1v2_a_0.VDD.n937 IOVSS 0.01041f $ **FLOATING
C1585 ldo_1v2_a_0.VDD.n938 IOVSS 0.01041f $ **FLOATING
C1586 ldo_1v2_a_0.VDD.n939 IOVSS 0.01041f $ **FLOATING
C1587 ldo_1v2_a_0.VDD.n940 IOVSS 0.01041f $ **FLOATING
C1588 ldo_1v2_a_0.VDD.n941 IOVSS 0.01041f $ **FLOATING
C1589 ldo_1v2_a_0.VDD.n942 IOVSS 0.01041f $ **FLOATING
C1590 ldo_1v2_a_0.VDD.n943 IOVSS 0.01041f $ **FLOATING
C1591 ldo_1v2_a_0.VDD.n944 IOVSS 0.01041f $ **FLOATING
C1592 ldo_1v2_a_0.VDD.n945 IOVSS 0.01041f $ **FLOATING
C1593 ldo_1v2_a_0.VDD.n946 IOVSS 0.01041f $ **FLOATING
C1594 ldo_1v2_a_0.VDD.n947 IOVSS 0.01041f $ **FLOATING
C1595 ldo_1v2_a_0.VDD.n948 IOVSS 0.01041f $ **FLOATING
C1596 ldo_1v2_a_0.VDD.n949 IOVSS 0.01041f $ **FLOATING
C1597 ldo_1v2_a_0.VDD.n950 IOVSS 0.01041f $ **FLOATING
C1598 ldo_1v2_a_0.VDD.n951 IOVSS 0.01041f $ **FLOATING
C1599 ldo_1v2_a_0.VDD.n952 IOVSS 0.01041f $ **FLOATING
C1600 ldo_1v2_a_0.VDD.n953 IOVSS 0.01041f $ **FLOATING
C1601 ldo_1v2_a_0.VDD.n954 IOVSS 0.01041f $ **FLOATING
C1602 ldo_1v2_a_0.VDD.n955 IOVSS 0.01041f $ **FLOATING
C1603 ldo_1v2_a_0.VDD.n956 IOVSS 0.01041f $ **FLOATING
C1604 ldo_1v2_a_0.VDD.n957 IOVSS 0.01041f $ **FLOATING
C1605 ldo_1v2_a_0.VDD.n958 IOVSS 0.01041f $ **FLOATING
C1606 ldo_1v2_a_0.VDD.n959 IOVSS 0.01041f $ **FLOATING
C1607 ldo_1v2_a_0.VDD.n960 IOVSS 0.01041f $ **FLOATING
C1608 ldo_1v2_a_0.VDD.n961 IOVSS 0.01041f $ **FLOATING
C1609 ldo_1v2_a_0.VDD.n962 IOVSS 0.01041f $ **FLOATING
C1610 ldo_1v2_a_0.VDD.n963 IOVSS 0.01041f $ **FLOATING
C1611 ldo_1v2_a_0.VDD.n964 IOVSS 0.01041f $ **FLOATING
C1612 ldo_1v2_a_0.VDD.n965 IOVSS 0.01041f $ **FLOATING
C1613 ldo_1v2_a_0.VDD.n966 IOVSS 0.01041f $ **FLOATING
C1614 ldo_1v2_a_0.VDD.n967 IOVSS 0.0117f $ **FLOATING
C1615 ldo_1v2_a_0.VDD.n968 IOVSS 0.01325f $ **FLOATING
C1616 ldo_1v2_a_0.VDD.n969 IOVSS 0.01561f $ **FLOATING
C1617 ldo_1v2_a_0.VDD.t0 IOVSS 42.154f $ **FLOATING
C1618 ldo_1v2_a_0.VDD.n972 IOVSS 0.01163f $ **FLOATING
C1619 ldo_1v2_a_0.VDD.t9 IOVSS 0.34662f $ **FLOATING
C1620 ldo_1v2_a_0.VDD.t15 IOVSS 0.34639f $ **FLOATING
C1621 ldo_1v2_a_0.VDD.n975 IOVSS 0.04938f $ **FLOATING
C1622 ldo_1v2_a_0.VDD.n976 IOVSS 0.04518f $ **FLOATING
C1623 ldo_1v2_a_0.VDD.t1 IOVSS 0.34661f $ **FLOATING
C1624 ldo_1v2_a_0.VDD.t21 IOVSS 0.34639f $ **FLOATING
C1625 ldo_1v2_a_0.VDD.n977 IOVSS 0.04939f $ **FLOATING
C1626 ldo_1v2_a_0.VDD.n978 IOVSS 0.04225f $ **FLOATING
C1627 ldo_1v2_a_0.VDD.t24 IOVSS 0.34662f $ **FLOATING
C1628 ldo_1v2_a_0.VDD.t12 IOVSS 0.34639f $ **FLOATING
C1629 ldo_1v2_a_0.VDD.n979 IOVSS 0.04938f $ **FLOATING
C1630 ldo_1v2_a_0.VDD.n980 IOVSS 0.04225f $ **FLOATING
C1631 ldo_1v2_a_0.VDD.t2 IOVSS 0.34662f $ **FLOATING
C1632 ldo_1v2_a_0.VDD.t17 IOVSS 0.34639f $ **FLOATING
C1633 ldo_1v2_a_0.VDD.n981 IOVSS 0.04938f $ **FLOATING
C1634 ldo_1v2_a_0.VDD.n982 IOVSS 0.04225f $ **FLOATING
C1635 ldo_1v2_a_0.VDD.t18 IOVSS 0.34662f $ **FLOATING
C1636 ldo_1v2_a_0.VDD.t6 IOVSS 0.34639f $ **FLOATING
C1637 ldo_1v2_a_0.VDD.n983 IOVSS 0.04938f $ **FLOATING
C1638 ldo_1v2_a_0.VDD.n984 IOVSS 0.04225f $ **FLOATING
C1639 ldo_1v2_a_0.VDD.t19 IOVSS 0.34662f $ **FLOATING
C1640 ldo_1v2_a_0.VDD.t3 IOVSS 0.34639f $ **FLOATING
C1641 ldo_1v2_a_0.VDD.n985 IOVSS 0.04938f $ **FLOATING
C1642 ldo_1v2_a_0.VDD.n986 IOVSS 0.04225f $ **FLOATING
C1643 ldo_1v2_a_0.VDD.t13 IOVSS 0.34662f $ **FLOATING
C1644 ldo_1v2_a_0.VDD.t4 IOVSS 0.34639f $ **FLOATING
C1645 ldo_1v2_a_0.VDD.n987 IOVSS 0.04938f $ **FLOATING
C1646 ldo_1v2_a_0.VDD.n988 IOVSS 0.04225f $ **FLOATING
C1647 ldo_1v2_a_0.VDD.t20 IOVSS 0.31942f $ **FLOATING
C1648 ldo_1v2_a_0.VDD.t7 IOVSS 0.31918f $ **FLOATING
C1649 ldo_1v2_a_0.VDD.n989 IOVSS 0.04937f $ **FLOATING
C1650 ldo_1v2_a_0.VDD.n990 IOVSS 0.03028f $ **FLOATING
C1651 ldo_1v2_a_0.VDD.n992 IOVSS 0.0659f $ **FLOATING
C1652 ldo_1v2_a_0.VDD.n993 IOVSS 0.14814f $ **FLOATING
C1653 ldo_1v2_a_0.VDD.n994 IOVSS 0.15685f $ **FLOATING
C1654 ldo_1v2_a_0.VDD.n995 IOVSS 0.09391f $ **FLOATING
C1655 ldo_1v2_a_0.VDD.n996 IOVSS 0.03842f $ **FLOATING
C1656 ldo_1v2_a_0.VDD.n997 IOVSS 0.0682f $ **FLOATING
C1657 ldo_1v2_a_0.VDD.n998 IOVSS 0.06431f $ **FLOATING
C1658 ldo_1v2_a_0.VDD.n1000 IOVSS 0.08602f $ **FLOATING
C1659 ldo_1v2_a_0.VDD.n1001 IOVSS 0.09719f $ **FLOATING
C1660 ldo_1v2_a_0.VDD.n1002 IOVSS 0.07135f $ **FLOATING
C1661 ldo_1v5_y_0.second_stage_1v5_0.dmv.t3 IOVSS 0.5236f $ **FLOATING
C1662 ldo_1v5_y_0.second_stage_1v5_0.dmv.t4 IOVSS 0.24974f $ **FLOATING
C1663 ldo_1v5_y_0.second_stage_1v5_0.dmv.n0 IOVSS 0.45554f $ **FLOATING
C1664 ldo_1v5_y_0.second_stage_1v5_0.dmv.t2 IOVSS 0.69363f $ **FLOATING
C1665 ldo_1v5_y_0.second_stage_1v5_0.dmv.t1 IOVSS 0.77028f $ **FLOATING
C1666 ldo_1v5_y_0.second_stage_1v5_0.dmv.n1 IOVSS 0.49898f $ **FLOATING
C1667 ldo_1v5_y_0.second_stage_1v5_0.dmv.n2 IOVSS 0.70659f $ **FLOATING
C1668 ldo_1v5_y_0.second_stage_1v5_0.dmv.t5 IOVSS 67.7737f $ **FLOATING
C1669 ldo_1v5_y_0.second_stage_1v5_0.dmv.n3 IOVSS 2.85491f $ **FLOATING
C1670 ldo_1v5_y_0.second_stage_1v5_0.dmv.t0 IOVSS 0.12342f $ **FLOATING
C1671 ldo_1v5_y_0.second_stage_1v5_0.dmv.n4 IOVSS 0.65171f $ **FLOATING
.ends
