* CDL Netlist generated by OpenROAD

*.BUSDELIMITER [

.include "SoC_Analog_Top.spice"
.include "$PDKPATH/libs.ref/sg13g2_stdcell/cdl/sg13g2_stdcell.cdl"
.include "$PDKPATH/libs.ref/sg13g2_io/spice/sg13g2_io.spi"

.SUBCKT SoC2263 VDD1v5 adc_done_PAD clk_PAD reset_n_PAD
+ sc_enable_PAD sc_vout_PAD sc_vref_PAD sensor_PAD state_out_0_PAD
+ state_out_1_PAD state_out_2_PAD trigger_PAD tx_PAD vbg_PAD
+ vramp_PAD VSS VDD IOVDD IOVSS
X_430_ sc_cal_ref_select\[3\] _043_ VDD VSS sg13g2_inv_1
X_431_ sc_cal_ref_select\[2\] _042_ VDD VSS sg13g2_inv_1
X_432_ sc_cal_ref_select\[1\] _041_ VDD VSS sg13g2_inv_1
X_433_ sc_cal_ref_select\[0\] _040_ VDD VSS sg13g2_inv_1
X_434_ ramp_reset_PIN _039_ VDD VSS sg13g2_inv_1
X_435_ _110_ net14 VDD VSS sg13g2_inv_1
X_436_ _111_ net10 VDD VSS sg13g2_inv_1
X_437_ _112_ net11 VDD VSS sg13g2_inv_1
X_438_ _113_ uut_full_system_top.uut_cal_fsm.amplifier_enable
+ VDD VSS sg13g2_inv_1
X_439_ adc_sel_cal_PIN adc_sel_meas_PIN VDD VSS sg13g2_inv_1
X_440_ _114_ uut_full_system_top.uut_cal_fsm.state\[2\] VDD
+ VSS sg13g2_inv_1
X_441_ _115_ uut_full_system_top.uut_adc_logic.state\[2\]
+ VDD VSS sg13g2_inv_1
X_442_ _116_ uut_full_system_top.uut_timer.done_d1 VDD VSS
+ sg13g2_inv_1
X_443_ _117_ uut_full_system_top.uut_uart.baud_counter\[6\]
+ VDD VSS sg13g2_inv_1
X_444_ _118_ uut_full_system_top.uut_adc_logic.adc_start_sync_1
+ VDD VSS sg13g2_inv_1
X_445_ _020_ uut_full_system_top.uut_timer.u_prescaler.counter\[0\]
+ VDD VSS sg13g2_inv_1
X_446_ sc_select_sen_PIN sc_select_cal_PIN VDD VSS sg13g2_inv_1
X_447_ _119_ net3 VDD VSS sg13g2_inv_1
X_448_ _120_ uut_full_system_top.uut_adc_logic.is_neg VDD
+ VSS sg13g2_inv_1
X_449_ _121_ uut_full_system_top.uut_timer.u_counter.counter\[4\]
+ VDD VSS sg13g2_inv_1
X_450_ _122_ uut_full_system_top.uut_timer.trigger_flag VDD
+ VSS sg13g2_inv_1
X_451_ uut_full_system_top.uut_cal_fsm.state\[0\] _045_ VDD
+ VSS sg13g2_inv_1
X_452_ _123_ _046_ VDD VSS sg13g2_inv_1
X_453_ tx _047_ VDD VSS sg13g2_inv_1
X_454_ _124_ uut_full_system_top.uut_uart.state\[3\] _044_
+ VDD VSS sg13g2_nand2b_1
X_455_ _125_ uut_full_system_top.uut_uart.bit_index\[0\] uut_full_system_top.uut_uart.bit_index\[1\]
+ VDD VSS sg13g2_nor2_1
X_456_ _126_ uut_full_system_top.uut_uart.bit_index\[0\] uut_full_system_top.uut_uart.bit_index\[1\]
+ VDD VSS sg13g2_and2_1
X_457_ _127_ uut_full_system_top.uut_uart.data_reg\[0\] uut_full_system_top.uut_uart.data_reg\[1\]
+ uut_full_system_top.uut_uart.data_reg\[2\] uut_full_system_top.uut_uart.data_reg\[3\]
+ uut_full_system_top.uut_uart.bit_index\[0\] uut_full_system_top.uut_uart.bit_index\[1\]
+ VDD VSS sg13g2_mux4_1
X_458_ _128_ uut_full_system_top.uut_uart.data_reg\[4\] uut_full_system_top.uut_uart.data_reg\[5\]
+ uut_full_system_top.uut_uart.data_reg\[6\] uut_full_system_top.uut_uart.data_reg\[7\]
+ uut_full_system_top.uut_uart.bit_index\[0\] uut_full_system_top.uut_uart.bit_index\[1\]
+ VDD VSS sg13g2_mux4_1
X_459_ _129_ _127_ _128_ uut_full_system_top.uut_uart.bit_index\[2\]
+ VDD VSS sg13g2_mux2_1
X_460_ _051_ uut_full_system_top.uut_uart.state\[1\] _129_
+ _124_ VDD VSS sg13g2_a21oi_1
X_461_ _130_ net20 uut_full_system_top.uut_adc_logic.counter\[0\]
+ VDD VSS sg13g2_and2_1
X_462_ _131_ net16 net14 VDD VSS sg13g2_and2_1
X_463_ _132_ net18 net12 _131_ VDD VSS sg13g2_nand3_1
X_464_ _133_ net17 net19 _130_ VDD VSS sg13g2_nand3_1
X_465_ _134_ _110_ _133_ VDD VSS sg13g2_nor2_1
X_466_ _135_ net10 net11 VDD VSS sg13g2_nand2_1
X_467_ _136_ _132_ _135_ VDD VSS sg13g2_nor2_1
X_468_ _137_ net8 _130_ _136_ VDD VSS sg13g2_nand3_1
X_469_ _138_ adc_comp_out_PIN _137_ VDD VSS sg13g2_and2_1
X_470_ _050_ _123_ _138_ VDD VSS sg13g2_nand2_1
X_471_ _139_ uut_full_system_top.uut_uart.tx_start_sync_2
+ uut_full_system_top.uut_uart.tx_start_sync_1 VDD VSS sg13g2_nand2b_1
X_472_ _140_ _044_ _139_ VDD VSS sg13g2_nor2b_1
X_473_ _141_ uut_full_system_top.uut_uart.baud_counter\[0\]
+ uut_full_system_top.uut_uart.baud_counter\[1\] uut_full_system_top.uut_uart.baud_counter\[2\]
+ VDD VSS sg13g2_and3_1
X_474_ _142_ uut_full_system_top.uut_uart.baud_counter\[3\]
+ uut_full_system_top.uut_uart.baud_counter\[4\] VDD VSS sg13g2_nor2_1
X_475_ _143_ uut_full_system_top.uut_uart.baud_counter\[5\]
+ uut_full_system_top.uut_uart.baud_counter\[6\] _141_ _142_
+ VDD VSS sg13g2_and4_1
X_476_ _048_ uut_full_system_top.uut_uart.state\[3\] net1
+ _140_ VDD VSS sg13g2_a21oi_1
X_477_ _001_ _046_ _138_ VDD VSS sg13g2_nor2_1
X_478_ _000_ _138_ uut_full_system_top.uut_adc_logic.state\[4\]
+ VDD VSS sg13g2_nor2b_1
X_479_ reset_n analog_reset_n_PIN reset_n_pad_sg VDD VSS sg13g2_and2_1
X_480_ _144_ net56 state_out\[1\] VDD VSS sg13g2_nor2_1
X_481_ _145_ net55 _144_ VDD VSS sg13g2_or2_1
X_482_ _146_ net56 state_out\[1\] VDD VSS sg13g2_nand2_1
X_483_ _147_ _145_ _146_ VDD VSS sg13g2_nor2b_1
X_484_ singnal_conditionning_en_PIN uut_full_system_top.uut_cal_fsm.amplifier_enable
+ sc_enable_pad_sg _147_ VDD VSS sg13g2_or3_1
X_485_ uut_full_system_top.clk_gated_adc uut_full_system_top.uut_clock_gating.adc_clk_gate.enable_latched
+ clk VDD VSS sg13g2_and2_1
X_486_ uut_full_system_top.clk_gated_uart clk uut_full_system_top.uut_clock_gating.uart_clk_gate.enable_latched
+ VDD VSS sg13g2_and2_1
X_487_ uut_full_system_top.clk_gated_cal clk uut_full_system_top.uut_clock_gating.cal_clk_gate.enable_latched
+ VDD VSS sg13g2_and2_1
X_488_ uut_full_system_top.adc_start net55 _146_ VDD VSS sg13g2_nor2_1
X_489_ _148_ state_out\[1\] net55 VDD VSS sg13g2_nor2b_1
X_490_ _149_ net55 _144_ VDD VSS sg13g2_nand2_1
X_491_ uut_full_system_top.adc_clk_en adc_sel_meas_PIN net30
+ _145_ _149_ VDD VSS sg13g2_nand4_1
X_492_ _150_ uut_full_system_top.uut_cal_fsm.state\[1\] uut_full_system_top.uut_cal_fsm.amplifier_enable
+ uut_full_system_top.uut_cal_fsm.state\[2\] uut_full_system_top.uut_cal_fsm.state\[0\]
+ VDD VSS sg13g2_nor4_1
X_493_ uut_full_system_top.cal_active net30 _150_ VDD VSS
+ sg13g2_nand2_1
X_494_ uut_full_system_top.trigger_armed adc_sel_meas_PIN
+ trigger net30 _150_ VDD VSS sg13g2_and4_1
X_495_ _151_ net55 state_out\[1\] VDD VSS sg13g2_nand2_1
X_496_ uut_full_system_top.tx_start net56 _151_ VDD VSS sg13g2_nor2_1
X_497_ _152_ net1 uut_full_system_top.uut_uart.state\[3\]
+ VDD VSS sg13g2_nand2b_1
X_498_ _153_ uut_full_system_top.uut_uart.bit_index\[2\] _126_
+ VDD VSS sg13g2_and2_1
X_499_ _154_ uut_full_system_top.uut_uart.state\[1\] net1
+ VDD VSS sg13g2_nand2_1
X_500_ _155_ uut_full_system_top.uut_uart.state\[1\] net1
+ _153_ VDD VSS sg13g2_nand3_1
X_501_ _008_ _152_ _155_ VDD VSS sg13g2_nand2_1
X_502_ _156_ net1 uut_full_system_top.uut_uart.state\[2\]
+ VDD VSS sg13g2_nand2b_1
X_503_ _007_ _044_ _139_ _156_ VDD VSS sg13g2_o21ai_1
X_504_ _157_ uut_full_system_top.uut_uart.state\[2\] net1
+ VDD VSS sg13g2_nand2_1
X_505_ _158_ _153_ _154_ _157_ VDD VSS sg13g2_o21ai_1
X_506_ _159_ _143_ uut_full_system_top.uut_uart.state\[1\]
+ VDD VSS sg13g2_nand2b_1
X_507_ _006_ _158_ _159_ VDD VSS sg13g2_nand2b_1
X_508_ _160_ sc_cal_ref_select\[3\] sc_cal_ref_select\[2\]
+ sc_cal_ref_select\[1\] _040_ VDD VSS sg13g2_nor4_1
X_509_ _161_ cal_comp_out_PIN _160_ VDD VSS sg13g2_nor2_1
X_510_ _162_ cal_comp_out_PIN _160_ uut_full_system_top.uut_cal_fsm.state\[1\]
+ VDD VSS sg13g2_o21ai_1
X_511_ _005_ uut_full_system_top.uut_cal_fsm.state\[3\] _162_
+ VDD VSS sg13g2_nand2b_1
X_512_ _163_ uut_full_system_top.uut_cal_fsm.state\[1\] _161_
+ VDD VSS sg13g2_nand2_1
X_513_ _004_ _114_ _163_ VDD VSS sg13g2_nand2_1
X_514_ _164_ uut_full_system_top.uut_adc_logic.adc_start_sync_2
+ _118_ _147_ VDD VSS sg13g2_nor3_1
X_515_ _165_ uut_full_system_top.uut_adc_logic.state\[2\]
+ _164_ VDD VSS sg13g2_nand2_1
X_516_ _166_ uut_full_system_top.uut_adc_logic.state\[4\]
+ _138_ VDD VSS sg13g2_nand2_1
X_517_ _003_ _165_ _166_ VDD VSS sg13g2_nand2_1
X_518_ _167_ uut_full_system_top.uut_adc_logic.state\[3\]
+ net2 VDD VSS sg13g2_nor2_1
X_519_ _168_ _115_ _167_ VDD VSS sg13g2_nand2_1
X_520_ _002_ _115_ _164_ _167_ VDD VSS sg13g2_o21ai_1
X_521_ uut_full_system_top.uart_en net55 _146_ VDD VSS sg13g2_and2_1
X_522_ _030_ uut_full_system_top.uut_timer.u_prescaler.counter\[0\]
+ uut_full_system_top.uut_timer.u_prescaler.counter\[1\] VDD
+ VSS sg13g2_xor2_1
X_523_ _169_ uut_full_system_top.uut_timer.u_prescaler.counter\[0\]
+ uut_full_system_top.uut_timer.u_prescaler.counter\[1\] uut_full_system_top.uut_timer.u_prescaler.counter\[2\]
+ VDD VSS sg13g2_nand3_1
X_524_ _170_ uut_full_system_top.uut_timer.u_prescaler.counter\[0\]
+ uut_full_system_top.uut_timer.u_prescaler.counter\[1\] uut_full_system_top.uut_timer.u_prescaler.counter\[2\]
+ VDD VSS sg13g2_a21o_1
X_525_ _031_ _169_ _170_ VDD VSS sg13g2_and2_1
X_526_ _171_ uut_full_system_top.uut_timer.u_prescaler.counter\[0\]
+ uut_full_system_top.uut_timer.u_prescaler.counter\[1\] uut_full_system_top.uut_timer.u_prescaler.counter\[2\]
+ uut_full_system_top.uut_timer.u_prescaler.counter\[3\] VDD
+ VSS sg13g2_and4_1
X_527_ _032_ uut_full_system_top.uut_timer.u_prescaler.counter\[3\]
+ _169_ VDD VSS sg13g2_xnor2_1
X_528_ _172_ uut_full_system_top.uut_timer.u_prescaler.counter\[4\]
+ _171_ VDD VSS sg13g2_and2_1
X_529_ _033_ uut_full_system_top.uut_timer.u_prescaler.counter\[4\]
+ _171_ VDD VSS sg13g2_xor2_1
X_530_ _173_ uut_full_system_top.uut_timer.u_prescaler.counter\[11\]
+ uut_full_system_top.uut_timer.u_prescaler.counter\[8\] VDD
+ VSS sg13g2_nor2b_1
X_531_ _174_ uut_full_system_top.uut_timer.u_prescaler.counter\[5\]
+ uut_full_system_top.uut_timer.u_prescaler.counter\[7\] uut_full_system_top.uut_timer.u_prescaler.counter\[6\]
+ uut_full_system_top.uut_timer.u_prescaler.counter\[9\] VDD
+ VSS sg13g2_nor4_1
X_532_ _175_ uut_full_system_top.uut_timer.u_prescaler.counter\[15\]
+ uut_full_system_top.uut_timer.u_prescaler.counter\[16\] uut_full_system_top.uut_timer.u_prescaler.counter\[17\]
+ uut_full_system_top.uut_timer.u_prescaler.counter\[18\] VDD
+ VSS sg13g2_nand4_1
X_533_ _176_ uut_full_system_top.uut_timer.u_prescaler.counter\[10\]
+ uut_full_system_top.uut_timer.u_prescaler.counter\[13\] VDD
+ VSS sg13g2_nand2b_1
X_534_ _177_ uut_full_system_top.uut_timer.u_prescaler.counter\[12\]
+ uut_full_system_top.uut_timer.u_prescaler.counter\[14\] _175_
+ _176_ VDD VSS sg13g2_nor4_1
X_535_ _178_ _172_ _173_ _174_ _177_ VDD VSS sg13g2_and4_1
X_536_ _179_ uut_full_system_top.uut_timer.u_prescaler.counter\[5\]
+ _172_ VDD VSS sg13g2_xnor2_1
X_537_ _034_ _178_ _179_ VDD VSS sg13g2_nor2_1
X_538_ _180_ uut_full_system_top.uut_timer.u_prescaler.counter\[5\]
+ uut_full_system_top.uut_timer.u_prescaler.counter\[6\] _172_
+ VDD VSS sg13g2_nand3_1
X_539_ _181_ uut_full_system_top.uut_timer.u_prescaler.counter\[5\]
+ _172_ uut_full_system_top.uut_timer.u_prescaler.counter\[6\]
+ VDD VSS sg13g2_a21o_1
X_540_ _035_ _180_ _181_ VDD VSS sg13g2_and2_1
X_541_ _182_ uut_full_system_top.uut_timer.u_prescaler.counter\[5\]
+ uut_full_system_top.uut_timer.u_prescaler.counter\[7\] uut_full_system_top.uut_timer.u_prescaler.counter\[6\]
+ _172_ VDD VSS sg13g2_and4_1
X_542_ _036_ uut_full_system_top.uut_timer.u_prescaler.counter\[7\]
+ _180_ VDD VSS sg13g2_xnor2_1
X_543_ _183_ uut_full_system_top.uut_timer.u_prescaler.counter\[8\]
+ _182_ VDD VSS sg13g2_nor2_1
X_544_ _184_ uut_full_system_top.uut_timer.u_prescaler.counter\[8\]
+ _182_ VDD VSS sg13g2_and2_1
X_545_ _037_ _178_ _183_ _184_ VDD VSS sg13g2_nor3_1
X_546_ _038_ uut_full_system_top.uut_timer.u_prescaler.counter\[9\]
+ _184_ VDD VSS sg13g2_xor2_1
X_547_ _185_ uut_full_system_top.uut_timer.u_prescaler.counter\[9\]
+ uut_full_system_top.uut_timer.u_prescaler.counter\[10\] _184_
+ VDD VSS sg13g2_and3_1
X_548_ _186_ uut_full_system_top.uut_timer.u_prescaler.counter\[9\]
+ _184_ uut_full_system_top.uut_timer.u_prescaler.counter\[10\]
+ VDD VSS sg13g2_a21oi_1
X_549_ _021_ _185_ _186_ VDD VSS sg13g2_nor2_1
X_550_ _022_ uut_full_system_top.uut_timer.u_prescaler.counter\[11\]
+ _185_ VDD VSS sg13g2_xor2_1
X_551_ _187_ uut_full_system_top.uut_timer.u_prescaler.counter\[11\]
+ uut_full_system_top.uut_timer.u_prescaler.counter\[12\] _185_
+ VDD VSS sg13g2_nand3_1
X_552_ _188_ uut_full_system_top.uut_timer.u_prescaler.counter\[11\]
+ _185_ uut_full_system_top.uut_timer.u_prescaler.counter\[12\]
+ VDD VSS sg13g2_a21o_1
X_553_ _023_ _187_ _188_ VDD VSS sg13g2_and2_1
X_554_ _189_ uut_full_system_top.uut_timer.u_prescaler.counter\[13\]
+ _187_ VDD VSS sg13g2_nor2b_1
X_555_ _190_ uut_full_system_top.uut_timer.u_prescaler.counter\[11\]
+ uut_full_system_top.uut_timer.u_prescaler.counter\[12\] uut_full_system_top.uut_timer.u_prescaler.counter\[13\]
+ _185_ VDD VSS sg13g2_and4_1
X_556_ _024_ _178_ _189_ _190_ VDD VSS sg13g2_nor3_1
X_557_ _191_ uut_full_system_top.uut_timer.u_prescaler.counter\[14\]
+ _190_ VDD VSS sg13g2_and2_1
X_558_ _025_ uut_full_system_top.uut_timer.u_prescaler.counter\[14\]
+ _190_ VDD VSS sg13g2_xor2_1
X_559_ _192_ uut_full_system_top.uut_timer.u_prescaler.counter\[15\]
+ _191_ VDD VSS sg13g2_nor2_1
X_560_ _193_ uut_full_system_top.uut_timer.u_prescaler.counter\[15\]
+ _191_ VDD VSS sg13g2_and2_1
X_561_ _026_ _178_ _192_ _193_ VDD VSS sg13g2_nor3_1
X_562_ _194_ uut_full_system_top.uut_timer.u_prescaler.counter\[16\]
+ _193_ VDD VSS sg13g2_nor2_1
X_563_ _195_ uut_full_system_top.uut_timer.u_prescaler.counter\[16\]
+ _193_ VDD VSS sg13g2_and2_1
X_564_ _027_ _178_ _194_ _195_ VDD VSS sg13g2_nor3_1
X_565_ _196_ uut_full_system_top.uut_timer.u_prescaler.counter\[17\]
+ _195_ VDD VSS sg13g2_nor2_1
X_566_ _197_ uut_full_system_top.uut_timer.u_prescaler.counter\[17\]
+ _195_ VDD VSS sg13g2_and2_1
X_567_ _028_ _178_ _196_ _197_ VDD VSS sg13g2_nor3_1
X_568_ _198_ uut_full_system_top.uut_timer.u_prescaler.counter\[18\]
+ _197_ VDD VSS sg13g2_nor2_1
X_569_ _199_ uut_full_system_top.uut_timer.u_prescaler.counter\[18\]
+ _197_ _178_ VDD VSS sg13g2_a21oi_1
X_570_ _029_ _198_ _199_ VDD VSS sg13g2_nor2b_1
X_571_ _200_ uut_full_system_top.uut_timer.u_counter.trig_d2
+ uut_full_system_top.uut_timer.u_counter.trig_d1 VDD VSS sg13g2_nor2b_1
X_572_ _201_ _200_ VDD VSS sg13g2_inv_1
X_573_ _009_ uut_full_system_top.uut_timer.u_counter.counter\[0\]
+ _200_ VDD VSS sg13g2_nor2_1
X_574_ _202_ uut_full_system_top.uut_timer.u_counter.counter\[0\]
+ uut_full_system_top.uut_timer.u_counter.counter\[1\] _201_
+ VDD VSS sg13g2_o21ai_1
X_575_ _010_ uut_full_system_top.uut_timer.u_counter.counter\[0\]
+ uut_full_system_top.uut_timer.u_counter.counter\[1\] _202_
+ VDD VSS sg13g2_a21oi_1
X_576_ _203_ uut_full_system_top.uut_timer.u_counter.counter\[0\]
+ uut_full_system_top.uut_timer.u_counter.counter\[1\] uut_full_system_top.uut_timer.u_counter.counter\[2\]
+ VDD VSS sg13g2_a21oi_1
X_577_ _204_ uut_full_system_top.uut_timer.u_counter.counter\[0\]
+ uut_full_system_top.uut_timer.u_counter.counter\[1\] uut_full_system_top.uut_timer.u_counter.counter\[2\]
+ VDD VSS sg13g2_and3_1
X_578_ _011_ _200_ _203_ _204_ VDD VSS sg13g2_nor3_1
X_579_ _205_ uut_full_system_top.uut_timer.u_counter.counter\[8\]
+ uut_full_system_top.uut_timer.u_counter.counter\[6\] VDD VSS
+ sg13g2_nor2b_1
X_580_ _206_ uut_full_system_top.uut_timer.u_counter.counter\[3\]
+ uut_full_system_top.uut_timer.u_counter.counter\[5\] _121_
+ uut_full_system_top.uut_timer.u_counter.counter\[7\] VDD VSS
+ sg13g2_nor4_1
X_581_ _207_ uut_full_system_top.uut_timer.u_counter.counter\[9\]
+ _204_ _205_ _206_ VDD VSS sg13g2_and4_1
X_582_ _208_ _200_ _207_ VDD VSS sg13g2_or2_1
X_583_ _209_ uut_full_system_top.uut_timer.u_counter.counter\[3\]
+ _204_ VDD VSS sg13g2_and2_1
X_584_ _210_ uut_full_system_top.uut_timer.u_counter.counter\[3\]
+ _204_ VDD VSS sg13g2_nor2_1
X_585_ _012_ _208_ _209_ _210_ VDD VSS sg13g2_nor3_1
X_586_ _211_ uut_full_system_top.uut_timer.u_counter.counter\[4\]
+ _209_ VDD VSS sg13g2_and2_1
X_587_ _212_ uut_full_system_top.uut_timer.u_counter.counter\[4\]
+ _209_ VDD VSS sg13g2_nor2_1
X_588_ _013_ _208_ _211_ _212_ VDD VSS sg13g2_nor3_1
X_589_ _213_ uut_full_system_top.uut_timer.u_counter.counter\[5\]
+ _211_ _200_ VDD VSS sg13g2_a21oi_1
X_590_ _214_ uut_full_system_top.uut_timer.u_counter.counter\[5\]
+ _211_ _213_ VDD VSS sg13g2_o21ai_1
X_591_ _014_ _214_ VDD VSS sg13g2_inv_1
X_592_ _215_ uut_full_system_top.uut_timer.u_counter.counter\[5\]
+ _211_ uut_full_system_top.uut_timer.u_counter.counter\[6\]
+ VDD VSS sg13g2_a21oi_1
X_593_ _216_ uut_full_system_top.uut_timer.u_counter.counter\[5\]
+ uut_full_system_top.uut_timer.u_counter.counter\[6\] _211_
+ VDD VSS sg13g2_and3_1
X_594_ _015_ _208_ _215_ _216_ VDD VSS sg13g2_nor3_1
X_595_ _217_ uut_full_system_top.uut_timer.u_counter.counter\[7\]
+ _216_ VDD VSS sg13g2_nor2_1
X_596_ _218_ uut_full_system_top.uut_timer.u_counter.counter\[7\]
+ _216_ VDD VSS sg13g2_and2_1
X_597_ _016_ _200_ _217_ _218_ VDD VSS sg13g2_nor3_1
X_598_ _219_ uut_full_system_top.uut_timer.u_counter.counter\[8\]
+ _218_ VDD VSS sg13g2_or2_1
X_599_ _220_ uut_full_system_top.uut_timer.u_counter.counter\[8\]
+ _218_ VDD VSS sg13g2_nand2_1
X_600_ _017_ _201_ _219_ _220_ VDD VSS sg13g2_and3_1
X_601_ _221_ uut_full_system_top.uut_timer.u_counter.counter\[9\]
+ _220_ VDD VSS sg13g2_xor2_1
X_602_ _018_ _208_ _221_ VDD VSS sg13g2_nor2_1
X_603_ _019_ _201_ _207_ VDD VSS sg13g2_and2_1
X_604_ _222_ uut_full_system_top.uut_adc_logic.state\[2\]
+ uut_full_system_top.uut_adc_logic.counter_enable VDD VSS sg13g2_nor2b_1
X_605_ _223_ _138_ _222_ VDD VSS sg13g2_and2_1
X_606_ _224_ uut_full_system_top.uut_adc_logic.counter_enable
+ _138_ uut_full_system_top.uut_adc_logic.state\[2\] VDD VSS
+ sg13g2_a21oi_1
X_607_ _052_ _223_ _224_ uut_full_system_top.uut_adc_logic.counter\[0\]
+ VDD VSS sg13g2_mux2_1
X_608_ _225_ net20 uut_full_system_top.uut_adc_logic.counter\[0\]
+ VDD VSS sg13g2_xor2_1
X_609_ _226_ net20 _224_ _225_ _223_ VDD VSS sg13g2_a22oi_1
X_610_ _053_ _226_ VDD VSS sg13g2_inv_1
X_611_ _227_ net19 _130_ VDD VSS sg13g2_xor2_1
X_612_ _228_ net19 _224_ _227_ _223_ VDD VSS sg13g2_a22oi_1
X_613_ _054_ _228_ VDD VSS sg13g2_inv_1
X_614_ _229_ net18 _130_ net16 VDD VSS sg13g2_a21o_1
X_615_ _230_ _133_ _229_ VDD VSS sg13g2_and2_1
X_616_ _231_ net17 _224_ _230_ _223_ VDD VSS sg13g2_a22oi_1
X_617_ _055_ _231_ VDD VSS sg13g2_inv_1
X_618_ _232_ _110_ _133_ VDD VSS sg13g2_and2_1
X_619_ _233_ _134_ _232_ VDD VSS sg13g2_nor2_1
X_620_ _234_ net14 _224_ _233_ _223_ VDD VSS sg13g2_a22oi_1
X_621_ _056_ _234_ VDD VSS sg13g2_inv_1
X_622_ _235_ net13 _134_ VDD VSS sg13g2_xor2_1
X_623_ _236_ net13 _224_ _235_ _223_ VDD VSS sg13g2_a22oi_1
X_624_ _057_ _236_ VDD VSS sg13g2_inv_1
X_625_ _237_ net13 uut_full_system_top.uut_adc_logic.counter_enable
+ _134_ _138_ VDD VSS sg13g2_nand4_1
X_626_ _238_ _112_ _237_ VDD VSS sg13g2_nor2_1
X_627_ _239_ _112_ _237_ uut_full_system_top.uut_adc_logic.state\[2\]
+ VDD VSS sg13g2_a21oi_1
X_628_ _058_ _238_ _239_ VDD VSS sg13g2_nor2b_1
X_629_ _240_ _135_ _237_ VDD VSS sg13g2_nor2_1
X_630_ _241_ uut_full_system_top.uut_adc_logic.counter\[7\]
+ _238_ _115_ VDD VSS sg13g2_o21ai_1
X_631_ _059_ _240_ _241_ VDD VSS sg13g2_nor2_1
X_632_ _242_ net9 _240_ VDD VSS sg13g2_nor2_1
X_633_ _060_ uut_full_system_top.uut_adc_logic.state\[2\]
+ _242_ VDD VSS sg13g2_nor2_1
X_634_ _061_ _115_ adc_done net2 VDD VSS sg13g2_a21o_1
X_635_ _243_ ramp_en_PIN _123_ VDD VSS sg13g2_nor2_1
X_636_ _062_ _168_ _243_ _165_ VDD VSS sg13g2_o21ai_1
X_637_ _244_ uut_full_system_top.uut_adc_logic.state\[4\]
+ _123_ VDD VSS sg13g2_nor2_1
X_638_ _063_ ramp_reset_PIN _244_ _168_ VDD VSS sg13g2_a21oi_1
X_639_ _245_ net2 uut_full_system_top.adc_result\[0\] VDD
+ VSS sg13g2_nor2_1
X_640_ _246_ net4 net6 VDD VSS sg13g2_nor2_1
X_641_ _247_ net4 net6 VDD VSS sg13g2_or2_1
X_642_ _248_ net3 net6 VDD VSS sg13g2_nor2_1
X_643_ _249_ net3 _246_ VDD VSS sg13g2_nor2_1
X_644_ _250_ _119_ _247_ VDD VSS sg13g2_nand2_1
X_645_ _251_ net10 net7 VDD VSS sg13g2_nor2_1
X_646_ _252_ net8 net7 VDD VSS sg13g2_nor2b_1
X_647_ _253_ net5 _248_ _251_ _252_ VDD VSS sg13g2_or4_1
X_648_ _254_ net12 net11 net6 VDD VSS sg13g2_mux2_1
X_649_ _255_ net16 net14 net6 VDD VSS sg13g2_mux2_1
X_650_ _256_ net4 _255_ VDD VSS sg13g2_nand2b_1
X_651_ _257_ net5 _254_ net3 VDD VSS sg13g2_a21oi_1
X_652_ _258_ _250_ _253_ _256_ _257_ VDD VSS sg13g2_a22oi_1
X_653_ _259_ net11 net10 net7 VDD VSS sg13g2_mux2_1
X_654_ _260_ net14 net11 net12 net10 net4 net6 VDD VSS sg13g2_mux4_1
X_655_ _261_ net3 _260_ VDD VSS sg13g2_and2_1
X_656_ _262_ net18 net16 net6 VDD VSS sg13g2_mux2_1
X_657_ _263_ net20 _262_ net4 VDD VSS sg13g2_mux2_1
X_658_ _264_ _249_ _263_ _261_ VDD VSS sg13g2_a21oi_1
X_659_ _265_ _249_ _263_ _261_ VDD VSS sg13g2_a21o_1
X_660_ _266_ net12 net10 net11 net8 net4 net7 VDD VSS sg13g2_mux4_1
X_661_ _267_ net3 _266_ VDD VSS sg13g2_and2_1
X_662_ _268_ net18 _255_ net4 VDD VSS sg13g2_mux2_1
X_663_ _269_ _249_ _268_ _267_ VDD VSS sg13g2_a21oi_1
X_664_ _270_ _249_ _268_ _267_ VDD VSS sg13g2_a21o_1
X_665_ _271_ net7 net8 VDD VSS sg13g2_nor2b_1
X_666_ _272_ _259_ _271_ net5 VDD VSS sg13g2_mux2_1
X_667_ _273_ net18 net15 net16 net12 net4 net6 VDD VSS sg13g2_mux4_1
X_668_ _274_ _119_ _247_ _273_ VDD VSS sg13g2_and3_1
X_669_ _275_ net3 _272_ _274_ VDD VSS sg13g2_a21o_1
X_670_ _276_ _264_ _269_ uut_full_system_top.uut_adc_logic.is_neg
+ VDD VSS sg13g2_a21oi_1
X_671_ _277_ _120_ _275_ _276_ VDD VSS sg13g2_a21oi_1
X_672_ _278_ _258_ _277_ VDD VSS sg13g2_xor2_1
X_673_ _279_ net17 _278_ VDD VSS sg13g2_nor2_1
X_674_ _280_ _275_ _276_ VDD VSS sg13g2_xor2_1
X_675_ _281_ _280_ net19 VDD VSS sg13g2_nor2b_1
X_676_ _282_ uut_full_system_top.uut_adc_logic.is_neg _264_
+ _270_ VDD VSS sg13g2_o21ai_1
X_677_ _283_ _120_ _265_ _269_ VDD VSS sg13g2_nand3_1
X_678_ _284_ net20 _282_ _283_ VDD VSS sg13g2_nand3_1
X_679_ _285_ uut_full_system_top.uut_adc_logic.counter\[0\]
+ _264_ VDD VSS sg13g2_nor2_1
X_680_ _286_ _282_ _283_ net20 VDD VSS sg13g2_a21oi_1
X_681_ _287_ _282_ _283_ net20 VDD VSS sg13g2_a21o_1
X_682_ _288_ _284_ _287_ VDD VSS sg13g2_nand2_1
X_683_ _289_ _285_ _286_ _284_ VDD VSS sg13g2_o21ai_1
X_684_ _290_ net19 _280_ VDD VSS sg13g2_xnor2_1
X_685_ _291_ _289_ _290_ _281_ VDD VSS sg13g2_a21oi_1
X_686_ _292_ net17 _278_ _289_ _290_ _281_ VDD VSS sg13g2_a221oi_1
X_687_ _293_ _279_ _292_ VDD VSS sg13g2_or2_1
X_688_ _294_ net8 net3 VDD VSS sg13g2_and2_1
X_689_ _295_ _249_ _260_ _294_ _246_ VDD VSS sg13g2_a22oi_1
X_690_ _296_ _258_ _265_ _270_ _275_ VDD VSS sg13g2_nor4_1
X_691_ _297_ uut_full_system_top.uut_adc_logic.is_neg _296_
+ VDD VSS sg13g2_nor2_1
X_692_ _298_ _295_ _297_ VDD VSS sg13g2_xor2_1
X_693_ _299_ net14 _298_ VDD VSS sg13g2_nand2_1
X_694_ _300_ net14 _298_ VDD VSS sg13g2_xnor2_1
X_695_ _301_ _295_ _296_ uut_full_system_top.uut_adc_logic.is_neg
+ VDD VSS sg13g2_a21o_1
X_696_ _302_ _249_ _266_ VDD VSS sg13g2_nand2_1
X_697_ _303_ _301_ _302_ VDD VSS sg13g2_xnor2_1
X_698_ _304_ net12 _303_ VDD VSS sg13g2_nor2_1
X_699_ _305_ net12 _303_ VDD VSS sg13g2_xnor2_1
X_700_ _306_ _279_ _292_ _300_ _305_ VDD VSS sg13g2_or4_1
X_701_ _307_ net14 _298_ _303_ net12 VDD VSS sg13g2_a22oi_1
X_702_ _308_ _304_ _307_ VDD VSS sg13g2_or2_1
X_703_ _309_ _306_ _308_ VDD VSS sg13g2_and2_1
X_704_ _310_ _249_ _272_ VDD VSS sg13g2_nand2_1
X_705_ _311_ _120_ _249_ _266_ VDD VSS sg13g2_nand3_1
X_706_ _312_ _301_ _310_ _311_ VDD VSS sg13g2_nand3_1
X_707_ _313_ _301_ _311_ _310_ VDD VSS sg13g2_a21o_1
X_708_ _314_ _312_ _313_ VDD VSS sg13g2_nand2_1
X_709_ _315_ net11 _314_ VDD VSS sg13g2_nand2_1
X_710_ _316_ net11 _314_ VDD VSS sg13g2_xnor2_1
X_711_ _317_ uut_full_system_top.uut_adc_logic.shift_n\[2\]
+ _253_ VDD VSS sg13g2_nor2_1
X_712_ _318_ _253_ _119_ VDD VSS sg13g2_nand2b_1
X_713_ _319_ _120_ _312_ _318_ VDD VSS sg13g2_nand3_1
X_714_ _320_ _120_ _312_ _318_ VDD VSS sg13g2_a21o_1
X_715_ _321_ net10 _319_ _320_ VDD VSS sg13g2_nand3_1
X_716_ _322_ _319_ _320_ net10 VDD VSS sg13g2_a21oi_1
X_717_ _323_ _319_ _320_ _111_ VDD VSS sg13g2_a21o_1
X_718_ _324_ _111_ _319_ _320_ VDD VSS sg13g2_nand3_1
X_719_ _325_ _323_ _324_ VDD VSS sg13g2_nand2_1
X_720_ _326_ _306_ _308_ _323_ _324_ _316_ VDD VSS sg13g2_a221oi_1
X_721_ _327_ _315_ _321_ _322_ VDD VSS sg13g2_a21oi_1
X_722_ _328_ _312_ _317_ _120_ VDD VSS sg13g2_o21ai_1
X_723_ _329_ net8 _328_ VDD VSS sg13g2_xnor2_1
X_724_ _330_ _326_ _327_ _329_ VDD VSS sg13g2_or3_1
X_725_ _331_ _326_ _327_ _329_ VDD VSS sg13g2_o21ai_1
X_726_ _332_ uut_full_system_top.uut_adc_logic.state\[1\]
+ _330_ _331_ VDD VSS sg13g2_and3_1
X_727_ _333_ uut_full_system_top.uut_adc_logic.counter\[0\]
+ _265_ VDD VSS sg13g2_xnor2_1
X_728_ _064_ _332_ _333_ _245_ VDD VSS sg13g2_a21oi_1
X_729_ _334_ net2 uut_full_system_top.adc_result\[1\] VDD
+ VSS sg13g2_nor2_1
X_730_ _335_ _285_ _288_ VDD VSS sg13g2_xnor2_1
X_731_ _065_ _332_ _335_ _334_ VDD VSS sg13g2_a21oi_1
X_732_ _336_ net2 uut_full_system_top.adc_result\[2\] VDD
+ VSS sg13g2_nor2_1
X_733_ _337_ _289_ _290_ VDD VSS sg13g2_xnor2_1
X_734_ _066_ _332_ _337_ _336_ VDD VSS sg13g2_a21oi_1
X_735_ _338_ net2 uut_full_system_top.adc_result\[3\] VDD
+ VSS sg13g2_nor2_1
X_736_ _339_ net17 _278_ VDD VSS sg13g2_xnor2_1
X_737_ _340_ _291_ _339_ VDD VSS sg13g2_xnor2_1
X_738_ _067_ _332_ _340_ _338_ VDD VSS sg13g2_a21oi_1
X_739_ _341_ net2 uut_full_system_top.adc_result\[4\] VDD
+ VSS sg13g2_nor2_1
X_740_ _342_ _293_ _300_ VDD VSS sg13g2_xnor2_1
X_741_ _068_ _332_ _342_ _341_ VDD VSS sg13g2_a21oi_1
X_742_ _343_ net2 uut_full_system_top.adc_result\[5\] VDD
+ VSS sg13g2_nor2_1
X_743_ _344_ _293_ _300_ _299_ VDD VSS sg13g2_o21ai_1
X_744_ _345_ _305_ _344_ VDD VSS sg13g2_xor2_1
X_745_ _069_ _332_ _345_ _343_ VDD VSS sg13g2_a21oi_1
X_746_ _346_ uut_full_system_top.uut_adc_logic.state\[1\]
+ uut_full_system_top.adc_result\[6\] VDD VSS sg13g2_nor2_1
X_747_ _347_ _309_ _316_ VDD VSS sg13g2_xnor2_1
X_748_ _070_ _332_ _347_ _346_ VDD VSS sg13g2_a21oi_1
X_749_ _348_ uut_full_system_top.uut_adc_logic.state\[1\]
+ uut_full_system_top.adc_result\[7\] VDD VSS sg13g2_nor2_1
X_750_ _349_ _309_ _316_ _315_ VDD VSS sg13g2_o21ai_1
X_751_ _350_ _325_ _349_ VDD VSS sg13g2_xnor2_1
X_752_ _071_ _332_ _350_ _348_ VDD VSS sg13g2_a21oi_1
X_753_ _072_ adc_sel_cal_PIN _123_ _115_ VDD VSS sg13g2_o21ai_1
X_754_ _073_ _138_ _222_ _244_ VDD VSS sg13g2_mux2_1
X_755_ _351_ uut_full_system_top.uut_adc_logic.state\[3\]
+ net7 VDD VSS sg13g2_nand2b_1
X_756_ _352_ net16 net18 VDD VSS sg13g2_nor2_1
X_757_ _353_ net16 net15 VDD VSS sg13g2_nor2_1
X_758_ _354_ net13 uut_full_system_top.uut_adc_logic.counter\[7\]
+ uut_full_system_top.uut_adc_logic.counter\[6\] VDD VSS sg13g2_nor3_1
X_759_ _355_ net8 _354_ VDD VSS sg13g2_nand2_1
X_760_ _356_ _355_ VDD VSS sg13g2_inv_1
X_761_ _357_ net20 uut_full_system_top.uut_adc_logic.counter\[0\]
+ _355_ VDD VSS sg13g2_nor3_1
X_762_ _358_ _353_ _357_ _352_ VDD VSS sg13g2_a21o_1
X_763_ _359_ _358_ VDD VSS sg13g2_inv_1
X_764_ _360_ net18 _357_ VDD VSS sg13g2_nand2b_1
X_765_ _361_ net16 _360_ _358_ VDD VSS sg13g2_a21o_1
X_766_ _362_ net15 _229_ _232_ _361_ VDD VSS sg13g2_a22oi_1
X_767_ _363_ net9 _135_ VDD VSS sg13g2_nor2_1
X_768_ _364_ net13 _363_ VDD VSS sg13g2_nand2_1
X_769_ _365_ _364_ VDD VSS sg13g2_inv_1
X_770_ _366_ uut_full_system_top.uut_adc_logic.counter\[1\]
+ net18 net17 VDD VSS sg13g2_a21oi_1
X_771_ _367_ _110_ _364_ _366_ VDD VSS sg13g2_nor3_1
X_772_ _368_ _132_ _135_ _131_ VDD VSS sg13g2_o21ai_1
X_773_ _369_ _131_ _354_ net9 VDD VSS sg13g2_o21ai_1
X_774_ _370_ _131_ _360_ _369_ VDD VSS sg13g2_a21oi_1
X_775_ _371_ net19 net15 _130_ VDD VSS sg13g2_nor3_1
X_776_ _372_ _353_ _364_ _371_ VDD VSS sg13g2_nor3_1
X_777_ _373_ _370_ _372_ VDD VSS sg13g2_nor2_1
X_778_ _374_ _356_ _362_ _367_ _368_ _373_ VDD VSS sg13g2_a221oi_1
X_779_ _375_ uut_full_system_top.uut_adc_logic.counter\[1\]
+ _352_ VDD VSS sg13g2_nand2b_1
X_780_ _376_ net15 _363_ _375_ VDD VSS sg13g2_nand3_1
X_781_ _377_ net9 _111_ _112_ _132_ VDD VSS sg13g2_nand4_1
X_782_ _378_ _364_ _376_ _377_ VDD VSS sg13g2_nand3_1
X_783_ _379_ uut_full_system_top.uut_adc_logic.state\[3\]
+ _378_ VDD VSS sg13g2_nand2_1
X_784_ _074_ _374_ _379_ _351_ VDD VSS sg13g2_o21ai_1
X_785_ _380_ _232_ _356_ _365_ _131_ VDD VSS sg13g2_a22oi_1
X_786_ _381_ _373_ uut_full_system_top.uut_adc_logic.state\[3\]
+ VDD VSS sg13g2_nor2b_1
X_787_ _382_ _358_ _380_ _381_ VDD VSS sg13g2_o21ai_1
X_788_ _383_ uut_full_system_top.uut_adc_logic.state\[3\]
+ net5 _382_ VDD VSS sg13g2_o21ai_1
X_789_ _075_ _383_ VDD VSS sg13g2_inv_1
X_790_ _384_ _359_ _380_ _381_ VDD VSS sg13g2_o21ai_1
X_791_ _076_ uut_full_system_top.uut_adc_logic.state\[3\]
+ _119_ _384_ VDD VSS sg13g2_o21ai_1
X_792_ _385_ net8 uut_full_system_top.uut_adc_logic.state\[3\]
+ VDD VSS sg13g2_nand2_1
X_793_ _077_ uut_full_system_top.uut_adc_logic.state\[3\]
+ _120_ _385_ VDD VSS sg13g2_o21ai_1
X_794_ _078_ _114_ sc_select_sen_PIN uut_full_system_top.uut_cal_fsm.state\[3\]
+ VDD VSS sg13g2_a21oi_1
X_795_ _079_ _113_ _045_ uut_full_system_top.uut_cal_fsm.state\[3\]
+ VDD VSS sg13g2_a21oi_1
X_796_ _386_ sc_cal_ref_select\[0\] _163_ VDD VSS sg13g2_nor2_1
X_797_ _080_ _040_ _163_ VDD VSS sg13g2_xnor2_1
X_798_ _081_ sc_cal_ref_select\[1\] _386_ VDD VSS sg13g2_xnor2_1
X_799_ _387_ _042_ _041_ _386_ VDD VSS sg13g2_nand3_1
X_800_ _388_ _041_ _386_ _042_ VDD VSS sg13g2_a21o_1
X_801_ _082_ _387_ _388_ VDD VSS sg13g2_and2_1
X_802_ _083_ _043_ _387_ VDD VSS sg13g2_xnor2_1
X_803_ _389_ net56 uut_full_system_top.uart_busy _148_ VDD
+ VSS sg13g2_and3_1
X_804_ _390_ uut_full_system_top.uut_fsm.adc_done_sync _149_
+ VDD VSS sg13g2_nor2_1
X_805_ _391_ uut_full_system_top.uut_timer.trig_d2 uut_full_system_top.uut_timer.trig_d1
+ VDD VSS sg13g2_nand2b_1
X_806_ _392_ _116_ uut_full_system_top.uut_timer.done_d2 _391_
+ VDD VSS sg13g2_o21ai_1
X_807_ _393_ net55 net56 state_out\[1\] _392_ VDD VSS sg13g2_nor4_1
X_808_ _394_ net56 uut_full_system_top.uut_fsm.uart_done_sync
+ _151_ VDD VSS sg13g2_nor3_1
X_809_ _395_ _389_ _390_ _393_ _394_ VDD VSS sg13g2_nor4_1
X_810_ _396_ state_out\[2\] state_out\[1\] net56 VDD VSS sg13g2_a21oi_1
X_811_ _084_ _395_ _396_ _389_ VDD VSS sg13g2_a21o_1
X_812_ _397_ state_out\[0\] _148_ _147_ VDD VSS sg13g2_a21oi_1
X_813_ _398_ state_out\[1\] _395_ VDD VSS sg13g2_nor2_1
X_814_ _085_ _395_ _397_ _398_ VDD VSS sg13g2_a21oi_1
X_815_ _399_ uut_full_system_top.adc_start _148_ VDD VSS sg13g2_nor2_1
X_816_ _086_ _395_ _399_ _393_ VDD VSS sg13g2_a21oi_1
X_817_ _087_ uut_full_system_top.uut_timer.clear_flag_sync
+ _122_ _391_ VDD VSS sg13g2_o21ai_1
X_818_ _088_ uut_full_system_top.uut_timer.clear_flag _200_
+ net23 VDD VSS sg13g2_mux2_1
X_819_ _089_ net53 _178_ VDD VSS sg13g2_xor2_1
X_820_ _400_ _124_ _152_ VDD VSS sg13g2_nand2_1
X_821_ _090_ _048_ uut_full_system_top.uart_busy _400_ VDD
+ VSS sg13g2_mux2_1
X_822_ _401_ uut_full_system_top.uut_uart.state\[3\] net1
+ _400_ uut_full_system_top.uart_done VDD VSS sg13g2_a22oi_1
X_823_ _091_ _401_ VDD VSS sg13g2_inv_1
X_824_ _402_ uut_full_system_top.uut_uart.state\[3\] uut_full_system_top.uut_uart.state\[2\]
+ uut_full_system_top.uut_uart.state\[1\] VDD VSS sg13g2_nor3_1
X_825_ _403_ _140_ _402_ VDD VSS sg13g2_or2_1
X_826_ _404_ _044_ _402_ _140_ VDD VSS sg13g2_a21o_1
X_827_ _405_ uut_full_system_top.uut_uart.baud_counter\[0\]
+ _404_ VDD VSS sg13g2_nand2_1
X_828_ _092_ uut_full_system_top.uut_uart.baud_counter\[0\]
+ _403_ _405_ VDD VSS sg13g2_o21ai_1
X_829_ _406_ uut_full_system_top.uut_uart.baud_counter\[1\]
+ _404_ VDD VSS sg13g2_nand2_1
X_830_ _407_ uut_full_system_top.uut_uart.baud_counter\[0\]
+ uut_full_system_top.uut_uart.baud_counter\[1\] VDD VSS sg13g2_xnor2_1
X_831_ _093_ _403_ _407_ _406_ VDD VSS sg13g2_o21ai_1
X_832_ _408_ uut_full_system_top.uut_uart.baud_counter\[0\]
+ uut_full_system_top.uut_uart.baud_counter\[1\] uut_full_system_top.uut_uart.baud_counter\[2\]
+ VDD VSS sg13g2_a21oi_1
X_833_ _409_ _141_ _403_ _408_ VDD VSS sg13g2_nor3_1
X_834_ _094_ uut_full_system_top.uut_uart.baud_counter\[2\]
+ _404_ _409_ VDD VSS sg13g2_a21o_1
X_835_ _410_ net1 _403_ VDD VSS sg13g2_nor2_1
X_836_ _411_ uut_full_system_top.uut_uart.baud_counter\[3\]
+ _141_ VDD VSS sg13g2_xor2_1
X_837_ _412_ uut_full_system_top.uut_uart.baud_counter\[3\]
+ _404_ _410_ _411_ VDD VSS sg13g2_a22oi_1
X_838_ _095_ _412_ VDD VSS sg13g2_inv_1
X_839_ _413_ uut_full_system_top.uut_uart.baud_counter\[3\]
+ uut_full_system_top.uut_uart.baud_counter\[4\] _141_ VDD VSS
+ sg13g2_and3_1
X_840_ _414_ uut_full_system_top.uut_uart.baud_counter\[3\]
+ _141_ uut_full_system_top.uut_uart.baud_counter\[4\] VDD VSS
+ sg13g2_a21oi_1
X_841_ _415_ _403_ _413_ _414_ VDD VSS sg13g2_nor3_1
X_842_ _096_ uut_full_system_top.uut_uart.baud_counter\[4\]
+ _404_ _415_ VDD VSS sg13g2_a21o_1
X_843_ _416_ uut_full_system_top.uut_uart.baud_counter\[5\]
+ _413_ VDD VSS sg13g2_nand2_1
X_844_ _417_ _410_ _416_ _404_ VDD VSS sg13g2_a21oi_1
X_845_ _418_ _410_ _413_ uut_full_system_top.uut_uart.baud_counter\[5\]
+ VDD VSS sg13g2_a21oi_1
X_846_ _097_ _417_ _418_ VDD VSS sg13g2_nor2_1
X_847_ _419_ uut_full_system_top.uut_uart.baud_counter\[5\]
+ _117_ _410_ _413_ VDD VSS sg13g2_nand4_1
X_848_ _098_ _117_ _417_ _419_ VDD VSS sg13g2_o21ai_1
X_849_ _420_ _155_ _158_ VDD VSS sg13g2_nand2_1
X_850_ _421_ uut_full_system_top.uut_uart.bit_index\[0\] _420_
+ VDD VSS sg13g2_nand2_1
X_851_ _099_ uut_full_system_top.uut_uart.bit_index\[0\] _154_
+ _421_ VDD VSS sg13g2_o21ai_1
X_852_ _422_ _125_ _126_ _154_ VDD VSS sg13g2_nor3_1
X_853_ _100_ uut_full_system_top.uut_uart.bit_index\[1\] _420_
+ _422_ VDD VSS sg13g2_a21o_1
X_854_ _423_ uut_full_system_top.uut_uart.state\[1\] _157_
+ VDD VSS sg13g2_nor2_1
X_855_ _424_ _126_ _158_ uut_full_system_top.uut_uart.bit_index\[2\]
+ VDD VSS sg13g2_a21oi_1
X_856_ _101_ _423_ _424_ VDD VSS sg13g2_nor2_1
X_857_ _425_ uut_full_system_top.uart_busy _139_ VDD VSS sg13g2_nor2_1
X_858_ _102_ uut_full_system_top.uut_uart.data_reg\[0\] uut_full_system_top.adc_result\[0\]
+ _425_ VDD VSS sg13g2_mux2_1
X_859_ _103_ uut_full_system_top.uut_uart.data_reg\[1\] uut_full_system_top.adc_result\[1\]
+ _425_ VDD VSS sg13g2_mux2_1
X_860_ _104_ uut_full_system_top.uut_uart.data_reg\[2\] uut_full_system_top.adc_result\[2\]
+ _425_ VDD VSS sg13g2_mux2_1
X_861_ _105_ uut_full_system_top.uut_uart.data_reg\[3\] uut_full_system_top.adc_result\[3\]
+ _425_ VDD VSS sg13g2_mux2_1
X_862_ _106_ uut_full_system_top.uut_uart.data_reg\[4\] uut_full_system_top.adc_result\[4\]
+ _425_ VDD VSS sg13g2_mux2_1
X_863_ _107_ uut_full_system_top.uut_uart.data_reg\[5\] uut_full_system_top.adc_result\[5\]
+ _425_ VDD VSS sg13g2_mux2_1
X_864_ _108_ uut_full_system_top.uut_uart.data_reg\[6\] uut_full_system_top.adc_result\[6\]
+ _425_ VDD VSS sg13g2_mux2_1
X_865_ _109_ uut_full_system_top.uut_uart.data_reg\[7\] uut_full_system_top.adc_result\[7\]
+ _425_ VDD VSS sg13g2_mux2_1
X_866_ uut_full_system_top.uut_adc_logic.counter\[0\] net49
+ _052_ net36 VDD VSS sg13g2_dfrbpq_1
X_867_ uut_full_system_top.uut_adc_logic.counter\[1\] net49
+ _053_ net36 VDD VSS sg13g2_dfrbpq_1
X_868_ uut_full_system_top.uut_adc_logic.counter\[2\] net51
+ _054_ net38 VDD VSS sg13g2_dfrbpq_1
X_869_ uut_full_system_top.uut_adc_logic.counter\[3\] net49
+ _055_ net36 VDD VSS sg13g2_dfrbpq_1
X_870_ uut_full_system_top.uut_adc_logic.counter\[4\] net51
+ _056_ net38 VDD VSS sg13g2_dfrbpq_1
X_871_ uut_full_system_top.uut_adc_logic.counter\[5\] net51
+ _057_ net38 VDD VSS sg13g2_dfrbpq_1
X_872_ uut_full_system_top.uut_adc_logic.counter\[6\] net52
+ _058_ net38 VDD VSS sg13g2_dfrbpq_1
X_873_ uut_full_system_top.uut_adc_logic.counter\[7\] net52
+ _059_ net38 VDD VSS sg13g2_dfrbpq_1
X_874_ uut_full_system_top.uut_adc_logic.counter\[8\] net52
+ _060_ net38 VDD VSS sg13g2_dfrbpq_1
X_875_ adc_done net48 _061_ net35 VDD VSS sg13g2_dfrbpq_1
X_876_ ramp_en_PIN net48 _062_ net35 VDD VSS sg13g2_dfrbpq_1
X_877_ _039_ net49 _063_ net36 VDD VSS sg13g2_dfrbpq_1
X_878_ uut_full_system_top.adc_result\[0\] net50 _064_ net33
+ VDD VSS sg13g2_dfrbpq_1
X_879_ uut_full_system_top.adc_result\[1\] net50 _065_ net34
+ VDD VSS sg13g2_dfrbpq_1
X_880_ uut_full_system_top.adc_result\[2\] net50 _066_ net33
+ VDD VSS sg13g2_dfrbpq_1
X_881_ uut_full_system_top.adc_result\[3\] net50 _067_ net34
+ VDD VSS sg13g2_dfrbpq_1
X_882_ uut_full_system_top.adc_result\[4\] net50 _068_ net34
+ VDD VSS sg13g2_dfrbpq_1
X_883_ uut_full_system_top.adc_result\[5\] net51 _069_ net40
+ VDD VSS sg13g2_dfrbpq_1
X_884_ uut_full_system_top.adc_result\[6\] net51 _070_ net40
+ VDD VSS sg13g2_dfrbpq_1
X_885_ uut_full_system_top.adc_result\[7\] net51 _071_ net40
+ VDD VSS sg13g2_dfrbpq_1
X_886_ adc_sel_meas_PIN net48 _072_ net30 VDD VSS sg13g2_dfrbpq_1
X_887_ uut_full_system_top.uut_adc_logic.counter_enable net49
+ _073_ net37 VDD VSS sg13g2_dfrbpq_1
X_888_ uut_full_system_top.uut_adc_logic.shift_n\[0\] net52
+ _074_ net39 VDD VSS sg13g2_dfrbpq_1
X_889_ uut_full_system_top.uut_adc_logic.shift_n\[1\] net52
+ _075_ net39 VDD VSS sg13g2_dfrbpq_1
X_890_ uut_full_system_top.uut_adc_logic.shift_n\[2\] net51
+ _076_ net40 VDD VSS sg13g2_dfrbpq_1
X_891_ uut_full_system_top.uut_adc_logic.is_neg net51 _077_
+ net40 VDD VSS sg13g2_dfrbpq_1
X_892_ sc_select_cal_PIN net42 _078_ net37 VDD VSS sg13g2_dfrbpq_1
X_893_ uut_full_system_top.uut_cal_fsm.amplifier_enable net42
+ _079_ net30 VDD VSS sg13g2_dfrbpq_1
X_894_ _040_ net42 _080_ net38 VDD VSS sg13g2_dfrbpq_1
X_895_ _041_ net42 _081_ net38 VDD VSS sg13g2_dfrbpq_1
X_896_ _042_ uut_full_system_top.clk_gated_cal _082_ net39
+ VDD VSS sg13g2_dfrbpq_1
X_897_ _043_ uut_full_system_top.clk_gated_cal _083_ net39
+ VDD VSS sg13g2_dfrbpq_1
X_898_ state_out\[0\] clk _084_ net31 VDD VSS sg13g2_dfrbpq_1
X_899_ state_out\[1\] clk _085_ net31 VDD VSS sg13g2_dfrbpq_1
X_900_ state_out\[2\] clk _086_ net31 VDD VSS sg13g2_dfrbpq_1
X_901_ uut_full_system_top.uut_timer.trigger_flag clk _087_
+ net23 VDD VSS sg13g2_dfrbpq_1
X_902_ uut_full_system_top.uut_timer.clear_flag net54 _088_
+ net VDD VSS sg13g2_dfrbpq_1
X_903_ uut_full_system_top.uut_timer.clk_1hz clk _089_ net25
+ VDD VSS sg13g2_dfrbpq_1
X_904_ uut_full_system_top.uart_busy net43 _090_ net28 VDD
+ VSS sg13g2_dfrbpq_1
X_905_ uut_full_system_top.uart_done net43 _091_ net28 VDD
+ VSS sg13g2_dfrbpq_1
X_906_ uut_full_system_top.uut_uart.baud_counter\[0\] net43
+ _092_ net28 VDD VSS sg13g2_dfrbpq_1
X_907_ uut_full_system_top.uut_uart.baud_counter\[1\] net44
+ _093_ net28 VDD VSS sg13g2_dfrbpq_1
X_908_ uut_full_system_top.uut_uart.baud_counter\[2\] net43
+ _094_ net22 VDD VSS sg13g2_dfrbpq_1
X_909_ uut_full_system_top.uut_uart.baud_counter\[3\] net43
+ _095_ net22 VDD VSS sg13g2_dfrbpq_1
X_910_ uut_full_system_top.uut_uart.baud_counter\[4\] net43
+ _096_ net22 VDD VSS sg13g2_dfrbpq_1
X_911_ uut_full_system_top.uut_uart.baud_counter\[5\] net43
+ _097_ net22 VDD VSS sg13g2_dfrbpq_1
X_912_ uut_full_system_top.uut_uart.baud_counter\[6\] net43
+ _098_ net22 VDD VSS sg13g2_dfrbpq_1
X_913_ uut_full_system_top.uut_uart.bit_index\[0\] net45 _099_
+ net33 VDD VSS sg13g2_dfrbpq_1
X_914_ uut_full_system_top.uut_uart.bit_index\[1\] net45 _100_
+ net29 VDD VSS sg13g2_dfrbpq_1
X_915_ uut_full_system_top.uut_uart.bit_index\[2\] net45 _101_
+ net29 VDD VSS sg13g2_dfrbpq_1
X_916_ uut_full_system_top.uut_uart.data_reg\[0\] net45 _102_
+ net33 VDD VSS sg13g2_dfrbpq_1
X_917_ uut_full_system_top.uut_uart.data_reg\[1\] net45 _103_
+ net33 VDD VSS sg13g2_dfrbpq_1
X_918_ uut_full_system_top.uut_uart.data_reg\[2\] net45 _104_
+ net34 VDD VSS sg13g2_dfrbpq_1
X_919_ uut_full_system_top.uut_uart.data_reg\[3\] net46 _105_
+ net33 VDD VSS sg13g2_dfrbpq_1
X_920_ uut_full_system_top.uut_uart.data_reg\[4\] net46 _106_
+ net34 VDD VSS sg13g2_dfrbpq_1
X_921_ uut_full_system_top.uut_uart.data_reg\[5\] net45 _107_
+ net33 VDD VSS sg13g2_dfrbpq_1
X_922_ uut_full_system_top.uut_uart.data_reg\[6\] net46 _108_
+ net34 VDD VSS sg13g2_dfrbpq_1
X_923_ uut_full_system_top.uut_uart.data_reg\[7\] net46 _109_
+ net33 VDD VSS sg13g2_dfrbpq_1
X_924_ _044_ net44 _048_ net28 VDD VSS sg13g2_dfrbpq_1
X_925_ uut_full_system_top.uut_uart.state\[1\] net44 _006_
+ net29 VDD VSS sg13g2_dfrbpq_1
X_926_ uut_full_system_top.uut_uart.state\[2\] net44 _007_
+ net29 VDD VSS sg13g2_dfrbpq_1
X_927_ uut_full_system_top.uut_uart.state\[3\] net44 _008_
+ net28 VDD VSS sg13g2_dfrbpq_1
X_928_ _045_ net42 net60 net30 VDD VSS sg13g2_dfrbpq_1
X_929_ uut_full_system_top.uut_cal_fsm.state\[1\] net42 _004_
+ net35 VDD VSS sg13g2_dfrbpq_1
X_930_ uut_full_system_top.uut_cal_fsm.state\[2\] net42 uut_full_system_top.uut_cal_fsm.state\[0\]
+ net36 VDD VSS sg13g2_dfrbpq_1
X_931_ uut_full_system_top.uut_cal_fsm.state\[3\] net42 _005_
+ net36 VDD VSS sg13g2_dfrbpq_1
X_932_ _046_ net48 _050_ net35 VDD VSS sg13g2_dfrbpq_1
X_933_ uut_full_system_top.uut_adc_logic.state\[1\] net48
+ _000_ net35 VDD VSS sg13g2_dfrbpq_1
X_934_ uut_full_system_top.uut_adc_logic.state\[2\] net49
+ _002_ net37 VDD VSS sg13g2_dfrbpq_1
X_935_ uut_full_system_top.uut_adc_logic.state\[3\] net49
+ _001_ net37 VDD VSS sg13g2_dfrbpq_1
X_936_ uut_full_system_top.uut_adc_logic.state\[4\] net48
+ _003_ net36 VDD VSS sg13g2_dfrbpq_1
X_937_ _047_ net46 _051_ net34 VDD VSS sg13g2_dfrbpq_1
X_938_ uut_full_system_top.uut_uart.tx_start_sync_2 net45
+ uut_full_system_top.uut_uart.tx_start_sync_1 net29 VDD VSS
+ sg13g2_dfrbpq_1
X_939_ uut_full_system_top.uut_uart.tx_start_sync_1 net44
+ uut_full_system_top.tx_start net29 VDD VSS sg13g2_dfrbpq_1
X_940_ uut_full_system_top.uut_adc_logic.adc_start_sync_1
+ net48 uut_full_system_top.adc_start net30 VDD VSS sg13g2_dfrbpq_1
X_941_ uut_full_system_top.uut_adc_logic.adc_start_sync_2
+ net48 uut_full_system_top.uut_adc_logic.adc_start_sync_1 net35
+ VDD VSS sg13g2_dfrbpq_1
X_942_ uut_full_system_top.uut_fsm.uart_done_sync clk uut_full_system_top.uut_fsm.uart_s0
+ net28 VDD VSS sg13g2_dfrbpq_1
X_943_ uut_full_system_top.uut_fsm.uart_s0 clk uut_full_system_top.uart_done
+ net28 VDD VSS sg13g2_dfrbpq_1
X_944_ uut_full_system_top.uut_fsm.adc_s0 clk adc_done net35
+ VDD VSS sg13g2_dfrbpq_1
X_945_ uut_full_system_top.uut_fsm.adc_done_sync clk uut_full_system_top.uut_fsm.adc_s0
+ net35 VDD VSS sg13g2_dfrbpq_1
X_946_ uut_full_system_top.uut_clock_gating.adc_clk_gate.enable_latched
+ uut_full_system_top.adc_clk_en clk net57 VDD VSS sg13g2_dllrq_1
X_947_ uut_full_system_top.uut_clock_gating.uart_clk_gate.enable_latched
+ uut_full_system_top.uart_en clk net58 VDD VSS sg13g2_dllrq_1
X_948_ uut_full_system_top.uut_clock_gating.cal_clk_gate.enable_latched
+ uut_full_system_top.cal_active clk net59 VDD VSS sg13g2_dllrq_1
X_949_ uut_full_system_top.uut_timer.clear_flag_sync clk uut_full_system_top.uut_timer.clr_d1
+ net23 VDD VSS sg13g2_dfrbpq_1
X_950_ uut_full_system_top.uut_timer.done_d1 clk uut_full_system_top.uut_timer.timer_done_level
+ net27 VDD VSS sg13g2_dfrbpq_1
X_951_ uut_full_system_top.uut_timer.done_d2 clk uut_full_system_top.uut_timer.done_d1
+ net25 VDD VSS sg13g2_dfrbpq_1
X_952_ uut_full_system_top.uut_timer.trig_d2 clk uut_full_system_top.uut_timer.trig_d1
+ net30 VDD VSS sg13g2_dfrbpq_1
X_953_ uut_full_system_top.uut_timer.trig_d1 clk uut_full_system_top.trigger_armed
+ net32 VDD VSS sg13g2_dfrbpq_1
X_954_ uut_full_system_top.uut_timer.clr_d1 clk uut_full_system_top.uut_timer.clear_flag
+ net23 VDD VSS sg13g2_dfrbpq_1
X_955_ uut_full_system_top.uut_timer.u_prescaler.counter\[0\]
+ clk _020_ net23 VDD VSS sg13g2_dfrbpq_1
X_956_ uut_full_system_top.uut_timer.u_prescaler.counter\[1\]
+ clk _030_ net23 VDD VSS sg13g2_dfrbpq_1
X_957_ uut_full_system_top.uut_timer.u_prescaler.counter\[2\]
+ clk _031_ net23 VDD VSS sg13g2_dfrbpq_1
X_958_ uut_full_system_top.uut_timer.u_prescaler.counter\[3\]
+ clk _032_ net24 VDD VSS sg13g2_dfrbpq_1
X_959_ uut_full_system_top.uut_timer.u_prescaler.counter\[4\]
+ clk _033_ net24 VDD VSS sg13g2_dfrbpq_1
X_960_ uut_full_system_top.uut_timer.u_prescaler.counter\[5\]
+ clk _034_ net24 VDD VSS sg13g2_dfrbpq_1
X_961_ uut_full_system_top.uut_timer.u_prescaler.counter\[6\]
+ clk _035_ net24 VDD VSS sg13g2_dfrbpq_1
X_962_ uut_full_system_top.uut_timer.u_prescaler.counter\[7\]
+ clk _036_ net25 VDD VSS sg13g2_dfrbpq_1
X_963_ uut_full_system_top.uut_timer.u_prescaler.counter\[8\]
+ clk _037_ net25 VDD VSS sg13g2_dfrbpq_1
X_964_ uut_full_system_top.uut_timer.u_prescaler.counter\[9\]
+ clk _038_ net25 VDD VSS sg13g2_dfrbpq_1
X_965_ uut_full_system_top.uut_timer.u_prescaler.counter\[10\]
+ clk _021_ net31 VDD VSS sg13g2_dfrbpq_1
X_966_ uut_full_system_top.uut_timer.u_prescaler.counter\[11\]
+ clk _022_ net31 VDD VSS sg13g2_dfrbpq_1
X_967_ uut_full_system_top.uut_timer.u_prescaler.counter\[12\]
+ clk _023_ net32 VDD VSS sg13g2_dfrbpq_1
X_968_ uut_full_system_top.uut_timer.u_prescaler.counter\[13\]
+ clk _024_ net31 VDD VSS sg13g2_dfrbpq_1
X_969_ uut_full_system_top.uut_timer.u_prescaler.counter\[14\]
+ clk _025_ net31 VDD VSS sg13g2_dfrbpq_1
X_970_ uut_full_system_top.uut_timer.u_prescaler.counter\[15\]
+ clk _026_ net31 VDD VSS sg13g2_dfrbpq_1
X_971_ uut_full_system_top.uut_timer.u_prescaler.counter\[16\]
+ clk _027_ net25 VDD VSS sg13g2_dfrbpq_1
X_972_ uut_full_system_top.uut_timer.u_prescaler.counter\[17\]
+ clk _028_ net26 VDD VSS sg13g2_dfrbpq_1
X_973_ uut_full_system_top.uut_timer.u_prescaler.counter\[18\]
+ clk _029_ net23 VDD VSS sg13g2_dfrbpq_1
X_974_ uut_full_system_top.uut_timer.timer_done_level net54
+ _019_ net27 VDD VSS sg13g2_dfrbpq_1
X_975_ uut_full_system_top.uut_timer.u_counter.trig_d1 net54
+ uut_full_system_top.uut_timer.trigger_flag net25 VDD VSS sg13g2_dfrbpq_1
X_976_ uut_full_system_top.uut_timer.u_counter.counter\[0\]
+ net54 _009_ net21 VDD VSS sg13g2_dfrbpq_1
X_977_ uut_full_system_top.uut_timer.u_counter.counter\[1\]
+ net54 _010_ net21 VDD VSS sg13g2_dfrbpq_1
X_978_ uut_full_system_top.uut_timer.u_counter.counter\[2\]
+ net54 _011_ net21 VDD VSS sg13g2_dfrbpq_1
X_979_ uut_full_system_top.uut_timer.u_counter.counter\[3\]
+ net53 _012_ net21 VDD VSS sg13g2_dfrbpq_1
X_980_ uut_full_system_top.uut_timer.u_counter.counter\[4\]
+ net53 _013_ net21 VDD VSS sg13g2_dfrbpq_1
X_981_ uut_full_system_top.uut_timer.u_counter.counter\[5\]
+ net53 _014_ net21 VDD VSS sg13g2_dfrbpq_1
X_982_ uut_full_system_top.uut_timer.u_counter.counter\[6\]
+ net53 _015_ net21 VDD VSS sg13g2_dfrbpq_1
X_983_ uut_full_system_top.uut_timer.u_counter.counter\[7\]
+ net53 _016_ net21 VDD VSS sg13g2_dfrbpq_1
X_984_ uut_full_system_top.uut_timer.u_counter.counter\[8\]
+ net53 _017_ net22 VDD VSS sg13g2_dfrbpq_1
X_985_ uut_full_system_top.uut_timer.u_counter.counter\[9\]
+ net53 _018_ net22 VDD VSS sg13g2_dfrbpq_1
X_986_ uut_full_system_top.uut_timer.u_counter.trig_d2 net54
+ uut_full_system_top.uut_timer.u_counter.trig_d1 net25 VDD
+ VSS sg13g2_dfrbpq_1
X_946__58 net57 VDD VSS sg13g2_tiehi
X_947__59 net58 VDD VSS sg13g2_tiehi
X_948__60 net59 VDD VSS sg13g2_tiehi
X_928__61 net60 VDD VSS sg13g2_tiehi
Xsg13g2_IOPadAnalog_sc_vout IOVDD IOVSS __unconnected100 sc_vout_PAD
+ VDD VSS sg13g2_IOPadAnalog
Xsg13g2_IOPadAnalog_sc_vref IOVDD IOVSS __unconnected102 sc_vref_PAD
+ VDD VSS sg13g2_IOPadAnalog
Xsg13g2_IOPadAnalog_sensor IOVDD IOVSS sensor_PAD sensor_PAD
+ VDD VSS sg13g2_IOPadAnalog
Xsg13g2_IOPadAnalog_vbg IOVDD IOVSS __unconnected103 vbg_PAD VDD VSS
+ sg13g2_IOPadAnalog
Xsg13g2_IOPadAnalog_vdd1v5 IOVDD IOVSS __unconnected107 VDD1v5 VDD VSS
+ sg13g2_IOPadAnalog
Xsg13g2_IOPadAnalog_vramp IOVDD IOVSS __unconnected101 vramp_PAD
+ VDD VSS sg13g2_IOPadAnalog
Xsg13g2_IOPadIOVSS_io_dummy IOVDD IOVSS VDD VSS sg13g2_IOPadIOVss
Xsg13g2_IOPadIOVdd_io IOVDD IOVSS VDD VSS sg13g2_IOPadIOVdd
Xsg13g2_IOPadIOVss_io IOVDD IOVSS VDD VSS sg13g2_IOPadIOVss
Xsg13g2_IOPadIn_clk clk IOVDD IOVSS clk_PAD VDD VSS sg13g2_IOPadOut16mA
Xsg13g2_IOPadIn_reset_n IOVDD IOVSS reset_n_pad_sg reset_n_PAD
+ VDD VSS sg13g2_IOPadIn
Xsg13g2_IOPadIn_sc_enable IOVDD IOVSS sc_enable_pad_sg sc_enable_PAD
+ VDD VSS sg13g2_IOPadIn
Xsg13g2_IOPadIn_trigger IOVDD IOVSS trigger trigger_PAD VDD
+ VSS sg13g2_IOPadIn
Xsg13g2_IOPadOut_adc_done adc_done IOVDD IOVSS adc_done_PAD
+ VDD VSS sg13g2_IOPadOut16mA
Xsg13g2_IOPadOut_state_out_0 net56 IOVDD IOVSS state_out_0_PAD
+ VDD VSS sg13g2_IOPadOut16mA
Xsg13g2_IOPadOut_state_out_1 state_out\[1\] IOVDD IOVSS state_out_1_PAD
+ VDD VSS sg13g2_IOPadOut16mA
Xsg13g2_IOPadOut_state_out_2 net55 IOVDD IOVSS state_out_2_PAD
+ VDD VSS sg13g2_IOPadOut16mA
Xsg13g2_IOPadOut_tx tx IOVDD IOVSS tx_PAD VDD VSS sg13g2_IOPadOut16mA
Xsg13g2_IOPadVdd_core IOVDD IOVSS VDD VSS sg13g2_IOPadVdd
Xsg13g2_IOPadVss_core IOVDD IOVSS VDD VSS sg13g2_IOPadVss
Xuut_soc_analog_top_wrapper IOVDD clk
+ VDD1v5 VDD ramp_en_PIN analog_reset_n_PIN ramp_reset_PIN
+ adc_comp_out_PIN adc_sel_cal_PIN vramp_PAD adc_sel_meas_PIN
+ sc_cal_ref_select\[0\] sc_cal_ref_select\[1\] sc_cal_ref_select\[2\]
+ sc_vout_PAD sc_cal_ref_select\[3\] sc_select_cal_PIN sc_select_sen_PIN
+ cal_comp_out_PIN vbg_PAD singnal_conditionning_en_PIN sensor_PAD VSS
+ sc_vref_PAD SoC_Analog_Top
XIO_CORNER_NORTH_WEST_INST IOVDD IOVSS VDD VSS sg13g2_Corner
XIO_CORNER_NORTH_EAST_INST IOVDD IOVSS VDD VSS sg13g2_Corner
XIO_CORNER_SOUTH_WEST_INST IOVDD IOVSS VDD VSS sg13g2_Corner
XIO_CORNER_SOUTH_EAST_INST IOVDD IOVSS VDD VSS sg13g2_Corner

Xfanout1 net1 _143_ VDD VSS sg13g2_buf_1
Xfanout2 net2 uut_full_system_top.uut_adc_logic.state\[1\]
+ VDD VSS sg13g2_buf_1
Xfanout3 net3 uut_full_system_top.uut_adc_logic.shift_n\[2\]
+ VDD VSS sg13g2_buf_1
Xfanout4 net4 uut_full_system_top.uut_adc_logic.shift_n\[1\]
+ VDD VSS sg13g2_buf_1
Xfanout5 net5 uut_full_system_top.uut_adc_logic.shift_n\[1\]
+ VDD VSS sg13g2_buf_1
Xfanout6 net6 uut_full_system_top.uut_adc_logic.shift_n\[0\]
+ VDD VSS sg13g2_buf_1
Xfanout7 net7 uut_full_system_top.uut_adc_logic.shift_n\[0\]
+ VDD VSS sg13g2_buf_1
Xfanout8 net8 uut_full_system_top.uut_adc_logic.counter\[8\]
+ VDD VSS sg13g2_buf_1
Xfanout9 net9 uut_full_system_top.uut_adc_logic.counter\[8\]
+ VDD VSS sg13g2_buf_1
Xfanout10 net10 uut_full_system_top.uut_adc_logic.counter\[7\]
+ VDD VSS sg13g2_buf_1
Xfanout11 net11 uut_full_system_top.uut_adc_logic.counter\[6\]
+ VDD VSS sg13g2_buf_1
Xfanout12 net12 uut_full_system_top.uut_adc_logic.counter\[5\]
+ VDD VSS sg13g2_buf_1
Xfanout13 net13 uut_full_system_top.uut_adc_logic.counter\[5\]
+ VDD VSS sg13g2_buf_1
Xfanout14 net14 uut_full_system_top.uut_adc_logic.counter\[4\]
+ VDD VSS sg13g2_buf_1
Xfanout15 net15 uut_full_system_top.uut_adc_logic.counter\[4\]
+ VDD VSS sg13g2_buf_1
Xfanout16 net16 net17 VDD VSS sg13g2_buf_1
Xfanout17 net17 uut_full_system_top.uut_adc_logic.counter\[3\]
+ VDD VSS sg13g2_buf_1
Xfanout18 net18 net19 VDD VSS sg13g2_buf_1
Xfanout19 net19 uut_full_system_top.uut_adc_logic.counter\[2\]
+ VDD VSS sg13g2_buf_1
Xfanout20 net20 uut_full_system_top.uut_adc_logic.counter\[1\]
+ VDD VSS sg13g2_buf_1
Xfanout21 net21 net22 VDD VSS sg13g2_buf_1
Xfanout22 net22 net27 VDD VSS sg13g2_buf_1
Xfanout23 net23 net26 VDD VSS sg13g2_buf_1
Xfanout24 net24 net26 VDD VSS sg13g2_buf_1
Xfanout25 net25 net26 VDD VSS sg13g2_buf_1
Xfanout26 net26 net27 VDD VSS sg13g2_buf_1
Xfanout27 net27 reset_n VDD VSS sg13g2_buf_1
Xfanout28 net28 net32 VDD VSS sg13g2_buf_1
Xfanout29 net29 net32 VDD VSS sg13g2_buf_1
Xfanout30 net30 net32 VDD VSS sg13g2_buf_1
Xfanout31 net31 net32 VDD VSS sg13g2_buf_1
Xfanout32 net32 reset_n VDD VSS sg13g2_buf_1
Xfanout33 net33 net34 VDD VSS sg13g2_buf_1
Xfanout34 net34 net41 VDD VSS sg13g2_buf_1
Xfanout35 net35 net36 VDD VSS sg13g2_buf_1
Xfanout36 net36 net41 VDD VSS sg13g2_buf_1
Xfanout37 net37 net41 VDD VSS sg13g2_buf_1
Xfanout38 net38 net40 VDD VSS sg13g2_buf_1
Xfanout39 net39 net40 VDD VSS sg13g2_buf_1
Xfanout40 net40 net41 VDD VSS sg13g2_buf_1
Xfanout41 net41 reset_n VDD VSS sg13g2_buf_1
Xfanout42 net42 uut_full_system_top.clk_gated_cal VDD VSS
+ sg13g2_buf_1
Xfanout43 net43 net47 VDD VSS sg13g2_buf_1
Xfanout44 net44 net47 VDD VSS sg13g2_buf_1
Xfanout45 net45 net47 VDD VSS sg13g2_buf_1
Xfanout46 net46 net47 VDD VSS sg13g2_buf_1
Xfanout47 net47 uut_full_system_top.clk_gated_uart VDD VSS
+ sg13g2_buf_1
Xfanout48 net48 net50 VDD VSS sg13g2_buf_1
Xfanout49 net49 net50 VDD VSS sg13g2_buf_1
Xfanout50 net50 uut_full_system_top.clk_gated_adc VDD VSS
+ sg13g2_buf_1
Xfanout51 net51 uut_full_system_top.clk_gated_adc VDD VSS
+ sg13g2_buf_1
Xfanout52 net52 uut_full_system_top.clk_gated_adc VDD VSS
+ sg13g2_buf_1
Xfanout53 net53 uut_full_system_top.uut_timer.clk_1hz VDD
+ VSS sg13g2_buf_1
Xfanout54 net54 uut_full_system_top.uut_timer.clk_1hz VDD
+ VSS sg13g2_buf_1
Xfanout55 net55 state_out\[2\] VDD VSS sg13g2_buf_1
Xfanout56 net56 state_out\[0\] VDD VSS sg13g2_buf_1
X_902__57 net VDD VSS sg13g2_tiehi
C__0 VSS vbg_PAD cap_cmim w=70e-6 l=70e-6
C__1 VSS VDD cap_cmim w=70e-6 l=40e-6
C__2 VSS VDD1v5 cap_cmim w=70e-6 l=70e-6
M__DECAP VSS VDD VSS VSS sg13_lv_nmos l=1e-6 w=1.6044e-6 m=1000
.ENDS SoC2263
