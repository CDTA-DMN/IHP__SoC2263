** sch_path: /foss/designs/xschemas/TOP/SoC_Analog_Top.sch
.subckt SoC_Analog_Top IOVDD clk VDD VDD1v2 RAMP_EN RESET RAMP_RESET ADC_CMP_OUTPUT ADC_SEL_CAL VRAMP ADC_SEL_MEAS SC_S0 SC_S1
+ SC_S2 SC_VOUT SC_S3 SC_SEL_CAL SC_SEL_SENSOR CMP_RESULT VBG EN SENSOR VSS SC_VREF
*.PININFO VDD:B RAMP_EN:I RAMP_RESET:I ADC_SEL_CAL:I ADC_SEL_MEAS:I ADC_CMP_OUTPUT:O VRAMP:O clk:O RESET:O IOVDD:B VSS:B SC_VOUT:O
*+ SC_S0:I SC_S1:I SC_S2:I SC_S3:I SC_SEL_CAL:I SC_SEL_SENSOR:I VBG:O SC_EN:I CMP_RESULT:O SENSOR:I VDD1v2:B SC_VREF:O
X1 VSS IOVDD SC_VOUT SC_S0 SC_S1 SC_S2 SC_S3 SC_SEL_CAL SC_SEL_SENSOR VBG VBIASH SC_EN VBIAS VDD CMP_RESULT SENSOR SC_VREF VSS
+ top_conditionning
X2 VSS VDD VBIAS_ADC_CMP RAMP_EN RAMP_REF RAMP_RESET ADC_SEL_CAL VDD1v2 ADC_SEL_MEAS SC_VOUT_HOLDED ADC_CMP_OUTPUT VRAMP VSS
+ adc_top_analog
X3 CLK_BIAS RAMP_REF VBIAS_ADC_CMP IOVDD VBIASH VBIAS VDD VSS VBIAS_POR VSS Current_Bank
XCLK1 VDD VSS clk CLK_BIAS VSS clk_1MHz
XPOR1 VDD1v2 RESET VBIAS_POR VSS VSS POR
XPMU1 VBG VSS VDD VDD1v2 IOVDD VSS PMU
x4 VDD SC_EN VSS SC_VOUT_HOLDED SC_VOUT VSS SampleAndHold
.ends

* expanding   symbol:  /foss/designs/xschemas/top_conditionning.sym # of pins=17
** sym_path: /foss/designs/xschemas/top_conditionning.sym
** sch_path: /foss/designs/xschemas/top_conditionning.sch
.subckt top_conditionning VSS IOVDD VOUT S0 S1 S2 S3 SEL_CAL SEL_SENSOR VBG VBIASH EN VBIAS VDD CMP_RESULT SENSOR V96 nbulk
*.PININFO VBIAS:B VOUT:B S0:B S1:B S2:B S3:B VSS:B V96:B SEL_SENSOR:B SEL_CAL:B VDD:B CMP_RESULT:B VBIASH:B IOVDD:B VBG:B EN:B
*+ SENSOR:B
XOPAMP1 CMP_RESULT VSS VDD VBIAS Vmin Vamp EN VSS ota_lv_gmid_comparator
xOPAMP4 IOVDD VBIASH Vamp Vn3 VOUT VSS cond_en VSS ota_hv_slow_gmid
xI1 IOVDD cond_en VBG I1mA VBIASH VSS V96 VSS current_source_1mA
x2 IOVDD EN cond_en VSS Nbulk level_shifter
XOPAMP2 Vamp1 VSS VDD VBIAS V96 Vn1 EN VSS ota_slow_gmid
XOPAMP3 Vamp VSS VDD VBIAS Vtemp Vn2 EN VSS ota_slow_gmid
xref1 V96 SEL_CAL S0 VSS Vmin Vtemp S1 S2 S3 SENSOR SEL_SENSOR I1mA VSS ref_selector
R2 Vn1 net1 rhigh w=0.5e-6 l=0.96e-6 m=1 b=0 ps=0
R6 net1 Vamp1 rhigh w=0.5e-6 l=0.96e-6 m=1 b=0 ps=0
R7 net7 net2 rhigh w=0.5e-6 l=0.96e-6 m=1 b=0 ps=0
R10 net2 Vn1 rhigh w=0.5e-6 l=0.96e-6 m=1 b=0 ps=0
R11 net7 net3 rhigh w=0.5e-6 l=0.96e-6 m=1 b=0 ps=0
R12 net3 net8 rhigh w=0.5e-6 l=0.96e-6 m=1 b=0 ps=0
R13 net9 net4 rhigh w=0.5e-6 l=0.96e-6 m=1 b=0 ps=0
R14 net4 net8 rhigh w=0.5e-6 l=0.96e-6 m=1 b=0 ps=0
R15 net9 net5 rhigh w=0.5e-6 l=0.96e-6 m=1 b=0 ps=0
R16 net5 net10 rhigh w=0.5e-6 l=0.96e-6 m=1 b=0 ps=0
R17 VSS net6 rhigh w=0.5e-6 l=0.96e-6 m=1 b=0 ps=0
R18 net6 net10 rhigh w=0.5e-6 l=0.96e-6 m=1 b=0 ps=0
R5 net11 Vn2 rhigh w=0.5e-6 l=1.6e-6 m=1 b=0 ps=0
R3 Vamp1 net11 rhigh w=0.5e-6 l=1.6e-6 m=1 b=0 ps=0
R4 net12 Vamp rhigh w=0.5e-6 l=1.6e-6 m=1 b=0 ps=0
R19 net17 net12 rhigh w=0.5e-6 l=1.6e-6 m=1 b=0 ps=0
R20 net13 net18 rhigh w=0.5e-6 l=1.6e-6 m=1 b=0 ps=0
R21 net17 net13 rhigh w=0.5e-6 l=1.6e-6 m=1 b=0 ps=0
R22 net14 net18 rhigh w=0.5e-6 l=1.6e-6 m=1 b=0 ps=0
R23 net19 net14 rhigh w=0.5e-6 l=1.6e-6 m=1 b=0 ps=0
R24 net15 net20 rhigh w=0.5e-6 l=1.6e-6 m=1 b=0 ps=0
R25 net19 net15 rhigh w=0.5e-6 l=1.6e-6 m=1 b=0 ps=0
R26 net16 net20 rhigh w=0.5e-6 l=1.6e-6 m=1 b=0 ps=0
R27 Vn2 net16 rhigh w=0.5e-6 l=1.6e-6 m=1 b=0 ps=0
R1 VSS VSS rhigh w=0.5e-6 l=1.6e-6 m=6 b=0 ps=0
R31 VSS VSS rhigh w=0.5e-6 l=0.96e-6 m=16 b=0 ps=0
R32 VSS VSS ptap1 A=40.755e-12 P=249.62e-6
R8 net21 Vn3 rhigh w=0.5e-6 l=1.23e-6 m=1 b=0 ps=0
R9 net21 net22 rhigh w=0.5e-6 l=0.96e-6 m=1 b=0 ps=0
R28 net23 net22 rhigh w=0.5e-6 l=0.96e-6 m=1 b=0 ps=0
R29 net23 net24 rhigh w=0.5e-6 l=0.96e-6 m=1 b=0 ps=0
R30 VSS net24 rhigh w=0.5e-6 l=1.23e-6 m=1 b=0 ps=0
R33 net25 net62 rhigh w=0.5e-6 l=0.96e-6 m=1 b=0 ps=0
R34 net25 net26 rhigh w=0.5e-6 l=0.96e-6 m=1 b=0 ps=0
R35 net31 net26 rhigh w=0.5e-6 l=0.96e-6 m=1 b=0 ps=0
R36 net27 net31 rhigh w=0.5e-6 l=0.96e-6 m=1 b=0 ps=0
R37 net27 net28 rhigh w=0.5e-6 l=0.96e-6 m=1 b=0 ps=0
R38 net29 net28 rhigh w=0.5e-6 l=0.96e-6 m=1 b=0 ps=0
R39 net29 net30 rhigh w=0.5e-6 l=0.96e-6 m=1 b=0 ps=0
R40 net41 net30 rhigh w=0.5e-6 l=0.96e-6 m=1 b=0 ps=0
R41 net32 net41 rhigh w=0.5e-6 l=0.96e-6 m=1 b=0 ps=0
R42 net32 net33 rhigh w=0.5e-6 l=0.96e-6 m=1 b=0 ps=0
R43 net34 net33 rhigh w=0.5e-6 l=0.96e-6 m=1 b=0 ps=0
R44 net34 net35 rhigh w=0.5e-6 l=0.96e-6 m=1 b=0 ps=0
R45 net40 net35 rhigh w=0.5e-6 l=0.96e-6 m=1 b=0 ps=0
R46 net36 net40 rhigh w=0.5e-6 l=0.96e-6 m=1 b=0 ps=0
R47 net36 net37 rhigh w=0.5e-6 l=0.96e-6 m=1 b=0 ps=0
R48 net38 net37 rhigh w=0.5e-6 l=0.96e-6 m=1 b=0 ps=0
R49 net38 net39 rhigh w=0.5e-6 l=0.96e-6 m=1 b=0 ps=0
R50 net61 net39 rhigh w=0.5e-6 l=0.96e-6 m=1 b=0 ps=0
R51 net42 VOUT rhigh w=0.5e-6 l=0.96e-6 m=1 b=0 ps=0
R52 net42 net43 rhigh w=0.5e-6 l=0.96e-6 m=1 b=0 ps=0
R53 net44 net43 rhigh w=0.5e-6 l=0.96e-6 m=1 b=0 ps=0
R54 net44 net45 rhigh w=0.5e-6 l=0.96e-6 m=1 b=0 ps=0
R55 net50 net45 rhigh w=0.5e-6 l=0.96e-6 m=1 b=0 ps=0
R56 net46 net50 rhigh w=0.5e-6 l=0.96e-6 m=1 b=0 ps=0
R57 net46 net47 rhigh w=0.5e-6 l=0.96e-6 m=1 b=0 ps=0
R58 net48 net47 rhigh w=0.5e-6 l=0.96e-6 m=1 b=0 ps=0
R59 net48 net49 rhigh w=0.5e-6 l=0.96e-6 m=1 b=0 ps=0
R60 net60 net49 rhigh w=0.5e-6 l=0.96e-6 m=1 b=0 ps=0
R61 net51 net60 rhigh w=0.5e-6 l=0.96e-6 m=1 b=0 ps=0
R62 net51 net52 rhigh w=0.5e-6 l=0.96e-6 m=1 b=0 ps=0
R63 net53 net52 rhigh w=0.5e-6 l=0.96e-6 m=1 b=0 ps=0
R64 net53 net54 rhigh w=0.5e-6 l=0.96e-6 m=1 b=0 ps=0
R65 net59 net54 rhigh w=0.5e-6 l=0.96e-6 m=1 b=0 ps=0
R66 net55 net59 rhigh w=0.5e-6 l=0.96e-6 m=1 b=0 ps=0
R67 net55 net56 rhigh w=0.5e-6 l=0.96e-6 m=1 b=0 ps=0
R68 net57 net56 rhigh w=0.5e-6 l=0.96e-6 m=1 b=0 ps=0
R69 net57 net58 rhigh w=0.5e-6 l=0.96e-6 m=1 b=0 ps=0
R70 net61 net58 rhigh w=0.5e-6 l=0.96e-6 m=1 b=0 ps=0
R71 net63 net62 rhigh w=0.5e-6 l=0.96e-6 m=1 b=0 ps=0
R72 net63 Vn3 rhigh w=0.5e-6 l=0.96e-6 m=1 b=0 ps=0
.ends

* expanding   symbol:  /foss/designs/xschemas/adc_top_analog.sym # of pins=12
** sym_path: /foss/designs/xschemas/adc_top_analog.sym
** sch_path: /foss/designs/xschemas/adc_top_analog.sch
.subckt adc_top_analog VSS VDD VBIAS RAMP_EN RAMP_REF RAMP_RESET SEL_CAL VCAL SEL_MEAS VMEAS CMP_OUTPUT VRAMP nbulk
*.PININFO CMP_OUTPUT:B VBIAS:B VDD:B VSS:B VRAMP:B RAMP_EN:B RAMP_REF:B RAMP_RESET:B VCAL:B VMEAS:B SEL_MEAS:B SEL_CAL:B
x1 VDD RAMP_EN VRAMP RAMP_RESET VSS RAMP_REF Nbulk Pbulk ramp_generator
XCOMP1 CMP_OUTPUT VSS VDD VBIAS VRAMP net1 RAMP_EN Nbulk ota_lv_gmid_comparator
M1 net1 SEL_MEAS VMEAS VSS sg13_lv_nmos w=20u l=0.13u ng=20
M2 VCAL SEL_CAL net1 VSS sg13_lv_nmos w=20u l=0.13u ng=20
R1 VDD Pbulk ntap1 A=55.716e-12 P=371.44e-6
R2 VSS VSS ptap1 A=59.4709e-12 P=318.23e-6
.ends

* expanding   symbol:  /foss/designs/xschemas/Current_Bank.sym # of pins=9
** sym_path: /foss/designs/xschemas/Current_Bank.sym
** sch_path: /foss/designs/xschemas/Current_Bank.sch
.subckt Current_Bank CLK_BIAS RAMP_REF VBIAS_ADC_CMP IOVDD VBIASH VBIAS VDD VSS VBIAS_POR nbulk
*.PININFO VSS:B VBIAS:B IOVDD:B VBIASH:B VBIAS_POR:B VDD:B RAMP_REF:B VBIAS_ADC_CMP:B CLK_BIAS:B
x1 IOVDD VP VSS Nbulk PbulkH beta_multiplier
M1 VBIAS_POR VP IOVDD PbulkH sg13_hv_pmos w=5u l=2u ng=1 m=2
M2 VBIAS_POR VBIAS_POR VSS nbulk sg13_hv_nmos w=0.5u l=2u ng=1 m=2
M3 VBIAS VBIAS_POR VSS nbulk sg13_hv_nmos w=0.5u l=2u ng=1 m=2
M4 VBIAS VBIAS VDD Pbulk sg13_lv_pmos w=0.5u l=0.5u ng=1 m=2
M5 VBIASH VBIAS_POR VSS nbulk sg13_hv_nmos w=0.5u l=2u ng=1 m=2
M6 VBIASH VBIASH IOVDD PbulkH sg13_hv_pmos w=0.5u l=0.5u ng=1 m=2
M7 RAMP_REF VBIAS VDD Pbulk sg13_lv_pmos w=0.5u l=0.5u ng=1 m=2
M8 VBIAS_ADC_CMP VBIAS_ADC_CMP VDD Pbulk sg13_lv_pmos w=0.5u l=0.5u ng=1 m=2
M9 VBIAS_ADC_CMP VBIAS_POR VSS nbulk sg13_hv_nmos w=0.5u l=2u ng=1 m=2
R1 VDD Pbulk ntap1 A=16.884e-12 P=113.76e-6
R2 VSS nbulk ptap1 A=78.21e-12 P=521.4e-6
R3 IOVDD PbulkH ntap1 A=46.206e-12 P=308.04e-6
M10 CLK_BIAS VBIAS_POR VSS nbulk sg13_hv_nmos w=0.5u l=2u ng=1 m=2
M11 CLK_BIAS CLK_BIAS VDD Pbulk sg13_lv_pmos w=0.5u l=3u ng=1 m=2
M12 VDD VDD VDD Pbulk sg13_lv_pmos w=0.5u l=0.5u ng=1 m=18
M13 IOVDD IOVDD IOVDD PbulkH sg13_hv_pmos w=0.5u l=0.5u ng=1 m=6
M14 IOVDD IOVDD IOVDD PbulkH sg13_hv_pmos w=5u l=1u ng=1 m=4
M15 VSS VSS VSS nbulk sg13_hv_nmos w=1u l=1u ng=1 m=5
.ends

* expanding   symbol:  /foss/designs/xschemas/clk_1MHz.sym # of pins=4
** sym_path: /foss/designs/xschemas/clk_1MHz.sym
** sch_path: /foss/designs/xschemas/clk_1MHz.sch
.subckt clk_1MHz VDD VSS VOUT I1u nbulk
*.PININFO VDD:B VSS:B VOUT:O I1u:I
XINV1 VDD Pbulk VOUT2 net1 Nbulk VSS ring_inv
XINV3 net2 Pbulk net3 VOUT2 Nbulk cpy_n ring_inv
XSCHMITT1 VSS VDD net1 net3 Nbulk VDD ring_schmitt
M2 net2 I1u VDD Pbulk sg13_lv_pmos w=3u l=3u ng=6
M3 cpy_n ref_n VSS Nbulk sg13_lv_nmos w=0.75u l=0.5u ng=1 m=3
M4 ref_n I1u VDD Pbulk sg13_lv_pmos w=1u l=3u ng=2
M5 ref_n ref_n VSS Nbulk sg13_lv_nmos w=0.75u l=0.5u ng=1
XINV2 VDD Pbulk VOUT VOUT2 Nbulk VSS ring_inv
C1 net3 VSS cap_cmim w=42e-6 l=42e-6
R1 VSS Nbulk ptap1 A=16.9974e-12 P=106.74e-6
R2 VDD Pbulk ntap1 A=17.115e-12 P=115.9e-6
M1 ref_n VSS VSS Nbulk sg13_lv_nmos w=0.75u l=0.5u ng=1
M6 VSS VSS cpy_n Nbulk sg13_lv_nmos w=0.75u l=0.5u ng=1
M7 VDD VDD VDD Pbulk sg13_lv_pmos w=1.68u l=1u ng=1 m=2
.ends

* expanding   symbol:  /foss/designs/xschemas/POR.sym # of pins=5
** sym_path: /foss/designs/xschemas/POR.sym
** sch_path: /foss/designs/xschemas/POR.sch
.subckt POR VDD RESET VBIAS VSS Nbulk
*.PININFO VSS:B VDD:B RESET:O VBIAS:I nbulk:B
XSCHMITT1 VSS VDD net2 net1 Nbulk Pbulk ring_schmitt
C1 VSS net1 cap_cmim w=40e-6 l=20e-6
M1 VSS VDD net1 Pbulk sg13_lv_pmos w=9.96u l=0.13u ng=12
XINV1 VDD Pbulk RESET net2 nbulk VSS ring_inv
M2 net1 net3 VDD Pbulk sg13_lv_pmos w=0.5u l=0.5u ng=1 m=2
M3 net3 net3 VDD Pbulk sg13_lv_pmos w=0.5u l=0.5u ng=1 m=2
M4 net3 VBIAS VSS nbulk sg13_hv_nmos w=0.5u l=2u ng=1
R1 VDD Pbulk ntap1 A=24.831e-12 P=166.14e-6
R2 VSS nbulk ptap1 A=12.969e-12 P=88.26e-6
M5 VDD VDD VDD Pbulk sg13_lv_pmos w=0.5u l=0.5u ng=1 m=4
.ends

* expanding   symbol:  /foss/designs/xschemas/PMU.sym # of pins=6
** sym_path: /foss/designs/xschemas/PMU.sym
** sch_path: /foss/designs/xschemas/PMU.sch
.subckt PMU VBG VSS VDD1v5 VDD1v2 IOVDD Nbulk
*.PININFO IOVDD:B VDD1v2:B VBG:O VSS:B VDD1v5:B Nbulk:B
x1 IOVDD VSS Nbulk VBG bgr
x2 IOVDD Nbulk VDD1v5 VBG VSS ldo_1v5_y
x3 IOVDD Nbulk VDD1v2 VBG VSS ldo_1v2_a
.ends

* expanding   symbol:  /foss/designs/xschemas/aymen/SampleAndHold.sym # of pins=6
** sym_path: /foss/designs/xschemas/aymen/SampleAndHold.sym
** sch_path: /foss/designs/xschemas/aymen/SampleAndHold.sch
.subckt SampleAndHold vdd en Nbulk Vout Vin VSS
*.PININFO Vout:O Vin:I en:I vdd:I Nbulk:B VSS:B
x2 vdd en net1 VSS Pbulk Nbulk inverter
x1 net1 Vin Vout Nbulk en Pbulk T_gate
C1 Vout VSS cap_cmim w=40e-6 l=120e-6
R1 vdd Pbulk ntap1 A=7.635e-12 P=52.1e-6
R2 VSS Nbulk ptap1 A=5.499e-12 P=37.86e-6
.ends

* expanding   symbol:  /foss/designs/xschemas/ota_lv_gmid_comparator.sym # of pins=7
** sym_path: /foss/designs/xschemas/ota_lv_gmid_comparator.sym
** sch_path: /foss/designs/xschemas/ota_lv_gmid_comparator.sch
.subckt ota_lv_gmid_comparator Vout VSS VDD Ibias VP VN EN_IN nbulk
*.PININFO VDD:B VSS:B VP:I VN:I Ibias:I Vout:B EN_IN:I
M1 net1 VP net2 Pbulk sg13_lv_pmos w=2.5u l=5u ng=1 m=2
M2 vota VN net2 Pbulk sg13_lv_pmos w=2.5u l=5u ng=1 m=2
M3 vota net1 VSS VSS sg13_lv_nmos w=0.5u l=10u ng=1 m=2
M4 net1 net1 VSS VSS sg13_lv_nmos w=0.5u l=10u ng=1 m=2
M5 net2 Ibias VDD Pbulk sg13_lv_pmos w=2u l=0.5u ng=1
M6 net3 Ibias VDD Pbulk sg13_lv_pmos w=2u l=0.5u ng=1
M7 net3 vota VSS VSS sg13_lv_nmos w=0.5u l=10u ng=1 m=4
M14 net4 EN_IN VSS VSS sg13_lv_nmos w=2u l=0.13u ng=1
M15 net4 EN_IN VDD Pbulk sg13_lv_pmos w=2u l=0.13u ng=1
M8 Ibias EN VDD Pbulk sg13_lv_pmos w=1.425u l=0.13u ng=1 m=14
XSCHMITT1 VSS VDD net5 net3 VSS Pbulk ring_schmitt
M10 EN net4 VSS VSS sg13_lv_nmos w=2u l=0.13u ng=1
M11 EN net4 VDD Pbulk sg13_lv_pmos w=2u l=0.13u ng=1
M12 net6 net5 VSS VSS sg13_lv_nmos w=2u l=0.13u ng=1
M13 net6 net5 VDD Pbulk sg13_lv_pmos w=2u l=0.13u ng=1
M16 Vout net6 VSS VSS sg13_lv_nmos w=2u l=0.13u ng=1
M17 Vout net6 VDD Pbulk sg13_lv_pmos w=2u l=0.13u ng=1
R1 VDD Pbulk ntap1 A=60.213e-12 P=354.9e-6
R2 VSS VSS ptap1 A=28.05e-12 P=188.2e-6
M18 VDD VDD VDD VDD sg13_lv_pmos w=3u l=3u ng=1 m=2
R3 VDD VDD rhigh w=0.5e-6 l=3e-6 m=4 b=0 ps=0
R4 VDD VDD rhigh w=0.5e-6 l=2.5e-6 m=4 b=0 ps=0
M19 VSS VSS VSS VSS sg13_lv_nmos w=0.5u l=2u ng=1 m=8
M20 VDD Ibias VDD Pbulk sg13_lv_pmos w=2u l=0.5u ng=1
M21 VDD VDD VDD Pbulk sg13_lv_pmos w=1u l=0.5u ng=1 m=6
M22 VDD VDD VDD Pbulk sg13_lv_pmos w=2.5u l=2u ng=1 m=8
M9 net3 EN VDD Pbulk sg13_lv_pmos w=1.425u l=0.13u ng=1 m=14
**** begin user architecture code

R0 net1 0 10G

**** end user architecture code
.ends

* expanding   symbol:  /foss/designs/xschemas/ota_hv_slow_gmid.sym # of pins=7
** sym_path: /foss/designs/xschemas/ota_hv_slow_gmid.sym
** sch_path: /foss/designs/xschemas/ota_hv_slow_gmid.sch
.subckt ota_hv_slow_gmid IOVDD Ibias VP VN Vout VSS EN_IN nbulk
*.PININFO VSS:B IOVDD:B Ibias:I VP:B VN:B Vout:B EN_IN:I
M1 net2 VN net1 Pbulk sg13_hv_pmos w=1.785u l=3u ng=1 m=2
M2 VOTA VP net1 Pbulk sg13_hv_pmos w=1.785u l=3u ng=1 m=2
M3 net2 net2 VSS Nbulk sg13_hv_nmos w=4.275u l=10u ng=1 m=2
M4 VOTA net2 VSS Nbulk sg13_hv_nmos w=4.275u l=10u ng=1 m=2
M5 net1 Ibias IOVDD Pbulk sg13_hv_pmos w=1u l=0.5u ng=1 m=2
M6 VAMP Ibias IOVDD Pbulk sg13_hv_pmos w=1u l=0.5u ng=1 m=2
M8 Ibiasn Ibias IOVDD Pbulk sg13_hv_pmos w=1u l=0.5u ng=1 m=2
C1 VOTA VAMP cap_cmim w=20e-6 l=20e-6
M10 Ibiasn Ibiasn VSS Nbulk sg13_hv_nmos w=1u l=1u ng=1
M11 Vout Ibiasn VSS Nbulk sg13_hv_nmos w=1u l=1u ng=1 m=2
M9 IOVDD VAMP Vout Nbulk sg13_hv_nmos w=1u l=1u ng=1 m=10
M12 Ibias EN IOVDD Pbulk sg13_hv_pmos w=8.94u l=0.4u ng=1
M13 EN_N EN_IN IOVDD Pbulk sg13_hv_pmos w=2u l=0.45u ng=1
M14 EN_N EN_IN VSS Nbulk sg13_hv_nmos w=1.2u l=0.45u ng=1
M15 VAMP EN_N VSS Nbulk sg13_hv_nmos w=44.76u l=0.45u ng=10
M16 EN EN_N IOVDD Pbulk sg13_hv_pmos w=2u l=0.45u ng=1
M17 EN EN_N VSS Nbulk sg13_hv_nmos w=1.2u l=0.45u ng=1
M7 VAMP VOTA VSS Nbulk sg13_hv_nmos w=4.275u l=10u ng=1 m=4
M18 VSS VSS VSS Nbulk sg13_hv_nmos w=4.275u l=4u ng=1 m=8
M19 IOVDD IOVDD IOVDD Pbulk sg13_hv_pmos w=1.785u l=3u ng=1 m=12
M20 IOVDD IOVDD IOVDD Pbulk sg13_hv_pmos w=1u l=0.5u ng=1 m=12
M21 VSS VSS VSS Nbulk sg13_hv_nmos w=1u l=1u ng=1 m=7
M22 VSS VSS Ibiasn Nbulk sg13_hv_nmos w=1u l=1u ng=1
R1 IOVDD Pbulk ntap1 A=68.477e-12 P=336.32e-6
R2 VSS Nbulk ptap1 A=81.9645e-12 P=420.3e-6
.ends

* expanding   symbol:  /foss/designs/xschemas/current_source_1mA.sym # of pins=7
** sym_path: /foss/designs/xschemas/current_source_1mA.sym
** sch_path: /foss/designs/xschemas/current_source_1mA.sch
.subckt current_source_1mA IOVDD EN_IN Vbg_1V I1mA Ibias VSS I100uA nbulk
*.PININFO IOVDD:B Ibias:I VSS:B EN_IN:I Vbg_1V:I I1mA:O I100uA:O
M1 Iref Vota Vcp Nbulk sg13_hv_nmos w=6u l=0.5u ng=8
M2 Iref Iref IOVDD Pbulk sg13_hv_pmos w=1.5u l=0.5u ng=1 m=2
xopamp1 IOVDD Ibias Vcp Vbg_1V Vota VSS EN_IN Pbulk Nbulk ota_med_hv_gmid
M3 I1mA Iref IOVDD Pbulk sg13_hv_pmos w=1.5u l=0.5u ng=1 m=20
M4 I100uA Iref IOVDD Pbulk sg13_hv_pmos w=1.5u l=0.5u ng=1 m=2
M8 Iref EN_IN IOVDD Pbulk sg13_hv_pmos w=14u l=0.4u ng=7
R6 net1 Vcp rppd w=0.5e-6 l=1.775e-6 m=1 b=1 ps=0.18e-6
R7 net2 net1 rppd w=0.5e-6 l=1.775e-6 m=1 b=1 ps=0.18e-6
R8 net3 net2 rppd w=0.5e-6 l=1.775e-6 m=1 b=1 ps=0.18e-6
R9 net4 net3 rppd w=0.5e-6 l=1.775e-6 m=1 b=1 ps=0.18e-6
R10 VSS net4 rppd w=0.5e-6 l=1.675e-6 m=1 b=1 ps=0.18e-6
R3 VSS VSS rppd w=0.5e-6 l=1.755e-6 m=10 b=1 ps=0.18e-6
M5 VSS VSS Vcp Nbulk sg13_hv_nmos w=0.75u l=0.5u ng=1 m=2
M6 IOVDD IOVDD IOVDD Pbulk sg13_hv_pmos w=1.5u l=0.5u ng=1 m=8
R4 IOVDD Pbulk ntap1 A=54.8005e-12 P=273.23e-6
R1 VSS Nbulk ptap1 A=37.6962e-12 P=225.34e-6
.ends

* expanding   symbol:  /foss/designs/xschemas/level_shifter.sym # of pins=4
** sym_path: /foss/designs/xschemas/level_shifter.sym
** sch_path: /foss/designs/xschemas/level_shifter.sch
.subckt level_shifter IOVDD IN OUT VSS nbulk
*.PININFO IN:I OUT:O IOVDD:B VSS:B
M1 shift IN IOVDD IOVDD sg13_hv_pmos w=0.6u l=0.45u ng=1
M2 shift IN VSS VSS sg13_hv_nmos w=5u l=0.45u ng=1
M3 OUT shift IOVDD IOVDD sg13_hv_pmos w=2u l=0.45u ng=1
M4 OUT shift VSS VSS sg13_hv_nmos w=1.2u l=0.45u ng=1
.ends

* expanding   symbol:  /foss/designs/xschemas/ota_slow_gmid.sym # of pins=7
** sym_path: /foss/designs/xschemas/ota_slow_gmid.sym
** sch_path: /foss/designs/xschemas/ota_slow_gmid.sch
.subckt ota_slow_gmid Vout VSS VDD Ibias Vp Vn EN_IN nbulk
*.PININFO VDD:B VSS:B Vp:I Vn:I Ibias:I EN_IN:I Vout:B
M1 net1 Vn net2 Pbulk sg13_lv_pmos w=2.5u l=5u ng=1 m=2
M2 vota Vp net2 Pbulk sg13_lv_pmos w=2.5u l=5u ng=1 m=2
M3 vota net1 VSS VSS sg13_lv_nmos w=0.5u l=10u ng=1 m=2
M4 net1 net1 VSS VSS sg13_lv_nmos w=0.5u l=10u ng=1 m=2
M5 net2 Ibias VDD Pbulk sg13_lv_pmos w=1u l=0.5u ng=1 m=2
M6 Vout1 Ibias VDD Pbulk sg13_lv_pmos w=1u l=0.5u ng=1 m=2
M7 Vout1 vota VSS VSS sg13_lv_nmos w=0.5u l=10u ng=1 m=4
M8 net3 vota net3 net3 sg13_lv_pmos w=3u l=3u ng=1 m=3
R1 net3 Vout1 rhigh w=0.5e-6 l=22e-6 m=1 b=0 ps=0
M11 Ibiasn Ibiasn VSS VSS sg13_lv_nmos w=0.25u l=0.5u ng=1 m=4
M12 Ibiasn Ibias VDD Pbulk sg13_lv_pmos w=1u l=0.5u ng=1 m=2
M13 Ibias EN VDD Pbulk sg13_lv_pmos w=10u l=0.13u ng=10 m=2
M14 EN_N EN_IN VSS VSS sg13_lv_nmos w=2u l=0.13u ng=1
M15 EN_N EN_IN VDD Pbulk sg13_lv_pmos w=2u l=0.13u ng=1
M16 EN EN_N VSS VSS sg13_lv_nmos w=2u l=0.13u ng=1
M17 EN EN_N VDD Pbulk sg13_lv_pmos w=2u l=0.13u ng=1
M18 Vout1 EN_N VSS VSS sg13_lv_nmos w=12u l=0.13u ng=10 m=2
M19 Vout Ibiasn VSS VSS sg13_lv_nmos w=0.25u l=0.5u ng=1 m=60
M21 VDD Vout1 Vout VSS sg13_lv_nmos w=1u l=0.13u ng=1
M9 VSS VSS VSS VSS sg13_lv_nmos w=0.25u l=0.5u ng=1 m=32
M10 VSS VSS VSS VSS sg13_lv_nmos w=1u l=0.13u ng=1 m=12
M20 Vout VSS VSS VSS sg13_lv_nmos w=1u l=0.13u ng=1
M22 VSS VSS VDD VSS sg13_lv_nmos w=1u l=0.13u ng=1
M23 VSS VSS VSS VSS sg13_lv_nmos w=0.5u l=2u ng=1 m=8
M24 VDD VDD VDD Pbulk sg13_lv_pmos w=2.5u l=2u ng=1 m=8
R3 VSS VSS rhigh w=0.5e-6 l=3e-6 m=2 b=0 ps=0
R4 VSS VSS rhigh w=0.5e-6 l=2.5e-6 m=2 b=0 ps=0
M25 VDD VDD VDD Pbulk sg13_lv_pmos w=1u l=0.5u ng=1 m=6
R2 VDD Pbulk ntap1 A=45.85335e-12 P=251.98e-6
R5 VSS VSS ptap1 A=57.8892e-12 P=342.32e-6
.ends

* expanding   symbol:  /foss/designs/xschemas/ref_selector.sym # of pins=12
** sym_path: /foss/designs/xschemas/ref_selector.sym
** sch_path: /foss/designs/xschemas/ref_selector.sch
.subckt ref_selector Vref Scal S0 VSS Vmin Vmeas S1 S2 S3 Sen Ssen i1mA nbulk
*.PININFO VSS:B S0:I S1:I S2:I S3:I Vref:B Vmeas:B Vmin:B Scal:I Ssen:I Sen:B i1mA:B
M2 Vref S0 R0 Nbulk sg13_lv_nmos w=3u l=0.13u ng=1
M3 Vref S1 R1 Nbulk sg13_lv_nmos w=3u l=0.13u ng=1
M4 Vref S2 R2 Nbulk sg13_lv_nmos w=3u l=0.13u ng=1
M5 Vref S3 R3 Nbulk sg13_lv_nmos w=3u l=0.13u ng=1
M6 i1mA Ssen Sen Nbulk sg13_lv_nmos w=10u l=0.13u ng=1
M8 i1mA Scal Vcal Nbulk sg13_lv_nmos w=10u l=0.13u ng=1
M1 Vmeas Ssen Sen Nbulk sg13_lv_nmos w=5u l=0.13u ng=1
M7 Vmeas Scal Vcal Nbulk sg13_lv_nmos w=5u l=0.13u ng=1
R1 Vmin Vref rppd w=0.5e-6 l=1.43e-6 m=1 b=0 ps=0e-6
R4 net2 R3 rhigh w=0.5e-6 l=1.6e-6 m=1 b=0 ps=0
R5 net2 net1 rhigh w=0.5e-6 l=1.6e-6 m=1 b=0 ps=0
R6 Vmin net1 rhigh w=0.5e-6 l=1.6e-6 m=1 b=0 ps=0
R7 net4 net5 rhigh w=0.5e-6 l=1.6e-6 m=1 b=0 ps=0
R8 net4 net3 rhigh w=0.5e-6 l=1.6e-6 m=1 b=0 ps=0
R9 Vmin net3 rhigh w=0.5e-6 l=1.6e-6 m=1 b=0 ps=0
R10 net7 R2 rhigh w=0.5e-6 l=1.6e-6 m=1 b=0 ps=0
R11 net7 net6 rhigh w=0.5e-6 l=1.6e-6 m=1 b=0 ps=0
R12 net5 net6 rhigh w=0.5e-6 l=1.6e-6 m=1 b=0 ps=0
R13 net9 net10 rhigh w=0.5e-6 l=1.6e-6 m=1 b=0 ps=0
R14 net9 net8 rhigh w=0.5e-6 l=1.6e-6 m=1 b=0 ps=0
R15 Vmin net8 rhigh w=0.5e-6 l=1.6e-6 m=1 b=0 ps=0
R16 net12 net13 rhigh w=0.5e-6 l=1.6e-6 m=1 b=0 ps=0
R17 net12 net11 rhigh w=0.5e-6 l=1.6e-6 m=1 b=0 ps=0
R18 net10 net11 rhigh w=0.5e-6 l=1.6e-6 m=1 b=0 ps=0
R19 net15 net16 rhigh w=0.5e-6 l=1.6e-6 m=1 b=0 ps=0
R20 net15 net14 rhigh w=0.5e-6 l=1.6e-6 m=1 b=0 ps=0
R21 R1 net14 rhigh w=0.5e-6 l=1.6e-6 m=1 b=0 ps=0
R22 net18 net13 rhigh w=0.5e-6 l=1.6e-6 m=1 b=0 ps=0
R23 net18 net17 rhigh w=0.5e-6 l=1.6e-6 m=1 b=0 ps=0
R24 net16 net17 rhigh w=0.5e-6 l=1.6e-6 m=1 b=0 ps=0
R25 net20 net21 rhigh w=0.5e-6 l=1.6e-6 m=1 b=0 ps=0
R26 net20 net19 rhigh w=0.5e-6 l=1.6e-6 m=1 b=0 ps=0
R27 net22 net19 rhigh w=0.5e-6 l=1.6e-6 m=1 b=0 ps=0
R28 net24 net25 rhigh w=0.5e-6 l=1.6e-6 m=1 b=0 ps=0
R29 net24 net23 rhigh w=0.5e-6 l=1.6e-6 m=1 b=0 ps=0
R30 net21 net23 rhigh w=0.5e-6 l=1.6e-6 m=1 b=0 ps=0
R31 net27 net28 rhigh w=0.5e-6 l=1.6e-6 m=1 b=0 ps=0
R32 net27 net26 rhigh w=0.5e-6 l=1.6e-6 m=1 b=0 ps=0
R33 R0 net26 rhigh w=0.5e-6 l=1.6e-6 m=1 b=0 ps=0
R34 net30 net25 rhigh w=0.5e-6 l=1.6e-6 m=1 b=0 ps=0
R35 net30 net29 rhigh w=0.5e-6 l=1.6e-6 m=1 b=0 ps=0
R36 net28 net29 rhigh w=0.5e-6 l=1.6e-6 m=1 b=0 ps=0
R37 net32 net33 rhigh w=0.5e-6 l=1.6e-6 m=1 b=0 ps=0
R38 net32 net31 rhigh w=0.5e-6 l=1.6e-6 m=1 b=0 ps=0
R39 net22 net31 rhigh w=0.5e-6 l=1.6e-6 m=1 b=0 ps=0
R40 net35 net36 rhigh w=0.5e-6 l=1.6e-6 m=1 b=0 ps=0
R41 net35 net34 rhigh w=0.5e-6 l=1.6e-6 m=1 b=0 ps=0
R42 net33 net34 rhigh w=0.5e-6 l=1.6e-6 m=1 b=0 ps=0
R43 net38 net39 rhigh w=0.5e-6 l=1.6e-6 m=1 b=0 ps=0
R44 net38 net37 rhigh w=0.5e-6 l=1.6e-6 m=1 b=0 ps=0
R45 Vmin net37 rhigh w=0.5e-6 l=1.6e-6 m=1 b=0 ps=0
R46 net41 net36 rhigh w=0.5e-6 l=1.6e-6 m=1 b=0 ps=0
R47 net41 net40 rhigh w=0.5e-6 l=1.6e-6 m=1 b=0 ps=0
R48 net39 net40 rhigh w=0.5e-6 l=1.6e-6 m=1 b=0 ps=0
R2 VSS Vcal rppd w=0.5e-6 l=1.43e-6 m=10 b=0 ps=0e-6
C2 VSS Vmin cap_cmim w=20e-6 l=10e-6
C1 VSS Vcal cap_cmim w=20e-6 l=10e-6
R49 VSS Vmin rppd w=0.5e-6 l=1.43e-6 m=14 b=0 ps=0e-6
R50 VSS VSS rhigh w=0.5e-6 l=1.6e-6 m=20 b=0 ps=0
R51 VSS VSS rppd w=0.5e-6 l=1.43e-6 m=20 b=0 ps=0e-6
R3 VSS Nbulk ptap1 A=60.426e-12 P=402.84e-6
.ends

* expanding   symbol:  /foss/designs/xschemas/aymen/ramp_generator.sym # of pins=6
** sym_path: /foss/designs/xschemas/aymen/ramp_generator.sym
** sch_path: /foss/designs/xschemas/aymen/ramp_generator.sch
.subckt ramp_generator vdd ramp_en vramp Reset VSS RAMP_REF nbulk pbulk
*.PININFO ramp_en:I VSS:B vdd:B Reset:I vramp:O RAMP_REF:I
M5 vramp Reset VSS VSS sg13_lv_nmos w=52.8u l=0.13u ng=10
M6 vramp net1 vdd pbulk sg13_lv_pmos w=0.15u l=10u ng=1 m=2
M1 net1 net1 vdd pbulk sg13_lv_pmos w=0.15u l=10u ng=1 m=30
M2 net1 ramp_en vdd pbulk sg13_lv_pmos w=40u l=0.13u ng=1
M3 VSS RAMP_REF net1 VSS sg13_lv_nmos w=0.3u l=10u ng=1 m=2
M4 VSS RAMP_REF RAMP_REF VSS sg13_lv_nmos w=0.3u l=10u ng=1 m=6
C2 VSS vramp cap_cmim w=40e-6 l=40e-6 m=2
M7 vdd vdd vdd Pbulk sg13_lv_pmos w=0.15u l=5u ng=1 m=16
M8 VSS VSS VSS VSS sg13_lv_nmos w=0.3u l=10u ng=1 m=8
.ends

* expanding   symbol:  /foss/designs/xschemas/brahim/beta_multiplier.sym # of pins=3
** sym_path: /foss/designs/xschemas/brahim/beta_multiplier.sym
** sch_path: /foss/designs/xschemas/brahim/beta_multiplier.sch
.subckt beta_multiplier IOVDD VP VSS nbulk pbulk
*.PININFO IOVDD:B VSS:B VP:B
M1 net1 net1 IOVDD Pbulk sg13_hv_pmos w=5u l=1u ng=1 m=2
M2 net2 VR VSS Nbulk sg13_hv_nmos w=10u l=0.45u ng=1 m=2
M3 net2 net1 IOVDD Pbulk sg13_hv_pmos w=5u l=1u ng=1 m=2
M4 VP net2 VR nbulk sg13_hv_nmos w=10u l=0.45u ng=1 m=10
C1 net1 VSS cap_cmim w=10.0e-6 l=6.63e-6
M5 VP VP IOVDD Pbulk sg13_hv_pmos w=5u l=2u ng=1 m=2
M6 VN VP IOVDD Pbulk sg13_hv_pmos w=5u l=2u ng=1 m=2
M7 VP VN VR nbulk sg13_hv_nmos w=10u l=1u ng=1 m=4
M8 VN VR VSS nbulk sg13_hv_nmos w=10u l=1u ng=1
R1 VSS VR rhigh w=0.5e-6 l=184.92e-6 m=1 b=0 ps=0
M9 IOVDD IOVDD IOVDD Pbulk sg13_hv_pmos w=5u l=1u ng=1 m=4
M10 IOVDD IOVDD IOVDD Pbulk sg13_hv_pmos w=5u l=1u ng=1 m=4
M11 VSS VSS VSS nbulk sg13_hv_nmos w=10u l=1u ng=1
M12 VP VSS VP nbulk sg13_hv_nmos w=10u l=1u ng=1 m=2
M13 VSS VSS VSS nbulk sg13_hv_nmos w=10u l=0.45u ng=1 m=6
R2 IOVDD Pbulk ntap1 A=3.24e-12 P=2.16e-05
R3 VSS nbulk ptap1 A=3.24e-12 P=2.16e-05
R4 IOVDD Pbulk ntap1 A=3.24e-12 P=2.16e-05
R5 VSS nbulk ptap1 A=3.24e-12 P=2.16e-05
R6 VSS nbulk ptap1 A=3.24e-12 P=2.16e-05
M14 VSS VSS VN nbulk sg13_hv_nmos w=10u l=1u ng=1
.ends

* expanding   symbol:  /foss/designs/xschemas/ring_inv.sym # of pins=6
** sym_path: /foss/designs/xschemas/ring_inv.sym
** sch_path: /foss/designs/xschemas/ring_inv.sch
.subckt ring_inv VDP Pbulk Y A Nbulk VSN
*.PININFO A:I Y:O Pbulk:B Nbulk:B VDP:B VSN:B
M1 Y A VSN Nbulk sg13_lv_nmos w=0.7u l=0.13u ng=1
M2 Y A VDP Pbulk sg13_lv_pmos w=1.12u l=0.13u ng=1
.ends

* expanding   symbol:  /foss/designs/xschemas/ring_schmitt.sym # of pins=4
** sym_path: /foss/designs/xschemas/ring_schmitt.sym
** sch_path: /foss/designs/xschemas/ring_schmitt.sch
.subckt ring_schmitt VSS VDD Y A nbulk pbulk
*.PININFO A:I Y:O VDD:B VSS:B
M1 Y A VSPL nbulk sg13_lv_nmos w=10u l=0.13u ng=5
M2 Y A net1 pbulk sg13_lv_pmos w=6.25u l=0.13u ng=5
M3 VSPL A VSS nbulk sg13_lv_nmos w=0.155u l=0.5u ng=1
M4 net1 A VDD pbulk sg13_lv_pmos w=0.5u l=0.5u ng=1
M5 VSS Y net1 pbulk sg13_lv_pmos w=2.5u l=1u ng=1
M6 VDD Y VSPL nbulk sg13_lv_nmos w=2.945u l=0.5u ng=19
.ends

* expanding   symbol:  /foss/designs/xschemas/Ali/bgr.sym # of pins=4
** sym_path: /foss/designs/xschemas/Ali/bgr.sym
** sch_path: /foss/designs/xschemas/Ali/bgr.sch
.subckt bgr IOVDD VSS Nbulk VBG
*.PININFO VBG:B IOVDD:B VSS:B Nbulk:B
M13 VN net2 IOVDD Pbulk sg13_hv_pmos w=6u l=2u ng=2
M17 VSS VP VN Nbulk sg13_hv_nmos w=5u l=1u ng=1
M14 VP net2 IOVDD Pbulk sg13_hv_pmos w=24u l=2u ng=4
M15 VBG net2 IOVDD Pbulk sg13_hv_pmos w=10u l=1.8u ng=8
M16 VSS Vt Vt Nbulk sg13_hv_nmos w=25u l=1.5u ng=8
M18 IOVDD net1 VN Nbulk sg13_hv_nmos w=2u l=5u ng=1
M20 net1 VBG IOVDD Pbulk sg13_hv_pmos w=0.5u l=10u ng=1
M21 net1 VBG VSS Nbulk sg13_hv_nmos w=10u l=1u ng=1
x1 IOVDD net2 VP VN VSS PbulkO Nbulk opm_fixed
R4 IOVDD Pbulk ntap1 A=38.94e-12 P=259.6e-6
R5 VSS Nbulk ptap1 A=131.19e-12 P=795.16e-6
R6 IOVDD PbulkO ntap1 A=51.216e-12 P=341.44e-6
M1 VN IOVDD IOVDD Pbulk sg13_hv_pmos w=6u l=2u ng=1
M2 VSS VSS VSS Nbulk sg13_hv_nmos w=13.43u l=1.5u ng=2 m=2
M3 IOVDD IOVDD IOVDD Pbulk sg13_hv_pmos w=3.295u l=0.5u ng=1 m=2
M4 IOVDD IOVDD IOVDD Pbulk sg13_hv_pmos w=6u l=2u ng=2
R7 VSS VSS rppd w=0.5e-6 l=1.905e-6 m=24 b=0 ps=0e-6
R13 Vt VP rppd w=0.5e-6 l=39.6e-6 m=1 b=0 ps=0e-6
R14 VSS VP rppd w=0.5e-6 l=11.43e-6 m=1 b=0 ps=0e-6
R9 VSS net3 rppd w=0.5e-6 l=11.43e-6 m=4 b=0 ps=0e-6
R8 VBG net4 rppd w=0.5e-6 l=11.43e-6 m=2 b=0 ps=0e-6
R10 net3 net4 rppd w=0.5e-6 l=13.2e-6 m=1 b=0 ps=0e-6
.ends

* expanding   symbol:  /foss/designs/xschemas/ldo_1v5_y.sym # of pins=5
** sym_path: /foss/designs/xschemas/ldo_1v5_y.sym
** sch_path: /foss/designs/xschemas/ldo_1v5_y.sch
.subckt ldo_1v5_y IOVDD Nbulk VDD1v5 VBG VSS
*.PININFO VDD1v5:B VBG:B IOVDD:B VSS:B Nbulk:B
M1 net1 net1 IOVDD Pbulk sg13_hv_pmos w=5u l=1u ng=1 m=2
M2 net1 Vfb net3 Nbulk sg13_hv_nmos w=10u l=2u ng=1 m=2
M3 net2 net1 IOVDD Pbulk sg13_hv_pmos w=5u l=1u ng=1 m=2
M5 net2 VBG net3 Nbulk sg13_hv_nmos w=10u l=2u ng=1 m=2
M6 vref vref IOVDD Pbulk sg13_hv_pmos w=0.5u l=10u ng=1
M4 net3 vref VSS Nbulk sg13_hv_nmos w=4.5u l=2u ng=1 m=2
M7 vref vref VSS Nbulk sg13_hv_nmos w=4.5u l=2u ng=1
M8 VDD1v5 net2 IOVDD Pbulk sg13_hv_pmos w=399.9u l=1u ng=40
R1 net2 net4 rhigh w=0.7e-6 l=5.7e-6 m=1 b=1 ps=0.18e-6
R2 VDD1v5 Vfb rhigh w=0.5e-6 l=17e-6 m=1 b=1 ps=0.18e-6
R3 Vfb VSS rhigh w=0.5e-6 l=34e-6 m=1 b=1 ps=0.18e-6
C1 net4 VDD1v5 cap_cmim w=33.85e-6 l=47.23e-6
R5 IOVDD Pbulk ntap1 A=56.376e-12 P=375.84e-6
R6 VSS Nbulk ptap1 A=59.9255e-12 P=351.41e-6
R4 VSS VSS rhigh w=0.5e-6 l=1.7e-6 m=10 b=1 ps=0.18e-6
M9 VSS VSS VSS Nbulk sg13_hv_nmos w=4.5u l=2u ng=1
M10 VSS VSS vref Nbulk sg13_hv_nmos w=4.5u l=2u ng=1
M11 VSS VSS VSS Nbulk sg13_hv_nmos w=10u l=2u ng=1 m=4
M12 IOVDD IOVDD IOVDD Pbulk sg13_hv_pmos w=5u l=1u ng=1 m=4
.ends

* expanding   symbol:  /foss/designs/xschemas/ldo_1v2_a.sym # of pins=5
** sym_path: /foss/designs/xschemas/ldo_1v2_a.sym
** sch_path: /foss/designs/xschemas/ldo_1v2_a.sch
.subckt ldo_1v2_a IOVDD Nbulk VDD1v2 VBG VSS
*.PININFO VDD1v2:B VBG:B IOVDD:B VSS:B Nbulk:B
M1 net1 net1 IOVDD Pbulk sg13_hv_pmos w=5u l=1u ng=1 m=2
M2 net1 Vfb net3 Nbulk sg13_hv_nmos w=10u l=2u ng=1 m=2
M3 net2 net1 IOVDD Pbulk sg13_hv_pmos w=5u l=1u ng=1 m=2
M5 net2 VBG net3 Nbulk sg13_hv_nmos w=10u l=2u ng=1 m=2
M6 vref vref IOVDD Pbulk sg13_hv_pmos w=0.5u l=10u ng=1
M4 net3 vref VSS Nbulk sg13_hv_nmos w=4.5u l=2u ng=1 m=2
M7 vref vref VSS Nbulk sg13_hv_nmos w=4.5u l=2u ng=1
M8 VDD1v2 net2 IOVDD PbulkP sg13_hv_pmos w=10u l=1u ng=1 m=35
R1 net2 net4 rhigh w=0.52e-6 l=7.87e-6 m=1 b=0 ps=0
R2 VDD1v2 Vfb rhigh w=0.5e-6 l=3.84e-6 m=1 b=0 ps=0
R3 Vfb VSS rhigh w=0.5e-6 l=19.2e-6 m=1 b=0 ps=0
C1 net4 VDD1v2 cap_cmim w=33.85e-6 l=47.23e-6
R5 IOVDD Pbulk ntap1 A=23.016e-12 P=153.44e-6
R6 VSS Nbulk ptap1 A=52.3527e-12 P=304.37e-6
R7 IOVDD PbulkP ntap1 A=33.504e-12 P=223.36e-6
R4 VSS VSS rhigh w=0.5e-6 l=0.96e-6 m=12 b=0 ps=0
M9 VSS VSS VSS Nbulk sg13_hv_nmos w=4.5u l=2u ng=1
M10 VSS VSS vref Nbulk sg13_hv_nmos w=4.5u l=2u ng=1
M11 VSS VSS VSS Nbulk sg13_hv_nmos w=10u l=2u ng=1 m=4
M12 IOVDD IOVDD IOVDD Pbulk sg13_hv_pmos w=5u l=1u ng=1 m=4
.ends

* expanding   symbol:  /foss/designs/xschemas/aymen/inverter.sym # of pins=6
** sym_path: /foss/designs/xschemas/aymen/inverter.sym
** sch_path: /foss/designs/xschemas/aymen/inverter.sch
.subckt inverter vdd vi vo gnd Pbulk Nbulk
*.PININFO vi:B vo:B gnd:B vdd:B Pbulk:B Nbulk:B
M5 vo vi vdd Pbulk sg13_lv_pmos w=1200n l=130n ng=1
M7 vo vi gnd Nbulk sg13_lv_nmos w=780n l=130n ng=1
.ends

* expanding   symbol:  /foss/designs/xschemas/aymen/T_gate.sym # of pins=6
** sym_path: /foss/designs/xschemas/aymen/T_gate.sym
** sch_path: /foss/designs/xschemas/aymen/T_gate.sch
.subckt T_gate !Control Vin Vout gnd Control vdd
*.PININFO Vout:B Vin:B !Control:B Control:B gnd:B vdd:B
M1 Vin Control Vout gnd sg13_lv_nmos w=6u l=0.13u ng=1
M2 Vin !Control Vout vdd sg13_lv_pmos w=10u l=0.13u ng=1
.ends

* expanding   symbol:  /foss/designs/xschemas/ota_med_hv_gmid.sym # of pins=9
** sym_path: /foss/designs/xschemas/ota_med_hv_gmid.sym
** sch_path: /foss/designs/xschemas/ota_med_hv_gmid.sch
.subckt ota_med_hv_gmid IOVDD Ibias VN VP VOUT VSS EN_IN Pbulk Nbulk
*.PININFO Ibias:I VP:I VN:I IOVDD:B VSS:B VOUT:B EN_IN:I Pbulk:I Nbulk:I
M1 net2 net2 VSS Nbulk sg13_hv_nmos w=1.9u l=2u ng=1 m=2
M2 net2 VN net1 Pbulk sg13_hv_pmos w=2.94u l=1u ng=1 m=2
M3 net3 net2 VSS Nbulk sg13_hv_nmos w=1.9u l=2u ng=1 m=2
M4 net3 VP net1 Pbulk sg13_hv_pmos w=2.94u l=1u ng=1 m=2
M5 net1 Ibias IOVDD Pbulk sg13_hv_pmos w=1u l=0.5u ng=1 m=2
M6 VOUT net3 VSS Nbulk sg13_hv_nmos w=1.9u l=2u ng=1 m=4
M7 VOUT Ibias IOVDD Pbulk sg13_hv_pmos w=1u l=0.5u ng=1 m=2
C1 VOUT net3 cap_cmim w=20e-6 l=26e-6
M8 Ibias EN_IN IOVDD Pbulk sg13_hv_pmos w=14u l=0.4u ng=7
M9 VSS VSS VSS Nbulk sg13_hv_nmos w=1.9u l=2u ng=1 m=4
M10 IOVDD IOVDD IOVDD Pbulk sg13_hv_pmos w=2.94u l=1u ng=1 m=8
M11 IOVDD IOVDD IOVDD Pbulk sg13_hv_pmos w=1u l=0.5u ng=1 m=16
.ends

* expanding   symbol:  /foss/designs/xschemas/Ali/opm_fixed.sym # of pins=7
** sym_path: /foss/designs/xschemas/Ali/opm_fixed.sym
** sch_path: /foss/designs/xschemas/Ali/opm_fixed.sch
.subckt opm_fixed IOVDD out_opm vp_VBG1V vn_VBG1V VSS Pbulk Nbulk
*.PININFO vp_VBG1V:I vn_VBG1V:I IOVDD:B out_opm:O VSS:B Nbulk:B Pbulk:B
M5 out_opm vbias IOVDD Pbulk sg13_hv_pmos w=60u l=1.5u ng=8
M6 VSS net2 net2 Nbulk sg13_hv_nmos w=2.5u l=6u ng=1 m=2
C2 out_opm net1 cap_cmim w=40e-6 l=40e-6
M7 net2 vn_VBG1V net3 Pbulk sg13_hv_pmos w=4u l=1u ng=1 m=2
M8 VSS net2 net1 Nbulk sg13_hv_nmos w=2.5u l=6u ng=1 m=2
M9 net1 vp_VBG1V net3 Pbulk sg13_hv_pmos w=4u l=1u ng=1 m=2
M10 VSS net1 out_opm Nbulk sg13_hv_nmos w=35u l=6u ng=4
M11 net3 vbias IOVDD Pbulk sg13_hv_pmos w=5u l=5u ng=1
M12 vbias vbias IOVDD Pbulk sg13_hv_pmos w=25u l=2u ng=4
M19 vbias vbias VSS Nbulk sg13_hv_nmos w=9.99u l=6u ng=3
M1 VSS VSS VSS Nbulk sg13_hv_nmos w=2.5u l=0.5u ng=1 m=4
M2 IOVDD IOVDD IOVDD Pbulk sg13_hv_pmos w=4u l=0.5u ng=1 m=4
M3 IOVDD IOVDD IOVDD Pbulk sg13_hv_pmos w=5u l=0.5u ng=1 m=2
.ends

.GLOBAL VSS
